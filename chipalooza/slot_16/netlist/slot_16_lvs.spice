* sar_10_bit top-level LVS
* source: /home/arjun/eda/projects/SAR_ADC/circuit_files/sar_adc_test/layout/sar_10_bit.spice sha256=564b563afaf59f47c07f05820e5d98ef3e5ed535a22ca429aabee3109aac6c09
** sch_path: /home/arjun/eda/projects/SAR_ADC/circuit_files/sar_adc_test/xschem/sar_10_bit.sch
.subckt sar_10_bit RSTN busy START valid vcm vrefp ainn ainp CLK C0 C9 C1 C5 C6 C2 C7 C3 C8 C4 vss vddh Voutn vddl
*.PININFO ainn:I ainp:I CLK:I vrefp:I vcm:I C1:O C2:O C3:O C4:O C5:O C6:O C7:O C8:O C0:O C9:O busy:O valid:O START:I RSTN:I
*+ Voutn:B vddh:B vss:B vddl:B
x1 voutn_raw vcn voutp_raw vcp vddh vss comp_clk_hv strong_arm_comp
x3 vss sample_hv sampleb_hv vddh ainp vcp tg
x4 vss sample_hv sampleb_hv vddh ainn vcn tg
x15 vddh sample_hv sampleb_hv vss inverter
x6 dbp0_hv bp0 vss vddh vrefp vcm dac_sw_2to1_tg
x7 dbp1_hv bp1 vss vddh vrefp vcm dac_sw_2to1_tg
x8 dbp4_hv bp4 vss vddh vrefp vcm dac_sw_2to1_tg
x9 dbp5_hv bp5 vss vddh vrefp vcm dac_sw_2to1_tg
x10 dbp7_hv bp7 vss vddh vrefp vcm dac_sw_2to1_tg
x11 dbp8_hv bp8 vss vddh vrefp vcm dac_sw_2to1_tg
x12 dbp2_hv bp2 vss vddh vrefp vcm dac_sw_2to1_tg
x13 dbp3_hv bp3 vss vddh vrefp vcm dac_sw_2to1_tg
x14 dbp6_hv bp6 vss vddh vrefp vcm dac_sw_2to1_tg
x16 dbp9_hv bp9 vss vddh vrefp vcm dac_sw_2to1_tg
x17 dbn0_hv bn0 vss vddh vrefp vcm dac_sw_2to1_tg
x18 dbn1_hv bn1 vss vddh vrefp vcm dac_sw_2to1_tg
x19 dbn4_hv bn4 vss vddh vrefp vcm dac_sw_2to1_tg
x20 dbn5_hv bn5 vss vddh vrefp vcm dac_sw_2to1_tg
x21 dbn7_hv bn7 vss vddh vrefp vcm dac_sw_2to1_tg
x22 dbn8_hv bn8 vss vddh vrefp vcm dac_sw_2to1_tg
x23 dbn2_hv bn2 vss vddh vrefp vcm dac_sw_2to1_tg
x24 dbn3_hv bn3 vss vddh vrefp vcm dac_sw_2to1_tg
x25 dbn6_hv bn6 vss vddh vrefp vcm dac_sw_2to1_tg
x27 dbn9_hv bn9 vss vddh vrefp vcm dac_sw_2to1_tg
x5 CLK RSTN START comp_lv sample comp_clk busy valid dbp9 dbp8 dbp7 dbp6 dbp5 dbp4 dbp3 dbp2 dbp1 dbp0 dbn9 dbn8 dbn7 dbn6 dbn5 dbn4 dbn3 dbn2 dbn1 dbn0 C9 C8 C7 C6 C5 C4 C3 C2 C1 C0 vddl vss sar_fsm_wrapper
x26 vss vddl vddh comp_lv voutp_raw voutn_raw comp_clk_hv level_shifter_3v3_to_1v2
x28 vss vddl vddh comp_clk_hv comp_clk level_shifter_1v2_to_3v3
x29 vss vddl vddh sample_hv sample level_shifter_1v2_to_3v3
x30 vss vddl vddh dbp0_hv dbp0 level_shifter_1v2_to_3v3
x31 vss vddl vddh dbp1_hv dbp1 level_shifter_1v2_to_3v3
x32 vss vddl vddh dbp5_hv dbp5 level_shifter_1v2_to_3v3
x33 vss vddl vddh dbp6_hv dbp6 level_shifter_1v2_to_3v3
x34 vss vddl vddh dbp2_hv dbp2 level_shifter_1v2_to_3v3
x35 vss vddl vddh dbp3_hv dbp3 level_shifter_1v2_to_3v3
x36 vss vddl vddh dbp7_hv dbp7 level_shifter_1v2_to_3v3
x37 vss vddl vddh dbp8_hv dbp8 level_shifter_1v2_to_3v3
x38 vss vddl vddh dbp4_hv dbp4 level_shifter_1v2_to_3v3
x39 vss vddl vddh dbp9_hv dbp9 level_shifter_1v2_to_3v3
x40 vss vddl vddh dbn0_hv dbn0 level_shifter_1v2_to_3v3
x41 vss vddl vddh dbn1_hv dbn1 level_shifter_1v2_to_3v3
x42 vss vddl vddh dbn5_hv dbn5 level_shifter_1v2_to_3v3
x43 vss vddl vddh dbn6_hv dbn6 level_shifter_1v2_to_3v3
x44 vss vddl vddh dbn2_hv dbn2 level_shifter_1v2_to_3v3
x45 vss vddl vddh dbn3_hv dbn3 level_shifter_1v2_to_3v3
x46 vss vddl vddh dbn7_hv dbn7 level_shifter_1v2_to_3v3
x47 vss vddl vddh dbn8_hv dbn8 level_shifter_1v2_to_3v3
x48 vss vddl vddh dbn4_hv dbn4 level_shifter_1v2_to_3v3
x49 vss vddl vddh dbn9_hv dbn9 level_shifter_1v2_to_3v3
x50 vddh voutn_raw Voutn vss inverter
x51 vddh voutp_raw Voutp_dummy vss inverter
x52 vcp bp3 bp0 bp5 bp2 vcm bp1 bp7 bp6 bp8 bp4 bp9 vcn bn0 bn1 bn8 bn7 bn6 bn5 bn4 bn3 bn9 bn2 vcm cdac_caps_10b_diff
.ends

* expanding   symbol:  strong_arm_comp.sym # of pins=7
** sym_path: /home/arjun/eda/projects/SAR_ADC/circuit_files/sar_adc_test/xschem/strong_arm_comp.sym
** sch_path: /home/arjun/eda/projects/SAR_ADC/circuit_files/sar_adc_test/xschem/strong_arm_comp.sch
.subckt strong_arm_comp Voutn Vinn Voutp Vinp vdd vss CLK
*.PININFO Vinn:I Voutp:O vdd:B Vinp:I CLK:I vss:B Voutn:O
MM1 P CLK vdd vdd sg13_hv_pmos w=2u l=0.4u ng=1 m=4
MM2 net1 CLK vss vss sg13_hv_nmos w=2u l=0.45u ng=1 m=8
MM3 X CLK vdd vdd sg13_hv_pmos w=2u l=0.4u ng=1 m=4
MM4 P Vinn net1 vss sg13_hv_nmos w=2u l=0.45u ng=1 m=6
MM5 Q Vinp net1 vss sg13_hv_nmos w=2u l=0.45u ng=1 m=6
MM6 X Y P vss sg13_hv_nmos w=2u l=0.45u ng=1 m=2
MM7 Y X Q vss sg13_hv_nmos w=2u l=0.45u ng=1 m=2
MM8 X Y vdd vdd sg13_hv_pmos w=2u l=0.4u ng=1 m=4
MM9 Y CLK vdd vdd sg13_hv_pmos w=2u l=0.4u ng=1 m=4
MM10 Q CLK vdd vdd sg13_hv_pmos w=2u l=0.4u ng=1 m=4
MM11 Y X vdd vdd sg13_hv_pmos w=2u l=0.4u ng=1 m=4
MM12 net2 X vss vss sg13_hv_nmos w=2u l=0.45u ng=1
MM13 Voutp net2 vss vss sg13_hv_nmos w=2u l=0.45u ng=1 m=2
MM14 Voutn net3 vss vss sg13_hv_nmos w=2u l=0.45u ng=1 m=2
MM15 net3 Y vss vss sg13_hv_nmos w=2u l=0.45u ng=1
MM16 net2 X vdd vdd sg13_hv_pmos w=2u l=0.4u ng=1 m=2
MM17 Voutp Voutn vdd vdd sg13_hv_pmos w=2u l=0.4u ng=1 m=4
MM18 net3 Y vdd vdd sg13_hv_pmos w=2u l=0.4u ng=1 m=2
MM19 Voutn Voutp vdd vdd sg13_hv_pmos w=2u l=0.4u ng=1 m=4
.ends

* expanding   symbol:  tg.sym # of pins=6
** sym_path: /home/arjun/eda/projects/SAR_ADC/circuit_files/sar_adc_test/xschem/tg.sym
** sch_path: /home/arjun/eda/projects/SAR_ADC/circuit_files/sar_adc_test/xschem/tg.sch
.subckt tg vss ng pg vdd a b
*.PININFO ng:I vdd:B pg:I a:B b:B vss:B
MM12 b ng a vss sg13_hv_nmos w=2u l=0.45u ng=1
MM16 b pg a vdd sg13_hv_pmos w=2u l=0.4u ng=1 m=2
.ends

* expanding   symbol:  inverter.sym # of pins=4
** sym_path: /home/arjun/eda/projects/SAR_ADC/circuit_files/sar_adc_test/xschem/inverter.sym
** sch_path: /home/arjun/eda/projects/SAR_ADC/circuit_files/sar_adc_test/xschem/inverter.sch
.subckt inverter vdd Vinn Voutp vss
*.PININFO vdd:B vss:B Vinn:I Voutp:O
MM12 Voutp Vinn vss vss sg13_hv_nmos w=2u l=0.45u ng=1
MM16 Voutp Vinn vdd vdd sg13_hv_pmos w=2u l=0.4u ng=1 m=2
.ends

* expanding   symbol:  dac_sw_2to1_tg.sym # of pins=6
** sym_path: /home/arjun/eda/projects/SAR_ADC/circuit_files/sar_adc_test/xschem/dac_sw_2to1_tg.sym
** sch_path: /home/arjun/eda/projects/SAR_ADC/circuit_files/sar_adc_test/xschem/dac_sw_2to1_tg.sch
.subckt dac_sw_2to1_tg sel out vss vdd vref vcm
*.PININFO sel:I vdd:B vref:B vcm:B vss:B out:B
Mx1_MM12 out sel vref vss sg13_hv_nmos w=2u l=0.45u ng=1
Mx1_MM16 out selb vref vdd sg13_hv_pmos w=2u l=0.4u ng=1 m=2
Mx3_MM12 out selb vcm vss sg13_hv_nmos w=2u l=0.45u ng=1
Mx3_MM16 out sel vcm vdd sg13_hv_pmos w=2u l=0.4u ng=1 m=2
Mx2_MM12 selb sel vss vss sg13_hv_nmos w=2u l=0.45u ng=1
Mx2_MM16 selb sel vdd vdd sg13_hv_pmos w=2u l=0.4u ng=1 m=2
.ends

* expanding   symbol:  level_shifter_3v3_to_1v2.sym # of pins=7
** sym_path: /home/arjun/eda/projects/SAR_ADC/circuit_files/sar_adc_test/xschem/level_shifter_3v3_to_1v2.sym
** sch_path: /home/arjun/eda/projects/SAR_ADC/circuit_files/sar_adc_test/xschem/level_shifter_3v3_to_1v2.sch
.subckt level_shifter_3v3_to_1v2 vss vddl vddh out inp inn en_hv
*.PININFO vddl:B out:B vss:B inp:B inn:B en_hv:B vddh:B
MM7 q vddl xp vss sg13_hv_nmos w=2u l=0.45u ng=1 m=4
MM9 xp gatep vss vss sg13_hv_nmos w=2u l=0.45u ng=1 m=4
MM8 qb vddl xn vss sg13_hv_nmos w=2u l=0.45u ng=1 m=4
MM11 xn gaten vss vss sg13_hv_nmos w=2u l=0.45u ng=1 m=4
MM17 lvbuf hbuf2 vss vss sg13_lv_nmos w=0.6u l=0.13u ng=1
MM18 lvbuf hbuf2 vddl vddl sg13_lv_pmos w=1.2u l=0.13u ng=1
MM3 q qb vss vss sg13_hv_nmos w=2u l=0.45u ng=1
MM4 qb q vss vss sg13_hv_nmos w=2u l=0.45u ng=1
MM5 qb q vddl vddl sg13_hv_pmos w=2u l=0.4u ng=1 m=2
MM6 q qb vddl vddl sg13_hv_pmos w=2u l=0.4u ng=1 m=2
MM14 hbuf qb vddl vddl sg13_hv_pmos w=2u l=0.4u ng=1 m=2
MM15 hbuf qb vss vss sg13_hv_nmos w=2u l=0.45u ng=1
MM19 hbuf2 hbuf vddl vddl sg13_hv_pmos w=2u l=0.4u ng=1 m=2
MM20 hbuf2 hbuf vss vss sg13_hv_nmos w=2u l=0.45u ng=1
MM21 out lvbuf vss vss sg13_lv_nmos w=0.6u l=0.13u ng=1
MM22 out lvbuf vddl vddl sg13_lv_pmos w=1.2u l=0.13u ng=1
MM23 enb en_hv vddh vddh sg13_hv_pmos w=2u l=0.4u ng=1 m=2
MM24 enb en_hv vss vss sg13_hv_nmos w=2u l=0.45u ng=1
Mx1_MM12 gatep en_hv inp vss sg13_hv_nmos w=2u l=0.45u ng=1
Mx1_MM16 gatep enb inp vddh sg13_hv_pmos w=2u l=0.4u ng=1 m=2
Mx2_MM12 gaten en_hv inn vss sg13_hv_nmos w=2u l=0.45u ng=1
Mx2_MM16 gaten enb inn vddh sg13_hv_pmos w=2u l=0.4u ng=1 m=2
MM25 gatep enb vss vss sg13_hv_nmos w=2u l=0.45u ng=1
MM26 gaten enb vss vss sg13_hv_nmos w=2u l=0.45u ng=1
.ends

* expanding   symbol:  level_shifter_1v2_to_3v3.sym # of pins=5
** sym_path: /home/arjun/eda/projects/SAR_ADC/circuit_files/sar_adc_test/xschem/level_shifter_1v2_to_3v3.sym
** sch_path: /home/arjun/eda/projects/SAR_ADC/circuit_files/sar_adc_test/xschem/level_shifter_1v2_to_3v3.sch
.subckt level_shifter_1v2_to_3v3 vss vddl vddh out in
*.PININFO vddl:B vddh:B out:B vss:B in:B
MM1 inb in vss vss sg13_lv_nmos w=0.6u l=0.13u ng=1
MM2 inb in vddl vddl sg13_lv_pmos w=1.2u l=0.13u ng=1
MM3 a in vss vss sg13_hv_nmos w=2u l=0.45u ng=1 m=4
MM4 b inb vss vss sg13_hv_nmos w=2u l=0.45u ng=1 m=4
MM5 b a vddh vddh sg13_hv_pmos w=2u l=0.4u ng=1
MM6 a b vddh vddh sg13_hv_pmos w=2u l=0.4u ng=1
MM12 out a vss vss sg13_hv_nmos w=2u l=0.45u ng=1
MM16 out a vddh vddh sg13_hv_pmos w=2u l=0.4u ng=1 m=2
.ends

* expanding   symbol:  cdac_caps_10b_diff.sym # of pins=24
** sym_path: /home/arjun/eda/projects/SAR_ADC/circuit_files/sar_adc_test/xschem/cdac_caps_10b_diff.sym
** sch_path: /home/arjun/eda/projects/SAR_ADC/circuit_files/sar_adc_test/xschem/cdac_caps_10b_diff.sch
.subckt cdac_caps_10b_diff vcp bp3 bp0 bp5 bp2 bpd bp1 bp7 bp6 bp8 bp4 bp9 vcn bn0 bn1 bn8 bn7 bn6 bn5 bn4 bn3 bn9 bn2 bnd
*.PININFO vcp:B vcn:B bpd:B bp0:B bp1:B bp2:B bp3:B bp4:B bp5:B bp6:B bp7:B bp8:B bp9:B bnd:B bn1:B bn2:B bn3:B bn4:B bn5:B bn6:B
*+ bn7:B bn8:B bn9:B bn0:B
C_LVS_CC1_1 vcp bpd cap_cmomi w=2.67e-6 l=2.52e-6 m=1
C_LVS_CC2_1 vcp bp0 cap_cmomi w=2.67e-6 l=2.52e-6 m=1
C_LVS_CC3_1 vcp bp1 cap_cmomi w=2.67e-6 l=2.52e-6 m=1
C_LVS_CC3_2 vcp bp1 cap_cmomi w=2.67e-6 l=2.52e-6 m=1
C_LVS_CC4_1 vcp bp2 cap_cmomi w=2.67e-6 l=2.52e-6 m=1
C_LVS_CC4_2 vcp bp2 cap_cmomi w=2.67e-6 l=2.52e-6 m=1
C_LVS_CC4_3 vcp bp2 cap_cmomi w=2.67e-6 l=2.52e-6 m=1
C_LVS_CC4_4 vcp bp2 cap_cmomi w=2.67e-6 l=2.52e-6 m=1
C_LVS_CC5_1 vcp bp3 cap_cmomi w=2.67e-6 l=2.52e-6 m=1
C_LVS_CC5_2 vcp bp3 cap_cmomi w=2.67e-6 l=2.52e-6 m=1
C_LVS_CC5_3 vcp bp3 cap_cmomi w=2.67e-6 l=2.52e-6 m=1
C_LVS_CC5_4 vcp bp3 cap_cmomi w=2.67e-6 l=2.52e-6 m=1
C_LVS_CC5_5 vcp bp3 cap_cmomi w=2.67e-6 l=2.52e-6 m=1
C_LVS_CC5_6 vcp bp3 cap_cmomi w=2.67e-6 l=2.52e-6 m=1
C_LVS_CC5_7 vcp bp3 cap_cmomi w=2.67e-6 l=2.52e-6 m=1
C_LVS_CC5_8 vcp bp3 cap_cmomi w=2.67e-6 l=2.52e-6 m=1
C_LVS_CC6_1 vcp bp4 cap_cmomi w=2.67e-6 l=2.52e-6 m=1
C_LVS_CC6_2 vcp bp4 cap_cmomi w=2.67e-6 l=2.52e-6 m=1
C_LVS_CC6_3 vcp bp4 cap_cmomi w=2.67e-6 l=2.52e-6 m=1
C_LVS_CC6_4 vcp bp4 cap_cmomi w=2.67e-6 l=2.52e-6 m=1
C_LVS_CC6_5 vcp bp4 cap_cmomi w=2.67e-6 l=2.52e-6 m=1
C_LVS_CC6_6 vcp bp4 cap_cmomi w=2.67e-6 l=2.52e-6 m=1
C_LVS_CC6_7 vcp bp4 cap_cmomi w=2.67e-6 l=2.52e-6 m=1
C_LVS_CC6_8 vcp bp4 cap_cmomi w=2.67e-6 l=2.52e-6 m=1
C_LVS_CC6_9 vcp bp4 cap_cmomi w=2.67e-6 l=2.52e-6 m=1
C_LVS_CC6_10 vcp bp4 cap_cmomi w=2.67e-6 l=2.52e-6 m=1
C_LVS_CC6_11 vcp bp4 cap_cmomi w=2.67e-6 l=2.52e-6 m=1
C_LVS_CC6_12 vcp bp4 cap_cmomi w=2.67e-6 l=2.52e-6 m=1
C_LVS_CC6_13 vcp bp4 cap_cmomi w=2.67e-6 l=2.52e-6 m=1
C_LVS_CC6_14 vcp bp4 cap_cmomi w=2.67e-6 l=2.52e-6 m=1
C_LVS_CC6_15 vcp bp4 cap_cmomi w=2.67e-6 l=2.52e-6 m=1
C_LVS_CC6_16 vcp bp4 cap_cmomi w=2.67e-6 l=2.52e-6 m=1
C_LVS_CC7_1 vcp bp5 cap_cmomi w=2.67e-6 l=2.52e-6 m=1
C_LVS_CC7_2 vcp bp5 cap_cmomi w=2.67e-6 l=2.52e-6 m=1
C_LVS_CC7_3 vcp bp5 cap_cmomi w=2.67e-6 l=2.52e-6 m=1
C_LVS_CC7_4 vcp bp5 cap_cmomi w=2.67e-6 l=2.52e-6 m=1
C_LVS_CC7_5 vcp bp5 cap_cmomi w=2.67e-6 l=2.52e-6 m=1
C_LVS_CC7_6 vcp bp5 cap_cmomi w=2.67e-6 l=2.52e-6 m=1
C_LVS_CC7_7 vcp bp5 cap_cmomi w=2.67e-6 l=2.52e-6 m=1
C_LVS_CC7_8 vcp bp5 cap_cmomi w=2.67e-6 l=2.52e-6 m=1
C_LVS_CC7_9 vcp bp5 cap_cmomi w=2.67e-6 l=2.52e-6 m=1
C_LVS_CC7_10 vcp bp5 cap_cmomi w=2.67e-6 l=2.52e-6 m=1
C_LVS_CC7_11 vcp bp5 cap_cmomi w=2.67e-6 l=2.52e-6 m=1
C_LVS_CC7_12 vcp bp5 cap_cmomi w=2.67e-6 l=2.52e-6 m=1
C_LVS_CC7_13 vcp bp5 cap_cmomi w=2.67e-6 l=2.52e-6 m=1
C_LVS_CC7_14 vcp bp5 cap_cmomi w=2.67e-6 l=2.52e-6 m=1
C_LVS_CC7_15 vcp bp5 cap_cmomi w=2.67e-6 l=2.52e-6 m=1
C_LVS_CC7_16 vcp bp5 cap_cmomi w=2.67e-6 l=2.52e-6 m=1
C_LVS_CC7_17 vcp bp5 cap_cmomi w=2.67e-6 l=2.52e-6 m=1
C_LVS_CC7_18 vcp bp5 cap_cmomi w=2.67e-6 l=2.52e-6 m=1
C_LVS_CC7_19 vcp bp5 cap_cmomi w=2.67e-6 l=2.52e-6 m=1
C_LVS_CC7_20 vcp bp5 cap_cmomi w=2.67e-6 l=2.52e-6 m=1
C_LVS_CC7_21 vcp bp5 cap_cmomi w=2.67e-6 l=2.52e-6 m=1
C_LVS_CC7_22 vcp bp5 cap_cmomi w=2.67e-6 l=2.52e-6 m=1
C_LVS_CC7_23 vcp bp5 cap_cmomi w=2.67e-6 l=2.52e-6 m=1
C_LVS_CC7_24 vcp bp5 cap_cmomi w=2.67e-6 l=2.52e-6 m=1
C_LVS_CC7_25 vcp bp5 cap_cmomi w=2.67e-6 l=2.52e-6 m=1
C_LVS_CC7_26 vcp bp5 cap_cmomi w=2.67e-6 l=2.52e-6 m=1
C_LVS_CC7_27 vcp bp5 cap_cmomi w=2.67e-6 l=2.52e-6 m=1
C_LVS_CC7_28 vcp bp5 cap_cmomi w=2.67e-6 l=2.52e-6 m=1
C_LVS_CC7_29 vcp bp5 cap_cmomi w=2.67e-6 l=2.52e-6 m=1
C_LVS_CC7_30 vcp bp5 cap_cmomi w=2.67e-6 l=2.52e-6 m=1
C_LVS_CC7_31 vcp bp5 cap_cmomi w=2.67e-6 l=2.52e-6 m=1
C_LVS_CC7_32 vcp bp5 cap_cmomi w=2.67e-6 l=2.52e-6 m=1
C_LVS_CC8_1 vcp bp6 cap_cmomi w=2.67e-6 l=2.52e-6 m=1
C_LVS_CC8_2 vcp bp6 cap_cmomi w=2.67e-6 l=2.52e-6 m=1
C_LVS_CC8_3 vcp bp6 cap_cmomi w=2.67e-6 l=2.52e-6 m=1
C_LVS_CC8_4 vcp bp6 cap_cmomi w=2.67e-6 l=2.52e-6 m=1
C_LVS_CC8_5 vcp bp6 cap_cmomi w=2.67e-6 l=2.52e-6 m=1
C_LVS_CC8_6 vcp bp6 cap_cmomi w=2.67e-6 l=2.52e-6 m=1
C_LVS_CC8_7 vcp bp6 cap_cmomi w=2.67e-6 l=2.52e-6 m=1
C_LVS_CC8_8 vcp bp6 cap_cmomi w=2.67e-6 l=2.52e-6 m=1
C_LVS_CC8_9 vcp bp6 cap_cmomi w=2.67e-6 l=2.52e-6 m=1
C_LVS_CC8_10 vcp bp6 cap_cmomi w=2.67e-6 l=2.52e-6 m=1
C_LVS_CC8_11 vcp bp6 cap_cmomi w=2.67e-6 l=2.52e-6 m=1
C_LVS_CC8_12 vcp bp6 cap_cmomi w=2.67e-6 l=2.52e-6 m=1
C_LVS_CC8_13 vcp bp6 cap_cmomi w=2.67e-6 l=2.52e-6 m=1
C_LVS_CC8_14 vcp bp6 cap_cmomi w=2.67e-6 l=2.52e-6 m=1
C_LVS_CC8_15 vcp bp6 cap_cmomi w=2.67e-6 l=2.52e-6 m=1
C_LVS_CC8_16 vcp bp6 cap_cmomi w=2.67e-6 l=2.52e-6 m=1
C_LVS_CC8_17 vcp bp6 cap_cmomi w=2.67e-6 l=2.52e-6 m=1
C_LVS_CC8_18 vcp bp6 cap_cmomi w=2.67e-6 l=2.52e-6 m=1
C_LVS_CC8_19 vcp bp6 cap_cmomi w=2.67e-6 l=2.52e-6 m=1
C_LVS_CC8_20 vcp bp6 cap_cmomi w=2.67e-6 l=2.52e-6 m=1
C_LVS_CC8_21 vcp bp6 cap_cmomi w=2.67e-6 l=2.52e-6 m=1
C_LVS_CC8_22 vcp bp6 cap_cmomi w=2.67e-6 l=2.52e-6 m=1
C_LVS_CC8_23 vcp bp6 cap_cmomi w=2.67e-6 l=2.52e-6 m=1
C_LVS_CC8_24 vcp bp6 cap_cmomi w=2.67e-6 l=2.52e-6 m=1
C_LVS_CC8_25 vcp bp6 cap_cmomi w=2.67e-6 l=2.52e-6 m=1
C_LVS_CC8_26 vcp bp6 cap_cmomi w=2.67e-6 l=2.52e-6 m=1
C_LVS_CC8_27 vcp bp6 cap_cmomi w=2.67e-6 l=2.52e-6 m=1
C_LVS_CC8_28 vcp bp6 cap_cmomi w=2.67e-6 l=2.52e-6 m=1
C_LVS_CC8_29 vcp bp6 cap_cmomi w=2.67e-6 l=2.52e-6 m=1
C_LVS_CC8_30 vcp bp6 cap_cmomi w=2.67e-6 l=2.52e-6 m=1
C_LVS_CC8_31 vcp bp6 cap_cmomi w=2.67e-6 l=2.52e-6 m=1
C_LVS_CC8_32 vcp bp6 cap_cmomi w=2.67e-6 l=2.52e-6 m=1
C_LVS_CC8_33 vcp bp6 cap_cmomi w=2.67e-6 l=2.52e-6 m=1
C_LVS_CC8_34 vcp bp6 cap_cmomi w=2.67e-6 l=2.52e-6 m=1
C_LVS_CC8_35 vcp bp6 cap_cmomi w=2.67e-6 l=2.52e-6 m=1
C_LVS_CC8_36 vcp bp6 cap_cmomi w=2.67e-6 l=2.52e-6 m=1
C_LVS_CC8_37 vcp bp6 cap_cmomi w=2.67e-6 l=2.52e-6 m=1
C_LVS_CC8_38 vcp bp6 cap_cmomi w=2.67e-6 l=2.52e-6 m=1
C_LVS_CC8_39 vcp bp6 cap_cmomi w=2.67e-6 l=2.52e-6 m=1
C_LVS_CC8_40 vcp bp6 cap_cmomi w=2.67e-6 l=2.52e-6 m=1
C_LVS_CC8_41 vcp bp6 cap_cmomi w=2.67e-6 l=2.52e-6 m=1
C_LVS_CC8_42 vcp bp6 cap_cmomi w=2.67e-6 l=2.52e-6 m=1
C_LVS_CC8_43 vcp bp6 cap_cmomi w=2.67e-6 l=2.52e-6 m=1
C_LVS_CC8_44 vcp bp6 cap_cmomi w=2.67e-6 l=2.52e-6 m=1
C_LVS_CC8_45 vcp bp6 cap_cmomi w=2.67e-6 l=2.52e-6 m=1
C_LVS_CC8_46 vcp bp6 cap_cmomi w=2.67e-6 l=2.52e-6 m=1
C_LVS_CC8_47 vcp bp6 cap_cmomi w=2.67e-6 l=2.52e-6 m=1
C_LVS_CC8_48 vcp bp6 cap_cmomi w=2.67e-6 l=2.52e-6 m=1
C_LVS_CC8_49 vcp bp6 cap_cmomi w=2.67e-6 l=2.52e-6 m=1
C_LVS_CC8_50 vcp bp6 cap_cmomi w=2.67e-6 l=2.52e-6 m=1
C_LVS_CC8_51 vcp bp6 cap_cmomi w=2.67e-6 l=2.52e-6 m=1
C_LVS_CC8_52 vcp bp6 cap_cmomi w=2.67e-6 l=2.52e-6 m=1
C_LVS_CC8_53 vcp bp6 cap_cmomi w=2.67e-6 l=2.52e-6 m=1
C_LVS_CC8_54 vcp bp6 cap_cmomi w=2.67e-6 l=2.52e-6 m=1
C_LVS_CC8_55 vcp bp6 cap_cmomi w=2.67e-6 l=2.52e-6 m=1
C_LVS_CC8_56 vcp bp6 cap_cmomi w=2.67e-6 l=2.52e-6 m=1
C_LVS_CC8_57 vcp bp6 cap_cmomi w=2.67e-6 l=2.52e-6 m=1
C_LVS_CC8_58 vcp bp6 cap_cmomi w=2.67e-6 l=2.52e-6 m=1
C_LVS_CC8_59 vcp bp6 cap_cmomi w=2.67e-6 l=2.52e-6 m=1
C_LVS_CC8_60 vcp bp6 cap_cmomi w=2.67e-6 l=2.52e-6 m=1
C_LVS_CC8_61 vcp bp6 cap_cmomi w=2.67e-6 l=2.52e-6 m=1
C_LVS_CC8_62 vcp bp6 cap_cmomi w=2.67e-6 l=2.52e-6 m=1
C_LVS_CC8_63 vcp bp6 cap_cmomi w=2.67e-6 l=2.52e-6 m=1
C_LVS_CC8_64 vcp bp6 cap_cmomi w=2.67e-6 l=2.52e-6 m=1
C_LVS_CC9_1 vcp bp7 cap_cmomi w=2.67e-6 l=2.52e-6 m=1
C_LVS_CC9_2 vcp bp7 cap_cmomi w=2.67e-6 l=2.52e-6 m=1
C_LVS_CC9_3 vcp bp7 cap_cmomi w=2.67e-6 l=2.52e-6 m=1
C_LVS_CC9_4 vcp bp7 cap_cmomi w=2.67e-6 l=2.52e-6 m=1
C_LVS_CC9_5 vcp bp7 cap_cmomi w=2.67e-6 l=2.52e-6 m=1
C_LVS_CC9_6 vcp bp7 cap_cmomi w=2.67e-6 l=2.52e-6 m=1
C_LVS_CC9_7 vcp bp7 cap_cmomi w=2.67e-6 l=2.52e-6 m=1
C_LVS_CC9_8 vcp bp7 cap_cmomi w=2.67e-6 l=2.52e-6 m=1
C_LVS_CC9_9 vcp bp7 cap_cmomi w=2.67e-6 l=2.52e-6 m=1
C_LVS_CC9_10 vcp bp7 cap_cmomi w=2.67e-6 l=2.52e-6 m=1
C_LVS_CC9_11 vcp bp7 cap_cmomi w=2.67e-6 l=2.52e-6 m=1
C_LVS_CC9_12 vcp bp7 cap_cmomi w=2.67e-6 l=2.52e-6 m=1
C_LVS_CC9_13 vcp bp7 cap_cmomi w=2.67e-6 l=2.52e-6 m=1
C_LVS_CC9_14 vcp bp7 cap_cmomi w=2.67e-6 l=2.52e-6 m=1
C_LVS_CC9_15 vcp bp7 cap_cmomi w=2.67e-6 l=2.52e-6 m=1
C_LVS_CC9_16 vcp bp7 cap_cmomi w=2.67e-6 l=2.52e-6 m=1
C_LVS_CC9_17 vcp bp7 cap_cmomi w=2.67e-6 l=2.52e-6 m=1
C_LVS_CC9_18 vcp bp7 cap_cmomi w=2.67e-6 l=2.52e-6 m=1
C_LVS_CC9_19 vcp bp7 cap_cmomi w=2.67e-6 l=2.52e-6 m=1
C_LVS_CC9_20 vcp bp7 cap_cmomi w=2.67e-6 l=2.52e-6 m=1
C_LVS_CC9_21 vcp bp7 cap_cmomi w=2.67e-6 l=2.52e-6 m=1
C_LVS_CC9_22 vcp bp7 cap_cmomi w=2.67e-6 l=2.52e-6 m=1
C_LVS_CC9_23 vcp bp7 cap_cmomi w=2.67e-6 l=2.52e-6 m=1
C_LVS_CC9_24 vcp bp7 cap_cmomi w=2.67e-6 l=2.52e-6 m=1
C_LVS_CC9_25 vcp bp7 cap_cmomi w=2.67e-6 l=2.52e-6 m=1
C_LVS_CC9_26 vcp bp7 cap_cmomi w=2.67e-6 l=2.52e-6 m=1
C_LVS_CC9_27 vcp bp7 cap_cmomi w=2.67e-6 l=2.52e-6 m=1
C_LVS_CC9_28 vcp bp7 cap_cmomi w=2.67e-6 l=2.52e-6 m=1
C_LVS_CC9_29 vcp bp7 cap_cmomi w=2.67e-6 l=2.52e-6 m=1
C_LVS_CC9_30 vcp bp7 cap_cmomi w=2.67e-6 l=2.52e-6 m=1
C_LVS_CC9_31 vcp bp7 cap_cmomi w=2.67e-6 l=2.52e-6 m=1
C_LVS_CC9_32 vcp bp7 cap_cmomi w=2.67e-6 l=2.52e-6 m=1
C_LVS_CC9_33 vcp bp7 cap_cmomi w=2.67e-6 l=2.52e-6 m=1
C_LVS_CC9_34 vcp bp7 cap_cmomi w=2.67e-6 l=2.52e-6 m=1
C_LVS_CC9_35 vcp bp7 cap_cmomi w=2.67e-6 l=2.52e-6 m=1
C_LVS_CC9_36 vcp bp7 cap_cmomi w=2.67e-6 l=2.52e-6 m=1
C_LVS_CC9_37 vcp bp7 cap_cmomi w=2.67e-6 l=2.52e-6 m=1
C_LVS_CC9_38 vcp bp7 cap_cmomi w=2.67e-6 l=2.52e-6 m=1
C_LVS_CC9_39 vcp bp7 cap_cmomi w=2.67e-6 l=2.52e-6 m=1
C_LVS_CC9_40 vcp bp7 cap_cmomi w=2.67e-6 l=2.52e-6 m=1
C_LVS_CC9_41 vcp bp7 cap_cmomi w=2.67e-6 l=2.52e-6 m=1
C_LVS_CC9_42 vcp bp7 cap_cmomi w=2.67e-6 l=2.52e-6 m=1
C_LVS_CC9_43 vcp bp7 cap_cmomi w=2.67e-6 l=2.52e-6 m=1
C_LVS_CC9_44 vcp bp7 cap_cmomi w=2.67e-6 l=2.52e-6 m=1
C_LVS_CC9_45 vcp bp7 cap_cmomi w=2.67e-6 l=2.52e-6 m=1
C_LVS_CC9_46 vcp bp7 cap_cmomi w=2.67e-6 l=2.52e-6 m=1
C_LVS_CC9_47 vcp bp7 cap_cmomi w=2.67e-6 l=2.52e-6 m=1
C_LVS_CC9_48 vcp bp7 cap_cmomi w=2.67e-6 l=2.52e-6 m=1
C_LVS_CC9_49 vcp bp7 cap_cmomi w=2.67e-6 l=2.52e-6 m=1
C_LVS_CC9_50 vcp bp7 cap_cmomi w=2.67e-6 l=2.52e-6 m=1
C_LVS_CC9_51 vcp bp7 cap_cmomi w=2.67e-6 l=2.52e-6 m=1
C_LVS_CC9_52 vcp bp7 cap_cmomi w=2.67e-6 l=2.52e-6 m=1
C_LVS_CC9_53 vcp bp7 cap_cmomi w=2.67e-6 l=2.52e-6 m=1
C_LVS_CC9_54 vcp bp7 cap_cmomi w=2.67e-6 l=2.52e-6 m=1
C_LVS_CC9_55 vcp bp7 cap_cmomi w=2.67e-6 l=2.52e-6 m=1
C_LVS_CC9_56 vcp bp7 cap_cmomi w=2.67e-6 l=2.52e-6 m=1
C_LVS_CC9_57 vcp bp7 cap_cmomi w=2.67e-6 l=2.52e-6 m=1
C_LVS_CC9_58 vcp bp7 cap_cmomi w=2.67e-6 l=2.52e-6 m=1
C_LVS_CC9_59 vcp bp7 cap_cmomi w=2.67e-6 l=2.52e-6 m=1
C_LVS_CC9_60 vcp bp7 cap_cmomi w=2.67e-6 l=2.52e-6 m=1
C_LVS_CC9_61 vcp bp7 cap_cmomi w=2.67e-6 l=2.52e-6 m=1
C_LVS_CC9_62 vcp bp7 cap_cmomi w=2.67e-6 l=2.52e-6 m=1
C_LVS_CC9_63 vcp bp7 cap_cmomi w=2.67e-6 l=2.52e-6 m=1
C_LVS_CC9_64 vcp bp7 cap_cmomi w=2.67e-6 l=2.52e-6 m=1
C_LVS_CC9_65 vcp bp7 cap_cmomi w=2.67e-6 l=2.52e-6 m=1
C_LVS_CC9_66 vcp bp7 cap_cmomi w=2.67e-6 l=2.52e-6 m=1
C_LVS_CC9_67 vcp bp7 cap_cmomi w=2.67e-6 l=2.52e-6 m=1
C_LVS_CC9_68 vcp bp7 cap_cmomi w=2.67e-6 l=2.52e-6 m=1
C_LVS_CC9_69 vcp bp7 cap_cmomi w=2.67e-6 l=2.52e-6 m=1
C_LVS_CC9_70 vcp bp7 cap_cmomi w=2.67e-6 l=2.52e-6 m=1
C_LVS_CC9_71 vcp bp7 cap_cmomi w=2.67e-6 l=2.52e-6 m=1
C_LVS_CC9_72 vcp bp7 cap_cmomi w=2.67e-6 l=2.52e-6 m=1
C_LVS_CC9_73 vcp bp7 cap_cmomi w=2.67e-6 l=2.52e-6 m=1
C_LVS_CC9_74 vcp bp7 cap_cmomi w=2.67e-6 l=2.52e-6 m=1
C_LVS_CC9_75 vcp bp7 cap_cmomi w=2.67e-6 l=2.52e-6 m=1
C_LVS_CC9_76 vcp bp7 cap_cmomi w=2.67e-6 l=2.52e-6 m=1
C_LVS_CC9_77 vcp bp7 cap_cmomi w=2.67e-6 l=2.52e-6 m=1
C_LVS_CC9_78 vcp bp7 cap_cmomi w=2.67e-6 l=2.52e-6 m=1
C_LVS_CC9_79 vcp bp7 cap_cmomi w=2.67e-6 l=2.52e-6 m=1
C_LVS_CC9_80 vcp bp7 cap_cmomi w=2.67e-6 l=2.52e-6 m=1
C_LVS_CC9_81 vcp bp7 cap_cmomi w=2.67e-6 l=2.52e-6 m=1
C_LVS_CC9_82 vcp bp7 cap_cmomi w=2.67e-6 l=2.52e-6 m=1
C_LVS_CC9_83 vcp bp7 cap_cmomi w=2.67e-6 l=2.52e-6 m=1
C_LVS_CC9_84 vcp bp7 cap_cmomi w=2.67e-6 l=2.52e-6 m=1
C_LVS_CC9_85 vcp bp7 cap_cmomi w=2.67e-6 l=2.52e-6 m=1
C_LVS_CC9_86 vcp bp7 cap_cmomi w=2.67e-6 l=2.52e-6 m=1
C_LVS_CC9_87 vcp bp7 cap_cmomi w=2.67e-6 l=2.52e-6 m=1
C_LVS_CC9_88 vcp bp7 cap_cmomi w=2.67e-6 l=2.52e-6 m=1
C_LVS_CC9_89 vcp bp7 cap_cmomi w=2.67e-6 l=2.52e-6 m=1
C_LVS_CC9_90 vcp bp7 cap_cmomi w=2.67e-6 l=2.52e-6 m=1
C_LVS_CC9_91 vcp bp7 cap_cmomi w=2.67e-6 l=2.52e-6 m=1
C_LVS_CC9_92 vcp bp7 cap_cmomi w=2.67e-6 l=2.52e-6 m=1
C_LVS_CC9_93 vcp bp7 cap_cmomi w=2.67e-6 l=2.52e-6 m=1
C_LVS_CC9_94 vcp bp7 cap_cmomi w=2.67e-6 l=2.52e-6 m=1
C_LVS_CC9_95 vcp bp7 cap_cmomi w=2.67e-6 l=2.52e-6 m=1
C_LVS_CC9_96 vcp bp7 cap_cmomi w=2.67e-6 l=2.52e-6 m=1
C_LVS_CC9_97 vcp bp7 cap_cmomi w=2.67e-6 l=2.52e-6 m=1
C_LVS_CC9_98 vcp bp7 cap_cmomi w=2.67e-6 l=2.52e-6 m=1
C_LVS_CC9_99 vcp bp7 cap_cmomi w=2.67e-6 l=2.52e-6 m=1
C_LVS_CC9_100 vcp bp7 cap_cmomi w=2.67e-6 l=2.52e-6 m=1
C_LVS_CC9_101 vcp bp7 cap_cmomi w=2.67e-6 l=2.52e-6 m=1
C_LVS_CC9_102 vcp bp7 cap_cmomi w=2.67e-6 l=2.52e-6 m=1
C_LVS_CC9_103 vcp bp7 cap_cmomi w=2.67e-6 l=2.52e-6 m=1
C_LVS_CC9_104 vcp bp7 cap_cmomi w=2.67e-6 l=2.52e-6 m=1
C_LVS_CC9_105 vcp bp7 cap_cmomi w=2.67e-6 l=2.52e-6 m=1
C_LVS_CC9_106 vcp bp7 cap_cmomi w=2.67e-6 l=2.52e-6 m=1
C_LVS_CC9_107 vcp bp7 cap_cmomi w=2.67e-6 l=2.52e-6 m=1
C_LVS_CC9_108 vcp bp7 cap_cmomi w=2.67e-6 l=2.52e-6 m=1
C_LVS_CC9_109 vcp bp7 cap_cmomi w=2.67e-6 l=2.52e-6 m=1
C_LVS_CC9_110 vcp bp7 cap_cmomi w=2.67e-6 l=2.52e-6 m=1
C_LVS_CC9_111 vcp bp7 cap_cmomi w=2.67e-6 l=2.52e-6 m=1
C_LVS_CC9_112 vcp bp7 cap_cmomi w=2.67e-6 l=2.52e-6 m=1
C_LVS_CC9_113 vcp bp7 cap_cmomi w=2.67e-6 l=2.52e-6 m=1
C_LVS_CC9_114 vcp bp7 cap_cmomi w=2.67e-6 l=2.52e-6 m=1
C_LVS_CC9_115 vcp bp7 cap_cmomi w=2.67e-6 l=2.52e-6 m=1
C_LVS_CC9_116 vcp bp7 cap_cmomi w=2.67e-6 l=2.52e-6 m=1
C_LVS_CC9_117 vcp bp7 cap_cmomi w=2.67e-6 l=2.52e-6 m=1
C_LVS_CC9_118 vcp bp7 cap_cmomi w=2.67e-6 l=2.52e-6 m=1
C_LVS_CC9_119 vcp bp7 cap_cmomi w=2.67e-6 l=2.52e-6 m=1
C_LVS_CC9_120 vcp bp7 cap_cmomi w=2.67e-6 l=2.52e-6 m=1
C_LVS_CC9_121 vcp bp7 cap_cmomi w=2.67e-6 l=2.52e-6 m=1
C_LVS_CC9_122 vcp bp7 cap_cmomi w=2.67e-6 l=2.52e-6 m=1
C_LVS_CC9_123 vcp bp7 cap_cmomi w=2.67e-6 l=2.52e-6 m=1
C_LVS_CC9_124 vcp bp7 cap_cmomi w=2.67e-6 l=2.52e-6 m=1
C_LVS_CC9_125 vcp bp7 cap_cmomi w=2.67e-6 l=2.52e-6 m=1
C_LVS_CC9_126 vcp bp7 cap_cmomi w=2.67e-6 l=2.52e-6 m=1
C_LVS_CC9_127 vcp bp7 cap_cmomi w=2.67e-6 l=2.52e-6 m=1
C_LVS_CC9_128 vcp bp7 cap_cmomi w=2.67e-6 l=2.52e-6 m=1
C_LVS_CC10_1 vcp bp8 cap_cmomi w=2.67e-6 l=2.52e-6 m=1
C_LVS_CC10_2 vcp bp8 cap_cmomi w=2.67e-6 l=2.52e-6 m=1
C_LVS_CC10_3 vcp bp8 cap_cmomi w=2.67e-6 l=2.52e-6 m=1
C_LVS_CC10_4 vcp bp8 cap_cmomi w=2.67e-6 l=2.52e-6 m=1
C_LVS_CC10_5 vcp bp8 cap_cmomi w=2.67e-6 l=2.52e-6 m=1
C_LVS_CC10_6 vcp bp8 cap_cmomi w=2.67e-6 l=2.52e-6 m=1
C_LVS_CC10_7 vcp bp8 cap_cmomi w=2.67e-6 l=2.52e-6 m=1
C_LVS_CC10_8 vcp bp8 cap_cmomi w=2.67e-6 l=2.52e-6 m=1
C_LVS_CC10_9 vcp bp8 cap_cmomi w=2.67e-6 l=2.52e-6 m=1
C_LVS_CC10_10 vcp bp8 cap_cmomi w=2.67e-6 l=2.52e-6 m=1
C_LVS_CC10_11 vcp bp8 cap_cmomi w=2.67e-6 l=2.52e-6 m=1
C_LVS_CC10_12 vcp bp8 cap_cmomi w=2.67e-6 l=2.52e-6 m=1
C_LVS_CC10_13 vcp bp8 cap_cmomi w=2.67e-6 l=2.52e-6 m=1
C_LVS_CC10_14 vcp bp8 cap_cmomi w=2.67e-6 l=2.52e-6 m=1
C_LVS_CC10_15 vcp bp8 cap_cmomi w=2.67e-6 l=2.52e-6 m=1
C_LVS_CC10_16 vcp bp8 cap_cmomi w=2.67e-6 l=2.52e-6 m=1
C_LVS_CC10_17 vcp bp8 cap_cmomi w=2.67e-6 l=2.52e-6 m=1
C_LVS_CC10_18 vcp bp8 cap_cmomi w=2.67e-6 l=2.52e-6 m=1
C_LVS_CC10_19 vcp bp8 cap_cmomi w=2.67e-6 l=2.52e-6 m=1
C_LVS_CC10_20 vcp bp8 cap_cmomi w=2.67e-6 l=2.52e-6 m=1
C_LVS_CC10_21 vcp bp8 cap_cmomi w=2.67e-6 l=2.52e-6 m=1
C_LVS_CC10_22 vcp bp8 cap_cmomi w=2.67e-6 l=2.52e-6 m=1
C_LVS_CC10_23 vcp bp8 cap_cmomi w=2.67e-6 l=2.52e-6 m=1
C_LVS_CC10_24 vcp bp8 cap_cmomi w=2.67e-6 l=2.52e-6 m=1
C_LVS_CC10_25 vcp bp8 cap_cmomi w=2.67e-6 l=2.52e-6 m=1
C_LVS_CC10_26 vcp bp8 cap_cmomi w=2.67e-6 l=2.52e-6 m=1
C_LVS_CC10_27 vcp bp8 cap_cmomi w=2.67e-6 l=2.52e-6 m=1
C_LVS_CC10_28 vcp bp8 cap_cmomi w=2.67e-6 l=2.52e-6 m=1
C_LVS_CC10_29 vcp bp8 cap_cmomi w=2.67e-6 l=2.52e-6 m=1
C_LVS_CC10_30 vcp bp8 cap_cmomi w=2.67e-6 l=2.52e-6 m=1
C_LVS_CC10_31 vcp bp8 cap_cmomi w=2.67e-6 l=2.52e-6 m=1
C_LVS_CC10_32 vcp bp8 cap_cmomi w=2.67e-6 l=2.52e-6 m=1
C_LVS_CC10_33 vcp bp8 cap_cmomi w=2.67e-6 l=2.52e-6 m=1
C_LVS_CC10_34 vcp bp8 cap_cmomi w=2.67e-6 l=2.52e-6 m=1
C_LVS_CC10_35 vcp bp8 cap_cmomi w=2.67e-6 l=2.52e-6 m=1
C_LVS_CC10_36 vcp bp8 cap_cmomi w=2.67e-6 l=2.52e-6 m=1
C_LVS_CC10_37 vcp bp8 cap_cmomi w=2.67e-6 l=2.52e-6 m=1
C_LVS_CC10_38 vcp bp8 cap_cmomi w=2.67e-6 l=2.52e-6 m=1
C_LVS_CC10_39 vcp bp8 cap_cmomi w=2.67e-6 l=2.52e-6 m=1
C_LVS_CC10_40 vcp bp8 cap_cmomi w=2.67e-6 l=2.52e-6 m=1
C_LVS_CC10_41 vcp bp8 cap_cmomi w=2.67e-6 l=2.52e-6 m=1
C_LVS_CC10_42 vcp bp8 cap_cmomi w=2.67e-6 l=2.52e-6 m=1
C_LVS_CC10_43 vcp bp8 cap_cmomi w=2.67e-6 l=2.52e-6 m=1
C_LVS_CC10_44 vcp bp8 cap_cmomi w=2.67e-6 l=2.52e-6 m=1
C_LVS_CC10_45 vcp bp8 cap_cmomi w=2.67e-6 l=2.52e-6 m=1
C_LVS_CC10_46 vcp bp8 cap_cmomi w=2.67e-6 l=2.52e-6 m=1
C_LVS_CC10_47 vcp bp8 cap_cmomi w=2.67e-6 l=2.52e-6 m=1
C_LVS_CC10_48 vcp bp8 cap_cmomi w=2.67e-6 l=2.52e-6 m=1
C_LVS_CC10_49 vcp bp8 cap_cmomi w=2.67e-6 l=2.52e-6 m=1
C_LVS_CC10_50 vcp bp8 cap_cmomi w=2.67e-6 l=2.52e-6 m=1
C_LVS_CC10_51 vcp bp8 cap_cmomi w=2.67e-6 l=2.52e-6 m=1
C_LVS_CC10_52 vcp bp8 cap_cmomi w=2.67e-6 l=2.52e-6 m=1
C_LVS_CC10_53 vcp bp8 cap_cmomi w=2.67e-6 l=2.52e-6 m=1
C_LVS_CC10_54 vcp bp8 cap_cmomi w=2.67e-6 l=2.52e-6 m=1
C_LVS_CC10_55 vcp bp8 cap_cmomi w=2.67e-6 l=2.52e-6 m=1
C_LVS_CC10_56 vcp bp8 cap_cmomi w=2.67e-6 l=2.52e-6 m=1
C_LVS_CC10_57 vcp bp8 cap_cmomi w=2.67e-6 l=2.52e-6 m=1
C_LVS_CC10_58 vcp bp8 cap_cmomi w=2.67e-6 l=2.52e-6 m=1
C_LVS_CC10_59 vcp bp8 cap_cmomi w=2.67e-6 l=2.52e-6 m=1
C_LVS_CC10_60 vcp bp8 cap_cmomi w=2.67e-6 l=2.52e-6 m=1
C_LVS_CC10_61 vcp bp8 cap_cmomi w=2.67e-6 l=2.52e-6 m=1
C_LVS_CC10_62 vcp bp8 cap_cmomi w=2.67e-6 l=2.52e-6 m=1
C_LVS_CC10_63 vcp bp8 cap_cmomi w=2.67e-6 l=2.52e-6 m=1
C_LVS_CC10_64 vcp bp8 cap_cmomi w=2.67e-6 l=2.52e-6 m=1
C_LVS_CC10_65 vcp bp8 cap_cmomi w=2.67e-6 l=2.52e-6 m=1
C_LVS_CC10_66 vcp bp8 cap_cmomi w=2.67e-6 l=2.52e-6 m=1
C_LVS_CC10_67 vcp bp8 cap_cmomi w=2.67e-6 l=2.52e-6 m=1
C_LVS_CC10_68 vcp bp8 cap_cmomi w=2.67e-6 l=2.52e-6 m=1
C_LVS_CC10_69 vcp bp8 cap_cmomi w=2.67e-6 l=2.52e-6 m=1
C_LVS_CC10_70 vcp bp8 cap_cmomi w=2.67e-6 l=2.52e-6 m=1
C_LVS_CC10_71 vcp bp8 cap_cmomi w=2.67e-6 l=2.52e-6 m=1
C_LVS_CC10_72 vcp bp8 cap_cmomi w=2.67e-6 l=2.52e-6 m=1
C_LVS_CC10_73 vcp bp8 cap_cmomi w=2.67e-6 l=2.52e-6 m=1
C_LVS_CC10_74 vcp bp8 cap_cmomi w=2.67e-6 l=2.52e-6 m=1
C_LVS_CC10_75 vcp bp8 cap_cmomi w=2.67e-6 l=2.52e-6 m=1
C_LVS_CC10_76 vcp bp8 cap_cmomi w=2.67e-6 l=2.52e-6 m=1
C_LVS_CC10_77 vcp bp8 cap_cmomi w=2.67e-6 l=2.52e-6 m=1
C_LVS_CC10_78 vcp bp8 cap_cmomi w=2.67e-6 l=2.52e-6 m=1
C_LVS_CC10_79 vcp bp8 cap_cmomi w=2.67e-6 l=2.52e-6 m=1
C_LVS_CC10_80 vcp bp8 cap_cmomi w=2.67e-6 l=2.52e-6 m=1
C_LVS_CC10_81 vcp bp8 cap_cmomi w=2.67e-6 l=2.52e-6 m=1
C_LVS_CC10_82 vcp bp8 cap_cmomi w=2.67e-6 l=2.52e-6 m=1
C_LVS_CC10_83 vcp bp8 cap_cmomi w=2.67e-6 l=2.52e-6 m=1
C_LVS_CC10_84 vcp bp8 cap_cmomi w=2.67e-6 l=2.52e-6 m=1
C_LVS_CC10_85 vcp bp8 cap_cmomi w=2.67e-6 l=2.52e-6 m=1
C_LVS_CC10_86 vcp bp8 cap_cmomi w=2.67e-6 l=2.52e-6 m=1
C_LVS_CC10_87 vcp bp8 cap_cmomi w=2.67e-6 l=2.52e-6 m=1
C_LVS_CC10_88 vcp bp8 cap_cmomi w=2.67e-6 l=2.52e-6 m=1
C_LVS_CC10_89 vcp bp8 cap_cmomi w=2.67e-6 l=2.52e-6 m=1
C_LVS_CC10_90 vcp bp8 cap_cmomi w=2.67e-6 l=2.52e-6 m=1
C_LVS_CC10_91 vcp bp8 cap_cmomi w=2.67e-6 l=2.52e-6 m=1
C_LVS_CC10_92 vcp bp8 cap_cmomi w=2.67e-6 l=2.52e-6 m=1
C_LVS_CC10_93 vcp bp8 cap_cmomi w=2.67e-6 l=2.52e-6 m=1
C_LVS_CC10_94 vcp bp8 cap_cmomi w=2.67e-6 l=2.52e-6 m=1
C_LVS_CC10_95 vcp bp8 cap_cmomi w=2.67e-6 l=2.52e-6 m=1
C_LVS_CC10_96 vcp bp8 cap_cmomi w=2.67e-6 l=2.52e-6 m=1
C_LVS_CC10_97 vcp bp8 cap_cmomi w=2.67e-6 l=2.52e-6 m=1
C_LVS_CC10_98 vcp bp8 cap_cmomi w=2.67e-6 l=2.52e-6 m=1
C_LVS_CC10_99 vcp bp8 cap_cmomi w=2.67e-6 l=2.52e-6 m=1
C_LVS_CC10_100 vcp bp8 cap_cmomi w=2.67e-6 l=2.52e-6 m=1
C_LVS_CC10_101 vcp bp8 cap_cmomi w=2.67e-6 l=2.52e-6 m=1
C_LVS_CC10_102 vcp bp8 cap_cmomi w=2.67e-6 l=2.52e-6 m=1
C_LVS_CC10_103 vcp bp8 cap_cmomi w=2.67e-6 l=2.52e-6 m=1
C_LVS_CC10_104 vcp bp8 cap_cmomi w=2.67e-6 l=2.52e-6 m=1
C_LVS_CC10_105 vcp bp8 cap_cmomi w=2.67e-6 l=2.52e-6 m=1
C_LVS_CC10_106 vcp bp8 cap_cmomi w=2.67e-6 l=2.52e-6 m=1
C_LVS_CC10_107 vcp bp8 cap_cmomi w=2.67e-6 l=2.52e-6 m=1
C_LVS_CC10_108 vcp bp8 cap_cmomi w=2.67e-6 l=2.52e-6 m=1
C_LVS_CC10_109 vcp bp8 cap_cmomi w=2.67e-6 l=2.52e-6 m=1
C_LVS_CC10_110 vcp bp8 cap_cmomi w=2.67e-6 l=2.52e-6 m=1
C_LVS_CC10_111 vcp bp8 cap_cmomi w=2.67e-6 l=2.52e-6 m=1
C_LVS_CC10_112 vcp bp8 cap_cmomi w=2.67e-6 l=2.52e-6 m=1
C_LVS_CC10_113 vcp bp8 cap_cmomi w=2.67e-6 l=2.52e-6 m=1
C_LVS_CC10_114 vcp bp8 cap_cmomi w=2.67e-6 l=2.52e-6 m=1
C_LVS_CC10_115 vcp bp8 cap_cmomi w=2.67e-6 l=2.52e-6 m=1
C_LVS_CC10_116 vcp bp8 cap_cmomi w=2.67e-6 l=2.52e-6 m=1
C_LVS_CC10_117 vcp bp8 cap_cmomi w=2.67e-6 l=2.52e-6 m=1
C_LVS_CC10_118 vcp bp8 cap_cmomi w=2.67e-6 l=2.52e-6 m=1
C_LVS_CC10_119 vcp bp8 cap_cmomi w=2.67e-6 l=2.52e-6 m=1
C_LVS_CC10_120 vcp bp8 cap_cmomi w=2.67e-6 l=2.52e-6 m=1
C_LVS_CC10_121 vcp bp8 cap_cmomi w=2.67e-6 l=2.52e-6 m=1
C_LVS_CC10_122 vcp bp8 cap_cmomi w=2.67e-6 l=2.52e-6 m=1
C_LVS_CC10_123 vcp bp8 cap_cmomi w=2.67e-6 l=2.52e-6 m=1
C_LVS_CC10_124 vcp bp8 cap_cmomi w=2.67e-6 l=2.52e-6 m=1
C_LVS_CC10_125 vcp bp8 cap_cmomi w=2.67e-6 l=2.52e-6 m=1
C_LVS_CC10_126 vcp bp8 cap_cmomi w=2.67e-6 l=2.52e-6 m=1
C_LVS_CC10_127 vcp bp8 cap_cmomi w=2.67e-6 l=2.52e-6 m=1
C_LVS_CC10_128 vcp bp8 cap_cmomi w=2.67e-6 l=2.52e-6 m=1
C_LVS_CC10_129 vcp bp8 cap_cmomi w=2.67e-6 l=2.52e-6 m=1
C_LVS_CC10_130 vcp bp8 cap_cmomi w=2.67e-6 l=2.52e-6 m=1
C_LVS_CC10_131 vcp bp8 cap_cmomi w=2.67e-6 l=2.52e-6 m=1
C_LVS_CC10_132 vcp bp8 cap_cmomi w=2.67e-6 l=2.52e-6 m=1
C_LVS_CC10_133 vcp bp8 cap_cmomi w=2.67e-6 l=2.52e-6 m=1
C_LVS_CC10_134 vcp bp8 cap_cmomi w=2.67e-6 l=2.52e-6 m=1
C_LVS_CC10_135 vcp bp8 cap_cmomi w=2.67e-6 l=2.52e-6 m=1
C_LVS_CC10_136 vcp bp8 cap_cmomi w=2.67e-6 l=2.52e-6 m=1
C_LVS_CC10_137 vcp bp8 cap_cmomi w=2.67e-6 l=2.52e-6 m=1
C_LVS_CC10_138 vcp bp8 cap_cmomi w=2.67e-6 l=2.52e-6 m=1
C_LVS_CC10_139 vcp bp8 cap_cmomi w=2.67e-6 l=2.52e-6 m=1
C_LVS_CC10_140 vcp bp8 cap_cmomi w=2.67e-6 l=2.52e-6 m=1
C_LVS_CC10_141 vcp bp8 cap_cmomi w=2.67e-6 l=2.52e-6 m=1
C_LVS_CC10_142 vcp bp8 cap_cmomi w=2.67e-6 l=2.52e-6 m=1
C_LVS_CC10_143 vcp bp8 cap_cmomi w=2.67e-6 l=2.52e-6 m=1
C_LVS_CC10_144 vcp bp8 cap_cmomi w=2.67e-6 l=2.52e-6 m=1
C_LVS_CC10_145 vcp bp8 cap_cmomi w=2.67e-6 l=2.52e-6 m=1
C_LVS_CC10_146 vcp bp8 cap_cmomi w=2.67e-6 l=2.52e-6 m=1
C_LVS_CC10_147 vcp bp8 cap_cmomi w=2.67e-6 l=2.52e-6 m=1
C_LVS_CC10_148 vcp bp8 cap_cmomi w=2.67e-6 l=2.52e-6 m=1
C_LVS_CC10_149 vcp bp8 cap_cmomi w=2.67e-6 l=2.52e-6 m=1
C_LVS_CC10_150 vcp bp8 cap_cmomi w=2.67e-6 l=2.52e-6 m=1
C_LVS_CC10_151 vcp bp8 cap_cmomi w=2.67e-6 l=2.52e-6 m=1
C_LVS_CC10_152 vcp bp8 cap_cmomi w=2.67e-6 l=2.52e-6 m=1
C_LVS_CC10_153 vcp bp8 cap_cmomi w=2.67e-6 l=2.52e-6 m=1
C_LVS_CC10_154 vcp bp8 cap_cmomi w=2.67e-6 l=2.52e-6 m=1
C_LVS_CC10_155 vcp bp8 cap_cmomi w=2.67e-6 l=2.52e-6 m=1
C_LVS_CC10_156 vcp bp8 cap_cmomi w=2.67e-6 l=2.52e-6 m=1
C_LVS_CC10_157 vcp bp8 cap_cmomi w=2.67e-6 l=2.52e-6 m=1
C_LVS_CC10_158 vcp bp8 cap_cmomi w=2.67e-6 l=2.52e-6 m=1
C_LVS_CC10_159 vcp bp8 cap_cmomi w=2.67e-6 l=2.52e-6 m=1
C_LVS_CC10_160 vcp bp8 cap_cmomi w=2.67e-6 l=2.52e-6 m=1
C_LVS_CC10_161 vcp bp8 cap_cmomi w=2.67e-6 l=2.52e-6 m=1
C_LVS_CC10_162 vcp bp8 cap_cmomi w=2.67e-6 l=2.52e-6 m=1
C_LVS_CC10_163 vcp bp8 cap_cmomi w=2.67e-6 l=2.52e-6 m=1
C_LVS_CC10_164 vcp bp8 cap_cmomi w=2.67e-6 l=2.52e-6 m=1
C_LVS_CC10_165 vcp bp8 cap_cmomi w=2.67e-6 l=2.52e-6 m=1
C_LVS_CC10_166 vcp bp8 cap_cmomi w=2.67e-6 l=2.52e-6 m=1
C_LVS_CC10_167 vcp bp8 cap_cmomi w=2.67e-6 l=2.52e-6 m=1
C_LVS_CC10_168 vcp bp8 cap_cmomi w=2.67e-6 l=2.52e-6 m=1
C_LVS_CC10_169 vcp bp8 cap_cmomi w=2.67e-6 l=2.52e-6 m=1
C_LVS_CC10_170 vcp bp8 cap_cmomi w=2.67e-6 l=2.52e-6 m=1
C_LVS_CC10_171 vcp bp8 cap_cmomi w=2.67e-6 l=2.52e-6 m=1
C_LVS_CC10_172 vcp bp8 cap_cmomi w=2.67e-6 l=2.52e-6 m=1
C_LVS_CC10_173 vcp bp8 cap_cmomi w=2.67e-6 l=2.52e-6 m=1
C_LVS_CC10_174 vcp bp8 cap_cmomi w=2.67e-6 l=2.52e-6 m=1
C_LVS_CC10_175 vcp bp8 cap_cmomi w=2.67e-6 l=2.52e-6 m=1
C_LVS_CC10_176 vcp bp8 cap_cmomi w=2.67e-6 l=2.52e-6 m=1
C_LVS_CC10_177 vcp bp8 cap_cmomi w=2.67e-6 l=2.52e-6 m=1
C_LVS_CC10_178 vcp bp8 cap_cmomi w=2.67e-6 l=2.52e-6 m=1
C_LVS_CC10_179 vcp bp8 cap_cmomi w=2.67e-6 l=2.52e-6 m=1
C_LVS_CC10_180 vcp bp8 cap_cmomi w=2.67e-6 l=2.52e-6 m=1
C_LVS_CC10_181 vcp bp8 cap_cmomi w=2.67e-6 l=2.52e-6 m=1
C_LVS_CC10_182 vcp bp8 cap_cmomi w=2.67e-6 l=2.52e-6 m=1
C_LVS_CC10_183 vcp bp8 cap_cmomi w=2.67e-6 l=2.52e-6 m=1
C_LVS_CC10_184 vcp bp8 cap_cmomi w=2.67e-6 l=2.52e-6 m=1
C_LVS_CC10_185 vcp bp8 cap_cmomi w=2.67e-6 l=2.52e-6 m=1
C_LVS_CC10_186 vcp bp8 cap_cmomi w=2.67e-6 l=2.52e-6 m=1
C_LVS_CC10_187 vcp bp8 cap_cmomi w=2.67e-6 l=2.52e-6 m=1
C_LVS_CC10_188 vcp bp8 cap_cmomi w=2.67e-6 l=2.52e-6 m=1
C_LVS_CC10_189 vcp bp8 cap_cmomi w=2.67e-6 l=2.52e-6 m=1
C_LVS_CC10_190 vcp bp8 cap_cmomi w=2.67e-6 l=2.52e-6 m=1
C_LVS_CC10_191 vcp bp8 cap_cmomi w=2.67e-6 l=2.52e-6 m=1
C_LVS_CC10_192 vcp bp8 cap_cmomi w=2.67e-6 l=2.52e-6 m=1
C_LVS_CC10_193 vcp bp8 cap_cmomi w=2.67e-6 l=2.52e-6 m=1
C_LVS_CC10_194 vcp bp8 cap_cmomi w=2.67e-6 l=2.52e-6 m=1
C_LVS_CC10_195 vcp bp8 cap_cmomi w=2.67e-6 l=2.52e-6 m=1
C_LVS_CC10_196 vcp bp8 cap_cmomi w=2.67e-6 l=2.52e-6 m=1
C_LVS_CC10_197 vcp bp8 cap_cmomi w=2.67e-6 l=2.52e-6 m=1
C_LVS_CC10_198 vcp bp8 cap_cmomi w=2.67e-6 l=2.52e-6 m=1
C_LVS_CC10_199 vcp bp8 cap_cmomi w=2.67e-6 l=2.52e-6 m=1
C_LVS_CC10_200 vcp bp8 cap_cmomi w=2.67e-6 l=2.52e-6 m=1
C_LVS_CC10_201 vcp bp8 cap_cmomi w=2.67e-6 l=2.52e-6 m=1
C_LVS_CC10_202 vcp bp8 cap_cmomi w=2.67e-6 l=2.52e-6 m=1
C_LVS_CC10_203 vcp bp8 cap_cmomi w=2.67e-6 l=2.52e-6 m=1
C_LVS_CC10_204 vcp bp8 cap_cmomi w=2.67e-6 l=2.52e-6 m=1
C_LVS_CC10_205 vcp bp8 cap_cmomi w=2.67e-6 l=2.52e-6 m=1
C_LVS_CC10_206 vcp bp8 cap_cmomi w=2.67e-6 l=2.52e-6 m=1
C_LVS_CC10_207 vcp bp8 cap_cmomi w=2.67e-6 l=2.52e-6 m=1
C_LVS_CC10_208 vcp bp8 cap_cmomi w=2.67e-6 l=2.52e-6 m=1
C_LVS_CC10_209 vcp bp8 cap_cmomi w=2.67e-6 l=2.52e-6 m=1
C_LVS_CC10_210 vcp bp8 cap_cmomi w=2.67e-6 l=2.52e-6 m=1
C_LVS_CC10_211 vcp bp8 cap_cmomi w=2.67e-6 l=2.52e-6 m=1
C_LVS_CC10_212 vcp bp8 cap_cmomi w=2.67e-6 l=2.52e-6 m=1
C_LVS_CC10_213 vcp bp8 cap_cmomi w=2.67e-6 l=2.52e-6 m=1
C_LVS_CC10_214 vcp bp8 cap_cmomi w=2.67e-6 l=2.52e-6 m=1
C_LVS_CC10_215 vcp bp8 cap_cmomi w=2.67e-6 l=2.52e-6 m=1
C_LVS_CC10_216 vcp bp8 cap_cmomi w=2.67e-6 l=2.52e-6 m=1
C_LVS_CC10_217 vcp bp8 cap_cmomi w=2.67e-6 l=2.52e-6 m=1
C_LVS_CC10_218 vcp bp8 cap_cmomi w=2.67e-6 l=2.52e-6 m=1
C_LVS_CC10_219 vcp bp8 cap_cmomi w=2.67e-6 l=2.52e-6 m=1
C_LVS_CC10_220 vcp bp8 cap_cmomi w=2.67e-6 l=2.52e-6 m=1
C_LVS_CC10_221 vcp bp8 cap_cmomi w=2.67e-6 l=2.52e-6 m=1
C_LVS_CC10_222 vcp bp8 cap_cmomi w=2.67e-6 l=2.52e-6 m=1
C_LVS_CC10_223 vcp bp8 cap_cmomi w=2.67e-6 l=2.52e-6 m=1
C_LVS_CC10_224 vcp bp8 cap_cmomi w=2.67e-6 l=2.52e-6 m=1
C_LVS_CC10_225 vcp bp8 cap_cmomi w=2.67e-6 l=2.52e-6 m=1
C_LVS_CC10_226 vcp bp8 cap_cmomi w=2.67e-6 l=2.52e-6 m=1
C_LVS_CC10_227 vcp bp8 cap_cmomi w=2.67e-6 l=2.52e-6 m=1
C_LVS_CC10_228 vcp bp8 cap_cmomi w=2.67e-6 l=2.52e-6 m=1
C_LVS_CC10_229 vcp bp8 cap_cmomi w=2.67e-6 l=2.52e-6 m=1
C_LVS_CC10_230 vcp bp8 cap_cmomi w=2.67e-6 l=2.52e-6 m=1
C_LVS_CC10_231 vcp bp8 cap_cmomi w=2.67e-6 l=2.52e-6 m=1
C_LVS_CC10_232 vcp bp8 cap_cmomi w=2.67e-6 l=2.52e-6 m=1
C_LVS_CC10_233 vcp bp8 cap_cmomi w=2.67e-6 l=2.52e-6 m=1
C_LVS_CC10_234 vcp bp8 cap_cmomi w=2.67e-6 l=2.52e-6 m=1
C_LVS_CC10_235 vcp bp8 cap_cmomi w=2.67e-6 l=2.52e-6 m=1
C_LVS_CC10_236 vcp bp8 cap_cmomi w=2.67e-6 l=2.52e-6 m=1
C_LVS_CC10_237 vcp bp8 cap_cmomi w=2.67e-6 l=2.52e-6 m=1
C_LVS_CC10_238 vcp bp8 cap_cmomi w=2.67e-6 l=2.52e-6 m=1
C_LVS_CC10_239 vcp bp8 cap_cmomi w=2.67e-6 l=2.52e-6 m=1
C_LVS_CC10_240 vcp bp8 cap_cmomi w=2.67e-6 l=2.52e-6 m=1
C_LVS_CC10_241 vcp bp8 cap_cmomi w=2.67e-6 l=2.52e-6 m=1
C_LVS_CC10_242 vcp bp8 cap_cmomi w=2.67e-6 l=2.52e-6 m=1
C_LVS_CC10_243 vcp bp8 cap_cmomi w=2.67e-6 l=2.52e-6 m=1
C_LVS_CC10_244 vcp bp8 cap_cmomi w=2.67e-6 l=2.52e-6 m=1
C_LVS_CC10_245 vcp bp8 cap_cmomi w=2.67e-6 l=2.52e-6 m=1
C_LVS_CC10_246 vcp bp8 cap_cmomi w=2.67e-6 l=2.52e-6 m=1
C_LVS_CC10_247 vcp bp8 cap_cmomi w=2.67e-6 l=2.52e-6 m=1
C_LVS_CC10_248 vcp bp8 cap_cmomi w=2.67e-6 l=2.52e-6 m=1
C_LVS_CC10_249 vcp bp8 cap_cmomi w=2.67e-6 l=2.52e-6 m=1
C_LVS_CC10_250 vcp bp8 cap_cmomi w=2.67e-6 l=2.52e-6 m=1
C_LVS_CC10_251 vcp bp8 cap_cmomi w=2.67e-6 l=2.52e-6 m=1
C_LVS_CC10_252 vcp bp8 cap_cmomi w=2.67e-6 l=2.52e-6 m=1
C_LVS_CC10_253 vcp bp8 cap_cmomi w=2.67e-6 l=2.52e-6 m=1
C_LVS_CC10_254 vcp bp8 cap_cmomi w=2.67e-6 l=2.52e-6 m=1
C_LVS_CC10_255 vcp bp8 cap_cmomi w=2.67e-6 l=2.52e-6 m=1
C_LVS_CC10_256 vcp bp8 cap_cmomi w=2.67e-6 l=2.52e-6 m=1
C_LVS_CC12_1 vcp bp9 cap_cmomi w=2.67e-6 l=2.52e-6 m=1
C_LVS_CC12_2 vcp bp9 cap_cmomi w=2.67e-6 l=2.52e-6 m=1
C_LVS_CC12_3 vcp bp9 cap_cmomi w=2.67e-6 l=2.52e-6 m=1
C_LVS_CC12_4 vcp bp9 cap_cmomi w=2.67e-6 l=2.52e-6 m=1
C_LVS_CC12_5 vcp bp9 cap_cmomi w=2.67e-6 l=2.52e-6 m=1
C_LVS_CC12_6 vcp bp9 cap_cmomi w=2.67e-6 l=2.52e-6 m=1
C_LVS_CC12_7 vcp bp9 cap_cmomi w=2.67e-6 l=2.52e-6 m=1
C_LVS_CC12_8 vcp bp9 cap_cmomi w=2.67e-6 l=2.52e-6 m=1
C_LVS_CC12_9 vcp bp9 cap_cmomi w=2.67e-6 l=2.52e-6 m=1
C_LVS_CC12_10 vcp bp9 cap_cmomi w=2.67e-6 l=2.52e-6 m=1
C_LVS_CC12_11 vcp bp9 cap_cmomi w=2.67e-6 l=2.52e-6 m=1
C_LVS_CC12_12 vcp bp9 cap_cmomi w=2.67e-6 l=2.52e-6 m=1
C_LVS_CC12_13 vcp bp9 cap_cmomi w=2.67e-6 l=2.52e-6 m=1
C_LVS_CC12_14 vcp bp9 cap_cmomi w=2.67e-6 l=2.52e-6 m=1
C_LVS_CC12_15 vcp bp9 cap_cmomi w=2.67e-6 l=2.52e-6 m=1
C_LVS_CC12_16 vcp bp9 cap_cmomi w=2.67e-6 l=2.52e-6 m=1
C_LVS_CC12_17 vcp bp9 cap_cmomi w=2.67e-6 l=2.52e-6 m=1
C_LVS_CC12_18 vcp bp9 cap_cmomi w=2.67e-6 l=2.52e-6 m=1
C_LVS_CC12_19 vcp bp9 cap_cmomi w=2.67e-6 l=2.52e-6 m=1
C_LVS_CC12_20 vcp bp9 cap_cmomi w=2.67e-6 l=2.52e-6 m=1
C_LVS_CC12_21 vcp bp9 cap_cmomi w=2.67e-6 l=2.52e-6 m=1
C_LVS_CC12_22 vcp bp9 cap_cmomi w=2.67e-6 l=2.52e-6 m=1
C_LVS_CC12_23 vcp bp9 cap_cmomi w=2.67e-6 l=2.52e-6 m=1
C_LVS_CC12_24 vcp bp9 cap_cmomi w=2.67e-6 l=2.52e-6 m=1
C_LVS_CC12_25 vcp bp9 cap_cmomi w=2.67e-6 l=2.52e-6 m=1
C_LVS_CC12_26 vcp bp9 cap_cmomi w=2.67e-6 l=2.52e-6 m=1
C_LVS_CC12_27 vcp bp9 cap_cmomi w=2.67e-6 l=2.52e-6 m=1
C_LVS_CC12_28 vcp bp9 cap_cmomi w=2.67e-6 l=2.52e-6 m=1
C_LVS_CC12_29 vcp bp9 cap_cmomi w=2.67e-6 l=2.52e-6 m=1
C_LVS_CC12_30 vcp bp9 cap_cmomi w=2.67e-6 l=2.52e-6 m=1
C_LVS_CC12_31 vcp bp9 cap_cmomi w=2.67e-6 l=2.52e-6 m=1
C_LVS_CC12_32 vcp bp9 cap_cmomi w=2.67e-6 l=2.52e-6 m=1
C_LVS_CC12_33 vcp bp9 cap_cmomi w=2.67e-6 l=2.52e-6 m=1
C_LVS_CC12_34 vcp bp9 cap_cmomi w=2.67e-6 l=2.52e-6 m=1
C_LVS_CC12_35 vcp bp9 cap_cmomi w=2.67e-6 l=2.52e-6 m=1
C_LVS_CC12_36 vcp bp9 cap_cmomi w=2.67e-6 l=2.52e-6 m=1
C_LVS_CC12_37 vcp bp9 cap_cmomi w=2.67e-6 l=2.52e-6 m=1
C_LVS_CC12_38 vcp bp9 cap_cmomi w=2.67e-6 l=2.52e-6 m=1
C_LVS_CC12_39 vcp bp9 cap_cmomi w=2.67e-6 l=2.52e-6 m=1
C_LVS_CC12_40 vcp bp9 cap_cmomi w=2.67e-6 l=2.52e-6 m=1
C_LVS_CC12_41 vcp bp9 cap_cmomi w=2.67e-6 l=2.52e-6 m=1
C_LVS_CC12_42 vcp bp9 cap_cmomi w=2.67e-6 l=2.52e-6 m=1
C_LVS_CC12_43 vcp bp9 cap_cmomi w=2.67e-6 l=2.52e-6 m=1
C_LVS_CC12_44 vcp bp9 cap_cmomi w=2.67e-6 l=2.52e-6 m=1
C_LVS_CC12_45 vcp bp9 cap_cmomi w=2.67e-6 l=2.52e-6 m=1
C_LVS_CC12_46 vcp bp9 cap_cmomi w=2.67e-6 l=2.52e-6 m=1
C_LVS_CC12_47 vcp bp9 cap_cmomi w=2.67e-6 l=2.52e-6 m=1
C_LVS_CC12_48 vcp bp9 cap_cmomi w=2.67e-6 l=2.52e-6 m=1
C_LVS_CC12_49 vcp bp9 cap_cmomi w=2.67e-6 l=2.52e-6 m=1
C_LVS_CC12_50 vcp bp9 cap_cmomi w=2.67e-6 l=2.52e-6 m=1
C_LVS_CC12_51 vcp bp9 cap_cmomi w=2.67e-6 l=2.52e-6 m=1
C_LVS_CC12_52 vcp bp9 cap_cmomi w=2.67e-6 l=2.52e-6 m=1
C_LVS_CC12_53 vcp bp9 cap_cmomi w=2.67e-6 l=2.52e-6 m=1
C_LVS_CC12_54 vcp bp9 cap_cmomi w=2.67e-6 l=2.52e-6 m=1
C_LVS_CC12_55 vcp bp9 cap_cmomi w=2.67e-6 l=2.52e-6 m=1
C_LVS_CC12_56 vcp bp9 cap_cmomi w=2.67e-6 l=2.52e-6 m=1
C_LVS_CC12_57 vcp bp9 cap_cmomi w=2.67e-6 l=2.52e-6 m=1
C_LVS_CC12_58 vcp bp9 cap_cmomi w=2.67e-6 l=2.52e-6 m=1
C_LVS_CC12_59 vcp bp9 cap_cmomi w=2.67e-6 l=2.52e-6 m=1
C_LVS_CC12_60 vcp bp9 cap_cmomi w=2.67e-6 l=2.52e-6 m=1
C_LVS_CC12_61 vcp bp9 cap_cmomi w=2.67e-6 l=2.52e-6 m=1
C_LVS_CC12_62 vcp bp9 cap_cmomi w=2.67e-6 l=2.52e-6 m=1
C_LVS_CC12_63 vcp bp9 cap_cmomi w=2.67e-6 l=2.52e-6 m=1
C_LVS_CC12_64 vcp bp9 cap_cmomi w=2.67e-6 l=2.52e-6 m=1
C_LVS_CC12_65 vcp bp9 cap_cmomi w=2.67e-6 l=2.52e-6 m=1
C_LVS_CC12_66 vcp bp9 cap_cmomi w=2.67e-6 l=2.52e-6 m=1
C_LVS_CC12_67 vcp bp9 cap_cmomi w=2.67e-6 l=2.52e-6 m=1
C_LVS_CC12_68 vcp bp9 cap_cmomi w=2.67e-6 l=2.52e-6 m=1
C_LVS_CC12_69 vcp bp9 cap_cmomi w=2.67e-6 l=2.52e-6 m=1
C_LVS_CC12_70 vcp bp9 cap_cmomi w=2.67e-6 l=2.52e-6 m=1
C_LVS_CC12_71 vcp bp9 cap_cmomi w=2.67e-6 l=2.52e-6 m=1
C_LVS_CC12_72 vcp bp9 cap_cmomi w=2.67e-6 l=2.52e-6 m=1
C_LVS_CC12_73 vcp bp9 cap_cmomi w=2.67e-6 l=2.52e-6 m=1
C_LVS_CC12_74 vcp bp9 cap_cmomi w=2.67e-6 l=2.52e-6 m=1
C_LVS_CC12_75 vcp bp9 cap_cmomi w=2.67e-6 l=2.52e-6 m=1
C_LVS_CC12_76 vcp bp9 cap_cmomi w=2.67e-6 l=2.52e-6 m=1
C_LVS_CC12_77 vcp bp9 cap_cmomi w=2.67e-6 l=2.52e-6 m=1
C_LVS_CC12_78 vcp bp9 cap_cmomi w=2.67e-6 l=2.52e-6 m=1
C_LVS_CC12_79 vcp bp9 cap_cmomi w=2.67e-6 l=2.52e-6 m=1
C_LVS_CC12_80 vcp bp9 cap_cmomi w=2.67e-6 l=2.52e-6 m=1
C_LVS_CC12_81 vcp bp9 cap_cmomi w=2.67e-6 l=2.52e-6 m=1
C_LVS_CC12_82 vcp bp9 cap_cmomi w=2.67e-6 l=2.52e-6 m=1
C_LVS_CC12_83 vcp bp9 cap_cmomi w=2.67e-6 l=2.52e-6 m=1
C_LVS_CC12_84 vcp bp9 cap_cmomi w=2.67e-6 l=2.52e-6 m=1
C_LVS_CC12_85 vcp bp9 cap_cmomi w=2.67e-6 l=2.52e-6 m=1
C_LVS_CC12_86 vcp bp9 cap_cmomi w=2.67e-6 l=2.52e-6 m=1
C_LVS_CC12_87 vcp bp9 cap_cmomi w=2.67e-6 l=2.52e-6 m=1
C_LVS_CC12_88 vcp bp9 cap_cmomi w=2.67e-6 l=2.52e-6 m=1
C_LVS_CC12_89 vcp bp9 cap_cmomi w=2.67e-6 l=2.52e-6 m=1
C_LVS_CC12_90 vcp bp9 cap_cmomi w=2.67e-6 l=2.52e-6 m=1
C_LVS_CC12_91 vcp bp9 cap_cmomi w=2.67e-6 l=2.52e-6 m=1
C_LVS_CC12_92 vcp bp9 cap_cmomi w=2.67e-6 l=2.52e-6 m=1
C_LVS_CC12_93 vcp bp9 cap_cmomi w=2.67e-6 l=2.52e-6 m=1
C_LVS_CC12_94 vcp bp9 cap_cmomi w=2.67e-6 l=2.52e-6 m=1
C_LVS_CC12_95 vcp bp9 cap_cmomi w=2.67e-6 l=2.52e-6 m=1
C_LVS_CC12_96 vcp bp9 cap_cmomi w=2.67e-6 l=2.52e-6 m=1
C_LVS_CC12_97 vcp bp9 cap_cmomi w=2.67e-6 l=2.52e-6 m=1
C_LVS_CC12_98 vcp bp9 cap_cmomi w=2.67e-6 l=2.52e-6 m=1
C_LVS_CC12_99 vcp bp9 cap_cmomi w=2.67e-6 l=2.52e-6 m=1
C_LVS_CC12_100 vcp bp9 cap_cmomi w=2.67e-6 l=2.52e-6 m=1
C_LVS_CC12_101 vcp bp9 cap_cmomi w=2.67e-6 l=2.52e-6 m=1
C_LVS_CC12_102 vcp bp9 cap_cmomi w=2.67e-6 l=2.52e-6 m=1
C_LVS_CC12_103 vcp bp9 cap_cmomi w=2.67e-6 l=2.52e-6 m=1
C_LVS_CC12_104 vcp bp9 cap_cmomi w=2.67e-6 l=2.52e-6 m=1
C_LVS_CC12_105 vcp bp9 cap_cmomi w=2.67e-6 l=2.52e-6 m=1
C_LVS_CC12_106 vcp bp9 cap_cmomi w=2.67e-6 l=2.52e-6 m=1
C_LVS_CC12_107 vcp bp9 cap_cmomi w=2.67e-6 l=2.52e-6 m=1
C_LVS_CC12_108 vcp bp9 cap_cmomi w=2.67e-6 l=2.52e-6 m=1
C_LVS_CC12_109 vcp bp9 cap_cmomi w=2.67e-6 l=2.52e-6 m=1
C_LVS_CC12_110 vcp bp9 cap_cmomi w=2.67e-6 l=2.52e-6 m=1
C_LVS_CC12_111 vcp bp9 cap_cmomi w=2.67e-6 l=2.52e-6 m=1
C_LVS_CC12_112 vcp bp9 cap_cmomi w=2.67e-6 l=2.52e-6 m=1
C_LVS_CC12_113 vcp bp9 cap_cmomi w=2.67e-6 l=2.52e-6 m=1
C_LVS_CC12_114 vcp bp9 cap_cmomi w=2.67e-6 l=2.52e-6 m=1
C_LVS_CC12_115 vcp bp9 cap_cmomi w=2.67e-6 l=2.52e-6 m=1
C_LVS_CC12_116 vcp bp9 cap_cmomi w=2.67e-6 l=2.52e-6 m=1
C_LVS_CC12_117 vcp bp9 cap_cmomi w=2.67e-6 l=2.52e-6 m=1
C_LVS_CC12_118 vcp bp9 cap_cmomi w=2.67e-6 l=2.52e-6 m=1
C_LVS_CC12_119 vcp bp9 cap_cmomi w=2.67e-6 l=2.52e-6 m=1
C_LVS_CC12_120 vcp bp9 cap_cmomi w=2.67e-6 l=2.52e-6 m=1
C_LVS_CC12_121 vcp bp9 cap_cmomi w=2.67e-6 l=2.52e-6 m=1
C_LVS_CC12_122 vcp bp9 cap_cmomi w=2.67e-6 l=2.52e-6 m=1
C_LVS_CC12_123 vcp bp9 cap_cmomi w=2.67e-6 l=2.52e-6 m=1
C_LVS_CC12_124 vcp bp9 cap_cmomi w=2.67e-6 l=2.52e-6 m=1
C_LVS_CC12_125 vcp bp9 cap_cmomi w=2.67e-6 l=2.52e-6 m=1
C_LVS_CC12_126 vcp bp9 cap_cmomi w=2.67e-6 l=2.52e-6 m=1
C_LVS_CC12_127 vcp bp9 cap_cmomi w=2.67e-6 l=2.52e-6 m=1
C_LVS_CC12_128 vcp bp9 cap_cmomi w=2.67e-6 l=2.52e-6 m=1
C_LVS_CC12_129 vcp bp9 cap_cmomi w=2.67e-6 l=2.52e-6 m=1
C_LVS_CC12_130 vcp bp9 cap_cmomi w=2.67e-6 l=2.52e-6 m=1
C_LVS_CC12_131 vcp bp9 cap_cmomi w=2.67e-6 l=2.52e-6 m=1
C_LVS_CC12_132 vcp bp9 cap_cmomi w=2.67e-6 l=2.52e-6 m=1
C_LVS_CC12_133 vcp bp9 cap_cmomi w=2.67e-6 l=2.52e-6 m=1
C_LVS_CC12_134 vcp bp9 cap_cmomi w=2.67e-6 l=2.52e-6 m=1
C_LVS_CC12_135 vcp bp9 cap_cmomi w=2.67e-6 l=2.52e-6 m=1
C_LVS_CC12_136 vcp bp9 cap_cmomi w=2.67e-6 l=2.52e-6 m=1
C_LVS_CC12_137 vcp bp9 cap_cmomi w=2.67e-6 l=2.52e-6 m=1
C_LVS_CC12_138 vcp bp9 cap_cmomi w=2.67e-6 l=2.52e-6 m=1
C_LVS_CC12_139 vcp bp9 cap_cmomi w=2.67e-6 l=2.52e-6 m=1
C_LVS_CC12_140 vcp bp9 cap_cmomi w=2.67e-6 l=2.52e-6 m=1
C_LVS_CC12_141 vcp bp9 cap_cmomi w=2.67e-6 l=2.52e-6 m=1
C_LVS_CC12_142 vcp bp9 cap_cmomi w=2.67e-6 l=2.52e-6 m=1
C_LVS_CC12_143 vcp bp9 cap_cmomi w=2.67e-6 l=2.52e-6 m=1
C_LVS_CC12_144 vcp bp9 cap_cmomi w=2.67e-6 l=2.52e-6 m=1
C_LVS_CC12_145 vcp bp9 cap_cmomi w=2.67e-6 l=2.52e-6 m=1
C_LVS_CC12_146 vcp bp9 cap_cmomi w=2.67e-6 l=2.52e-6 m=1
C_LVS_CC12_147 vcp bp9 cap_cmomi w=2.67e-6 l=2.52e-6 m=1
C_LVS_CC12_148 vcp bp9 cap_cmomi w=2.67e-6 l=2.52e-6 m=1
C_LVS_CC12_149 vcp bp9 cap_cmomi w=2.67e-6 l=2.52e-6 m=1
C_LVS_CC12_150 vcp bp9 cap_cmomi w=2.67e-6 l=2.52e-6 m=1
C_LVS_CC12_151 vcp bp9 cap_cmomi w=2.67e-6 l=2.52e-6 m=1
C_LVS_CC12_152 vcp bp9 cap_cmomi w=2.67e-6 l=2.52e-6 m=1
C_LVS_CC12_153 vcp bp9 cap_cmomi w=2.67e-6 l=2.52e-6 m=1
C_LVS_CC12_154 vcp bp9 cap_cmomi w=2.67e-6 l=2.52e-6 m=1
C_LVS_CC12_155 vcp bp9 cap_cmomi w=2.67e-6 l=2.52e-6 m=1
C_LVS_CC12_156 vcp bp9 cap_cmomi w=2.67e-6 l=2.52e-6 m=1
C_LVS_CC12_157 vcp bp9 cap_cmomi w=2.67e-6 l=2.52e-6 m=1
C_LVS_CC12_158 vcp bp9 cap_cmomi w=2.67e-6 l=2.52e-6 m=1
C_LVS_CC12_159 vcp bp9 cap_cmomi w=2.67e-6 l=2.52e-6 m=1
C_LVS_CC12_160 vcp bp9 cap_cmomi w=2.67e-6 l=2.52e-6 m=1
C_LVS_CC12_161 vcp bp9 cap_cmomi w=2.67e-6 l=2.52e-6 m=1
C_LVS_CC12_162 vcp bp9 cap_cmomi w=2.67e-6 l=2.52e-6 m=1
C_LVS_CC12_163 vcp bp9 cap_cmomi w=2.67e-6 l=2.52e-6 m=1
C_LVS_CC12_164 vcp bp9 cap_cmomi w=2.67e-6 l=2.52e-6 m=1
C_LVS_CC12_165 vcp bp9 cap_cmomi w=2.67e-6 l=2.52e-6 m=1
C_LVS_CC12_166 vcp bp9 cap_cmomi w=2.67e-6 l=2.52e-6 m=1
C_LVS_CC12_167 vcp bp9 cap_cmomi w=2.67e-6 l=2.52e-6 m=1
C_LVS_CC12_168 vcp bp9 cap_cmomi w=2.67e-6 l=2.52e-6 m=1
C_LVS_CC12_169 vcp bp9 cap_cmomi w=2.67e-6 l=2.52e-6 m=1
C_LVS_CC12_170 vcp bp9 cap_cmomi w=2.67e-6 l=2.52e-6 m=1
C_LVS_CC12_171 vcp bp9 cap_cmomi w=2.67e-6 l=2.52e-6 m=1
C_LVS_CC12_172 vcp bp9 cap_cmomi w=2.67e-6 l=2.52e-6 m=1
C_LVS_CC12_173 vcp bp9 cap_cmomi w=2.67e-6 l=2.52e-6 m=1
C_LVS_CC12_174 vcp bp9 cap_cmomi w=2.67e-6 l=2.52e-6 m=1
C_LVS_CC12_175 vcp bp9 cap_cmomi w=2.67e-6 l=2.52e-6 m=1
C_LVS_CC12_176 vcp bp9 cap_cmomi w=2.67e-6 l=2.52e-6 m=1
C_LVS_CC12_177 vcp bp9 cap_cmomi w=2.67e-6 l=2.52e-6 m=1
C_LVS_CC12_178 vcp bp9 cap_cmomi w=2.67e-6 l=2.52e-6 m=1
C_LVS_CC12_179 vcp bp9 cap_cmomi w=2.67e-6 l=2.52e-6 m=1
C_LVS_CC12_180 vcp bp9 cap_cmomi w=2.67e-6 l=2.52e-6 m=1
C_LVS_CC12_181 vcp bp9 cap_cmomi w=2.67e-6 l=2.52e-6 m=1
C_LVS_CC12_182 vcp bp9 cap_cmomi w=2.67e-6 l=2.52e-6 m=1
C_LVS_CC12_183 vcp bp9 cap_cmomi w=2.67e-6 l=2.52e-6 m=1
C_LVS_CC12_184 vcp bp9 cap_cmomi w=2.67e-6 l=2.52e-6 m=1
C_LVS_CC12_185 vcp bp9 cap_cmomi w=2.67e-6 l=2.52e-6 m=1
C_LVS_CC12_186 vcp bp9 cap_cmomi w=2.67e-6 l=2.52e-6 m=1
C_LVS_CC12_187 vcp bp9 cap_cmomi w=2.67e-6 l=2.52e-6 m=1
C_LVS_CC12_188 vcp bp9 cap_cmomi w=2.67e-6 l=2.52e-6 m=1
C_LVS_CC12_189 vcp bp9 cap_cmomi w=2.67e-6 l=2.52e-6 m=1
C_LVS_CC12_190 vcp bp9 cap_cmomi w=2.67e-6 l=2.52e-6 m=1
C_LVS_CC12_191 vcp bp9 cap_cmomi w=2.67e-6 l=2.52e-6 m=1
C_LVS_CC12_192 vcp bp9 cap_cmomi w=2.67e-6 l=2.52e-6 m=1
C_LVS_CC12_193 vcp bp9 cap_cmomi w=2.67e-6 l=2.52e-6 m=1
C_LVS_CC12_194 vcp bp9 cap_cmomi w=2.67e-6 l=2.52e-6 m=1
C_LVS_CC12_195 vcp bp9 cap_cmomi w=2.67e-6 l=2.52e-6 m=1
C_LVS_CC12_196 vcp bp9 cap_cmomi w=2.67e-6 l=2.52e-6 m=1
C_LVS_CC12_197 vcp bp9 cap_cmomi w=2.67e-6 l=2.52e-6 m=1
C_LVS_CC12_198 vcp bp9 cap_cmomi w=2.67e-6 l=2.52e-6 m=1
C_LVS_CC12_199 vcp bp9 cap_cmomi w=2.67e-6 l=2.52e-6 m=1
C_LVS_CC12_200 vcp bp9 cap_cmomi w=2.67e-6 l=2.52e-6 m=1
C_LVS_CC12_201 vcp bp9 cap_cmomi w=2.67e-6 l=2.52e-6 m=1
C_LVS_CC12_202 vcp bp9 cap_cmomi w=2.67e-6 l=2.52e-6 m=1
C_LVS_CC12_203 vcp bp9 cap_cmomi w=2.67e-6 l=2.52e-6 m=1
C_LVS_CC12_204 vcp bp9 cap_cmomi w=2.67e-6 l=2.52e-6 m=1
C_LVS_CC12_205 vcp bp9 cap_cmomi w=2.67e-6 l=2.52e-6 m=1
C_LVS_CC12_206 vcp bp9 cap_cmomi w=2.67e-6 l=2.52e-6 m=1
C_LVS_CC12_207 vcp bp9 cap_cmomi w=2.67e-6 l=2.52e-6 m=1
C_LVS_CC12_208 vcp bp9 cap_cmomi w=2.67e-6 l=2.52e-6 m=1
C_LVS_CC12_209 vcp bp9 cap_cmomi w=2.67e-6 l=2.52e-6 m=1
C_LVS_CC12_210 vcp bp9 cap_cmomi w=2.67e-6 l=2.52e-6 m=1
C_LVS_CC12_211 vcp bp9 cap_cmomi w=2.67e-6 l=2.52e-6 m=1
C_LVS_CC12_212 vcp bp9 cap_cmomi w=2.67e-6 l=2.52e-6 m=1
C_LVS_CC12_213 vcp bp9 cap_cmomi w=2.67e-6 l=2.52e-6 m=1
C_LVS_CC12_214 vcp bp9 cap_cmomi w=2.67e-6 l=2.52e-6 m=1
C_LVS_CC12_215 vcp bp9 cap_cmomi w=2.67e-6 l=2.52e-6 m=1
C_LVS_CC12_216 vcp bp9 cap_cmomi w=2.67e-6 l=2.52e-6 m=1
C_LVS_CC12_217 vcp bp9 cap_cmomi w=2.67e-6 l=2.52e-6 m=1
C_LVS_CC12_218 vcp bp9 cap_cmomi w=2.67e-6 l=2.52e-6 m=1
C_LVS_CC12_219 vcp bp9 cap_cmomi w=2.67e-6 l=2.52e-6 m=1
C_LVS_CC12_220 vcp bp9 cap_cmomi w=2.67e-6 l=2.52e-6 m=1
C_LVS_CC12_221 vcp bp9 cap_cmomi w=2.67e-6 l=2.52e-6 m=1
C_LVS_CC12_222 vcp bp9 cap_cmomi w=2.67e-6 l=2.52e-6 m=1
C_LVS_CC12_223 vcp bp9 cap_cmomi w=2.67e-6 l=2.52e-6 m=1
C_LVS_CC12_224 vcp bp9 cap_cmomi w=2.67e-6 l=2.52e-6 m=1
C_LVS_CC12_225 vcp bp9 cap_cmomi w=2.67e-6 l=2.52e-6 m=1
C_LVS_CC12_226 vcp bp9 cap_cmomi w=2.67e-6 l=2.52e-6 m=1
C_LVS_CC12_227 vcp bp9 cap_cmomi w=2.67e-6 l=2.52e-6 m=1
C_LVS_CC12_228 vcp bp9 cap_cmomi w=2.67e-6 l=2.52e-6 m=1
C_LVS_CC12_229 vcp bp9 cap_cmomi w=2.67e-6 l=2.52e-6 m=1
C_LVS_CC12_230 vcp bp9 cap_cmomi w=2.67e-6 l=2.52e-6 m=1
C_LVS_CC12_231 vcp bp9 cap_cmomi w=2.67e-6 l=2.52e-6 m=1
C_LVS_CC12_232 vcp bp9 cap_cmomi w=2.67e-6 l=2.52e-6 m=1
C_LVS_CC12_233 vcp bp9 cap_cmomi w=2.67e-6 l=2.52e-6 m=1
C_LVS_CC12_234 vcp bp9 cap_cmomi w=2.67e-6 l=2.52e-6 m=1
C_LVS_CC12_235 vcp bp9 cap_cmomi w=2.67e-6 l=2.52e-6 m=1
C_LVS_CC12_236 vcp bp9 cap_cmomi w=2.67e-6 l=2.52e-6 m=1
C_LVS_CC12_237 vcp bp9 cap_cmomi w=2.67e-6 l=2.52e-6 m=1
C_LVS_CC12_238 vcp bp9 cap_cmomi w=2.67e-6 l=2.52e-6 m=1
C_LVS_CC12_239 vcp bp9 cap_cmomi w=2.67e-6 l=2.52e-6 m=1
C_LVS_CC12_240 vcp bp9 cap_cmomi w=2.67e-6 l=2.52e-6 m=1
C_LVS_CC12_241 vcp bp9 cap_cmomi w=2.67e-6 l=2.52e-6 m=1
C_LVS_CC12_242 vcp bp9 cap_cmomi w=2.67e-6 l=2.52e-6 m=1
C_LVS_CC12_243 vcp bp9 cap_cmomi w=2.67e-6 l=2.52e-6 m=1
C_LVS_CC12_244 vcp bp9 cap_cmomi w=2.67e-6 l=2.52e-6 m=1
C_LVS_CC12_245 vcp bp9 cap_cmomi w=2.67e-6 l=2.52e-6 m=1
C_LVS_CC12_246 vcp bp9 cap_cmomi w=2.67e-6 l=2.52e-6 m=1
C_LVS_CC12_247 vcp bp9 cap_cmomi w=2.67e-6 l=2.52e-6 m=1
C_LVS_CC12_248 vcp bp9 cap_cmomi w=2.67e-6 l=2.52e-6 m=1
C_LVS_CC12_249 vcp bp9 cap_cmomi w=2.67e-6 l=2.52e-6 m=1
C_LVS_CC12_250 vcp bp9 cap_cmomi w=2.67e-6 l=2.52e-6 m=1
C_LVS_CC12_251 vcp bp9 cap_cmomi w=2.67e-6 l=2.52e-6 m=1
C_LVS_CC12_252 vcp bp9 cap_cmomi w=2.67e-6 l=2.52e-6 m=1
C_LVS_CC12_253 vcp bp9 cap_cmomi w=2.67e-6 l=2.52e-6 m=1
C_LVS_CC12_254 vcp bp9 cap_cmomi w=2.67e-6 l=2.52e-6 m=1
C_LVS_CC12_255 vcp bp9 cap_cmomi w=2.67e-6 l=2.52e-6 m=1
C_LVS_CC12_256 vcp bp9 cap_cmomi w=2.67e-6 l=2.52e-6 m=1
C_LVS_CC12_257 vcp bp9 cap_cmomi w=2.67e-6 l=2.52e-6 m=1
C_LVS_CC12_258 vcp bp9 cap_cmomi w=2.67e-6 l=2.52e-6 m=1
C_LVS_CC12_259 vcp bp9 cap_cmomi w=2.67e-6 l=2.52e-6 m=1
C_LVS_CC12_260 vcp bp9 cap_cmomi w=2.67e-6 l=2.52e-6 m=1
C_LVS_CC12_261 vcp bp9 cap_cmomi w=2.67e-6 l=2.52e-6 m=1
C_LVS_CC12_262 vcp bp9 cap_cmomi w=2.67e-6 l=2.52e-6 m=1
C_LVS_CC12_263 vcp bp9 cap_cmomi w=2.67e-6 l=2.52e-6 m=1
C_LVS_CC12_264 vcp bp9 cap_cmomi w=2.67e-6 l=2.52e-6 m=1
C_LVS_CC12_265 vcp bp9 cap_cmomi w=2.67e-6 l=2.52e-6 m=1
C_LVS_CC12_266 vcp bp9 cap_cmomi w=2.67e-6 l=2.52e-6 m=1
C_LVS_CC12_267 vcp bp9 cap_cmomi w=2.67e-6 l=2.52e-6 m=1
C_LVS_CC12_268 vcp bp9 cap_cmomi w=2.67e-6 l=2.52e-6 m=1
C_LVS_CC12_269 vcp bp9 cap_cmomi w=2.67e-6 l=2.52e-6 m=1
C_LVS_CC12_270 vcp bp9 cap_cmomi w=2.67e-6 l=2.52e-6 m=1
C_LVS_CC12_271 vcp bp9 cap_cmomi w=2.67e-6 l=2.52e-6 m=1
C_LVS_CC12_272 vcp bp9 cap_cmomi w=2.67e-6 l=2.52e-6 m=1
C_LVS_CC12_273 vcp bp9 cap_cmomi w=2.67e-6 l=2.52e-6 m=1
C_LVS_CC12_274 vcp bp9 cap_cmomi w=2.67e-6 l=2.52e-6 m=1
C_LVS_CC12_275 vcp bp9 cap_cmomi w=2.67e-6 l=2.52e-6 m=1
C_LVS_CC12_276 vcp bp9 cap_cmomi w=2.67e-6 l=2.52e-6 m=1
C_LVS_CC12_277 vcp bp9 cap_cmomi w=2.67e-6 l=2.52e-6 m=1
C_LVS_CC12_278 vcp bp9 cap_cmomi w=2.67e-6 l=2.52e-6 m=1
C_LVS_CC12_279 vcp bp9 cap_cmomi w=2.67e-6 l=2.52e-6 m=1
C_LVS_CC12_280 vcp bp9 cap_cmomi w=2.67e-6 l=2.52e-6 m=1
C_LVS_CC12_281 vcp bp9 cap_cmomi w=2.67e-6 l=2.52e-6 m=1
C_LVS_CC12_282 vcp bp9 cap_cmomi w=2.67e-6 l=2.52e-6 m=1
C_LVS_CC12_283 vcp bp9 cap_cmomi w=2.67e-6 l=2.52e-6 m=1
C_LVS_CC12_284 vcp bp9 cap_cmomi w=2.67e-6 l=2.52e-6 m=1
C_LVS_CC12_285 vcp bp9 cap_cmomi w=2.67e-6 l=2.52e-6 m=1
C_LVS_CC12_286 vcp bp9 cap_cmomi w=2.67e-6 l=2.52e-6 m=1
C_LVS_CC12_287 vcp bp9 cap_cmomi w=2.67e-6 l=2.52e-6 m=1
C_LVS_CC12_288 vcp bp9 cap_cmomi w=2.67e-6 l=2.52e-6 m=1
C_LVS_CC12_289 vcp bp9 cap_cmomi w=2.67e-6 l=2.52e-6 m=1
C_LVS_CC12_290 vcp bp9 cap_cmomi w=2.67e-6 l=2.52e-6 m=1
C_LVS_CC12_291 vcp bp9 cap_cmomi w=2.67e-6 l=2.52e-6 m=1
C_LVS_CC12_292 vcp bp9 cap_cmomi w=2.67e-6 l=2.52e-6 m=1
C_LVS_CC12_293 vcp bp9 cap_cmomi w=2.67e-6 l=2.52e-6 m=1
C_LVS_CC12_294 vcp bp9 cap_cmomi w=2.67e-6 l=2.52e-6 m=1
C_LVS_CC12_295 vcp bp9 cap_cmomi w=2.67e-6 l=2.52e-6 m=1
C_LVS_CC12_296 vcp bp9 cap_cmomi w=2.67e-6 l=2.52e-6 m=1
C_LVS_CC12_297 vcp bp9 cap_cmomi w=2.67e-6 l=2.52e-6 m=1
C_LVS_CC12_298 vcp bp9 cap_cmomi w=2.67e-6 l=2.52e-6 m=1
C_LVS_CC12_299 vcp bp9 cap_cmomi w=2.67e-6 l=2.52e-6 m=1
C_LVS_CC12_300 vcp bp9 cap_cmomi w=2.67e-6 l=2.52e-6 m=1
C_LVS_CC12_301 vcp bp9 cap_cmomi w=2.67e-6 l=2.52e-6 m=1
C_LVS_CC12_302 vcp bp9 cap_cmomi w=2.67e-6 l=2.52e-6 m=1
C_LVS_CC12_303 vcp bp9 cap_cmomi w=2.67e-6 l=2.52e-6 m=1
C_LVS_CC12_304 vcp bp9 cap_cmomi w=2.67e-6 l=2.52e-6 m=1
C_LVS_CC12_305 vcp bp9 cap_cmomi w=2.67e-6 l=2.52e-6 m=1
C_LVS_CC12_306 vcp bp9 cap_cmomi w=2.67e-6 l=2.52e-6 m=1
C_LVS_CC12_307 vcp bp9 cap_cmomi w=2.67e-6 l=2.52e-6 m=1
C_LVS_CC12_308 vcp bp9 cap_cmomi w=2.67e-6 l=2.52e-6 m=1
C_LVS_CC12_309 vcp bp9 cap_cmomi w=2.67e-6 l=2.52e-6 m=1
C_LVS_CC12_310 vcp bp9 cap_cmomi w=2.67e-6 l=2.52e-6 m=1
C_LVS_CC12_311 vcp bp9 cap_cmomi w=2.67e-6 l=2.52e-6 m=1
C_LVS_CC12_312 vcp bp9 cap_cmomi w=2.67e-6 l=2.52e-6 m=1
C_LVS_CC12_313 vcp bp9 cap_cmomi w=2.67e-6 l=2.52e-6 m=1
C_LVS_CC12_314 vcp bp9 cap_cmomi w=2.67e-6 l=2.52e-6 m=1
C_LVS_CC12_315 vcp bp9 cap_cmomi w=2.67e-6 l=2.52e-6 m=1
C_LVS_CC12_316 vcp bp9 cap_cmomi w=2.67e-6 l=2.52e-6 m=1
C_LVS_CC12_317 vcp bp9 cap_cmomi w=2.67e-6 l=2.52e-6 m=1
C_LVS_CC12_318 vcp bp9 cap_cmomi w=2.67e-6 l=2.52e-6 m=1
C_LVS_CC12_319 vcp bp9 cap_cmomi w=2.67e-6 l=2.52e-6 m=1
C_LVS_CC12_320 vcp bp9 cap_cmomi w=2.67e-6 l=2.52e-6 m=1
C_LVS_CC12_321 vcp bp9 cap_cmomi w=2.67e-6 l=2.52e-6 m=1
C_LVS_CC12_322 vcp bp9 cap_cmomi w=2.67e-6 l=2.52e-6 m=1
C_LVS_CC12_323 vcp bp9 cap_cmomi w=2.67e-6 l=2.52e-6 m=1
C_LVS_CC12_324 vcp bp9 cap_cmomi w=2.67e-6 l=2.52e-6 m=1
C_LVS_CC12_325 vcp bp9 cap_cmomi w=2.67e-6 l=2.52e-6 m=1
C_LVS_CC12_326 vcp bp9 cap_cmomi w=2.67e-6 l=2.52e-6 m=1
C_LVS_CC12_327 vcp bp9 cap_cmomi w=2.67e-6 l=2.52e-6 m=1
C_LVS_CC12_328 vcp bp9 cap_cmomi w=2.67e-6 l=2.52e-6 m=1
C_LVS_CC12_329 vcp bp9 cap_cmomi w=2.67e-6 l=2.52e-6 m=1
C_LVS_CC12_330 vcp bp9 cap_cmomi w=2.67e-6 l=2.52e-6 m=1
C_LVS_CC12_331 vcp bp9 cap_cmomi w=2.67e-6 l=2.52e-6 m=1
C_LVS_CC12_332 vcp bp9 cap_cmomi w=2.67e-6 l=2.52e-6 m=1
C_LVS_CC12_333 vcp bp9 cap_cmomi w=2.67e-6 l=2.52e-6 m=1
C_LVS_CC12_334 vcp bp9 cap_cmomi w=2.67e-6 l=2.52e-6 m=1
C_LVS_CC12_335 vcp bp9 cap_cmomi w=2.67e-6 l=2.52e-6 m=1
C_LVS_CC12_336 vcp bp9 cap_cmomi w=2.67e-6 l=2.52e-6 m=1
C_LVS_CC12_337 vcp bp9 cap_cmomi w=2.67e-6 l=2.52e-6 m=1
C_LVS_CC12_338 vcp bp9 cap_cmomi w=2.67e-6 l=2.52e-6 m=1
C_LVS_CC12_339 vcp bp9 cap_cmomi w=2.67e-6 l=2.52e-6 m=1
C_LVS_CC12_340 vcp bp9 cap_cmomi w=2.67e-6 l=2.52e-6 m=1
C_LVS_CC12_341 vcp bp9 cap_cmomi w=2.67e-6 l=2.52e-6 m=1
C_LVS_CC12_342 vcp bp9 cap_cmomi w=2.67e-6 l=2.52e-6 m=1
C_LVS_CC12_343 vcp bp9 cap_cmomi w=2.67e-6 l=2.52e-6 m=1
C_LVS_CC12_344 vcp bp9 cap_cmomi w=2.67e-6 l=2.52e-6 m=1
C_LVS_CC12_345 vcp bp9 cap_cmomi w=2.67e-6 l=2.52e-6 m=1
C_LVS_CC12_346 vcp bp9 cap_cmomi w=2.67e-6 l=2.52e-6 m=1
C_LVS_CC12_347 vcp bp9 cap_cmomi w=2.67e-6 l=2.52e-6 m=1
C_LVS_CC12_348 vcp bp9 cap_cmomi w=2.67e-6 l=2.52e-6 m=1
C_LVS_CC12_349 vcp bp9 cap_cmomi w=2.67e-6 l=2.52e-6 m=1
C_LVS_CC12_350 vcp bp9 cap_cmomi w=2.67e-6 l=2.52e-6 m=1
C_LVS_CC12_351 vcp bp9 cap_cmomi w=2.67e-6 l=2.52e-6 m=1
C_LVS_CC12_352 vcp bp9 cap_cmomi w=2.67e-6 l=2.52e-6 m=1
C_LVS_CC12_353 vcp bp9 cap_cmomi w=2.67e-6 l=2.52e-6 m=1
C_LVS_CC12_354 vcp bp9 cap_cmomi w=2.67e-6 l=2.52e-6 m=1
C_LVS_CC12_355 vcp bp9 cap_cmomi w=2.67e-6 l=2.52e-6 m=1
C_LVS_CC12_356 vcp bp9 cap_cmomi w=2.67e-6 l=2.52e-6 m=1
C_LVS_CC12_357 vcp bp9 cap_cmomi w=2.67e-6 l=2.52e-6 m=1
C_LVS_CC12_358 vcp bp9 cap_cmomi w=2.67e-6 l=2.52e-6 m=1
C_LVS_CC12_359 vcp bp9 cap_cmomi w=2.67e-6 l=2.52e-6 m=1
C_LVS_CC12_360 vcp bp9 cap_cmomi w=2.67e-6 l=2.52e-6 m=1
C_LVS_CC12_361 vcp bp9 cap_cmomi w=2.67e-6 l=2.52e-6 m=1
C_LVS_CC12_362 vcp bp9 cap_cmomi w=2.67e-6 l=2.52e-6 m=1
C_LVS_CC12_363 vcp bp9 cap_cmomi w=2.67e-6 l=2.52e-6 m=1
C_LVS_CC12_364 vcp bp9 cap_cmomi w=2.67e-6 l=2.52e-6 m=1
C_LVS_CC12_365 vcp bp9 cap_cmomi w=2.67e-6 l=2.52e-6 m=1
C_LVS_CC12_366 vcp bp9 cap_cmomi w=2.67e-6 l=2.52e-6 m=1
C_LVS_CC12_367 vcp bp9 cap_cmomi w=2.67e-6 l=2.52e-6 m=1
C_LVS_CC12_368 vcp bp9 cap_cmomi w=2.67e-6 l=2.52e-6 m=1
C_LVS_CC12_369 vcp bp9 cap_cmomi w=2.67e-6 l=2.52e-6 m=1
C_LVS_CC12_370 vcp bp9 cap_cmomi w=2.67e-6 l=2.52e-6 m=1
C_LVS_CC12_371 vcp bp9 cap_cmomi w=2.67e-6 l=2.52e-6 m=1
C_LVS_CC12_372 vcp bp9 cap_cmomi w=2.67e-6 l=2.52e-6 m=1
C_LVS_CC12_373 vcp bp9 cap_cmomi w=2.67e-6 l=2.52e-6 m=1
C_LVS_CC12_374 vcp bp9 cap_cmomi w=2.67e-6 l=2.52e-6 m=1
C_LVS_CC12_375 vcp bp9 cap_cmomi w=2.67e-6 l=2.52e-6 m=1
C_LVS_CC12_376 vcp bp9 cap_cmomi w=2.67e-6 l=2.52e-6 m=1
C_LVS_CC12_377 vcp bp9 cap_cmomi w=2.67e-6 l=2.52e-6 m=1
C_LVS_CC12_378 vcp bp9 cap_cmomi w=2.67e-6 l=2.52e-6 m=1
C_LVS_CC12_379 vcp bp9 cap_cmomi w=2.67e-6 l=2.52e-6 m=1
C_LVS_CC12_380 vcp bp9 cap_cmomi w=2.67e-6 l=2.52e-6 m=1
C_LVS_CC12_381 vcp bp9 cap_cmomi w=2.67e-6 l=2.52e-6 m=1
C_LVS_CC12_382 vcp bp9 cap_cmomi w=2.67e-6 l=2.52e-6 m=1
C_LVS_CC12_383 vcp bp9 cap_cmomi w=2.67e-6 l=2.52e-6 m=1
C_LVS_CC12_384 vcp bp9 cap_cmomi w=2.67e-6 l=2.52e-6 m=1
C_LVS_CC12_385 vcp bp9 cap_cmomi w=2.67e-6 l=2.52e-6 m=1
C_LVS_CC12_386 vcp bp9 cap_cmomi w=2.67e-6 l=2.52e-6 m=1
C_LVS_CC12_387 vcp bp9 cap_cmomi w=2.67e-6 l=2.52e-6 m=1
C_LVS_CC12_388 vcp bp9 cap_cmomi w=2.67e-6 l=2.52e-6 m=1
C_LVS_CC12_389 vcp bp9 cap_cmomi w=2.67e-6 l=2.52e-6 m=1
C_LVS_CC12_390 vcp bp9 cap_cmomi w=2.67e-6 l=2.52e-6 m=1
C_LVS_CC12_391 vcp bp9 cap_cmomi w=2.67e-6 l=2.52e-6 m=1
C_LVS_CC12_392 vcp bp9 cap_cmomi w=2.67e-6 l=2.52e-6 m=1
C_LVS_CC12_393 vcp bp9 cap_cmomi w=2.67e-6 l=2.52e-6 m=1
C_LVS_CC12_394 vcp bp9 cap_cmomi w=2.67e-6 l=2.52e-6 m=1
C_LVS_CC12_395 vcp bp9 cap_cmomi w=2.67e-6 l=2.52e-6 m=1
C_LVS_CC12_396 vcp bp9 cap_cmomi w=2.67e-6 l=2.52e-6 m=1
C_LVS_CC12_397 vcp bp9 cap_cmomi w=2.67e-6 l=2.52e-6 m=1
C_LVS_CC12_398 vcp bp9 cap_cmomi w=2.67e-6 l=2.52e-6 m=1
C_LVS_CC12_399 vcp bp9 cap_cmomi w=2.67e-6 l=2.52e-6 m=1
C_LVS_CC12_400 vcp bp9 cap_cmomi w=2.67e-6 l=2.52e-6 m=1
C_LVS_CC12_401 vcp bp9 cap_cmomi w=2.67e-6 l=2.52e-6 m=1
C_LVS_CC12_402 vcp bp9 cap_cmomi w=2.67e-6 l=2.52e-6 m=1
C_LVS_CC12_403 vcp bp9 cap_cmomi w=2.67e-6 l=2.52e-6 m=1
C_LVS_CC12_404 vcp bp9 cap_cmomi w=2.67e-6 l=2.52e-6 m=1
C_LVS_CC12_405 vcp bp9 cap_cmomi w=2.67e-6 l=2.52e-6 m=1
C_LVS_CC12_406 vcp bp9 cap_cmomi w=2.67e-6 l=2.52e-6 m=1
C_LVS_CC12_407 vcp bp9 cap_cmomi w=2.67e-6 l=2.52e-6 m=1
C_LVS_CC12_408 vcp bp9 cap_cmomi w=2.67e-6 l=2.52e-6 m=1
C_LVS_CC12_409 vcp bp9 cap_cmomi w=2.67e-6 l=2.52e-6 m=1
C_LVS_CC12_410 vcp bp9 cap_cmomi w=2.67e-6 l=2.52e-6 m=1
C_LVS_CC12_411 vcp bp9 cap_cmomi w=2.67e-6 l=2.52e-6 m=1
C_LVS_CC12_412 vcp bp9 cap_cmomi w=2.67e-6 l=2.52e-6 m=1
C_LVS_CC12_413 vcp bp9 cap_cmomi w=2.67e-6 l=2.52e-6 m=1
C_LVS_CC12_414 vcp bp9 cap_cmomi w=2.67e-6 l=2.52e-6 m=1
C_LVS_CC12_415 vcp bp9 cap_cmomi w=2.67e-6 l=2.52e-6 m=1
C_LVS_CC12_416 vcp bp9 cap_cmomi w=2.67e-6 l=2.52e-6 m=1
C_LVS_CC12_417 vcp bp9 cap_cmomi w=2.67e-6 l=2.52e-6 m=1
C_LVS_CC12_418 vcp bp9 cap_cmomi w=2.67e-6 l=2.52e-6 m=1
C_LVS_CC12_419 vcp bp9 cap_cmomi w=2.67e-6 l=2.52e-6 m=1
C_LVS_CC12_420 vcp bp9 cap_cmomi w=2.67e-6 l=2.52e-6 m=1
C_LVS_CC12_421 vcp bp9 cap_cmomi w=2.67e-6 l=2.52e-6 m=1
C_LVS_CC12_422 vcp bp9 cap_cmomi w=2.67e-6 l=2.52e-6 m=1
C_LVS_CC12_423 vcp bp9 cap_cmomi w=2.67e-6 l=2.52e-6 m=1
C_LVS_CC12_424 vcp bp9 cap_cmomi w=2.67e-6 l=2.52e-6 m=1
C_LVS_CC12_425 vcp bp9 cap_cmomi w=2.67e-6 l=2.52e-6 m=1
C_LVS_CC12_426 vcp bp9 cap_cmomi w=2.67e-6 l=2.52e-6 m=1
C_LVS_CC12_427 vcp bp9 cap_cmomi w=2.67e-6 l=2.52e-6 m=1
C_LVS_CC12_428 vcp bp9 cap_cmomi w=2.67e-6 l=2.52e-6 m=1
C_LVS_CC12_429 vcp bp9 cap_cmomi w=2.67e-6 l=2.52e-6 m=1
C_LVS_CC12_430 vcp bp9 cap_cmomi w=2.67e-6 l=2.52e-6 m=1
C_LVS_CC12_431 vcp bp9 cap_cmomi w=2.67e-6 l=2.52e-6 m=1
C_LVS_CC12_432 vcp bp9 cap_cmomi w=2.67e-6 l=2.52e-6 m=1
C_LVS_CC12_433 vcp bp9 cap_cmomi w=2.67e-6 l=2.52e-6 m=1
C_LVS_CC12_434 vcp bp9 cap_cmomi w=2.67e-6 l=2.52e-6 m=1
C_LVS_CC12_435 vcp bp9 cap_cmomi w=2.67e-6 l=2.52e-6 m=1
C_LVS_CC12_436 vcp bp9 cap_cmomi w=2.67e-6 l=2.52e-6 m=1
C_LVS_CC12_437 vcp bp9 cap_cmomi w=2.67e-6 l=2.52e-6 m=1
C_LVS_CC12_438 vcp bp9 cap_cmomi w=2.67e-6 l=2.52e-6 m=1
C_LVS_CC12_439 vcp bp9 cap_cmomi w=2.67e-6 l=2.52e-6 m=1
C_LVS_CC12_440 vcp bp9 cap_cmomi w=2.67e-6 l=2.52e-6 m=1
C_LVS_CC12_441 vcp bp9 cap_cmomi w=2.67e-6 l=2.52e-6 m=1
C_LVS_CC12_442 vcp bp9 cap_cmomi w=2.67e-6 l=2.52e-6 m=1
C_LVS_CC12_443 vcp bp9 cap_cmomi w=2.67e-6 l=2.52e-6 m=1
C_LVS_CC12_444 vcp bp9 cap_cmomi w=2.67e-6 l=2.52e-6 m=1
C_LVS_CC12_445 vcp bp9 cap_cmomi w=2.67e-6 l=2.52e-6 m=1
C_LVS_CC12_446 vcp bp9 cap_cmomi w=2.67e-6 l=2.52e-6 m=1
C_LVS_CC12_447 vcp bp9 cap_cmomi w=2.67e-6 l=2.52e-6 m=1
C_LVS_CC12_448 vcp bp9 cap_cmomi w=2.67e-6 l=2.52e-6 m=1
C_LVS_CC12_449 vcp bp9 cap_cmomi w=2.67e-6 l=2.52e-6 m=1
C_LVS_CC12_450 vcp bp9 cap_cmomi w=2.67e-6 l=2.52e-6 m=1
C_LVS_CC12_451 vcp bp9 cap_cmomi w=2.67e-6 l=2.52e-6 m=1
C_LVS_CC12_452 vcp bp9 cap_cmomi w=2.67e-6 l=2.52e-6 m=1
C_LVS_CC12_453 vcp bp9 cap_cmomi w=2.67e-6 l=2.52e-6 m=1
C_LVS_CC12_454 vcp bp9 cap_cmomi w=2.67e-6 l=2.52e-6 m=1
C_LVS_CC12_455 vcp bp9 cap_cmomi w=2.67e-6 l=2.52e-6 m=1
C_LVS_CC12_456 vcp bp9 cap_cmomi w=2.67e-6 l=2.52e-6 m=1
C_LVS_CC12_457 vcp bp9 cap_cmomi w=2.67e-6 l=2.52e-6 m=1
C_LVS_CC12_458 vcp bp9 cap_cmomi w=2.67e-6 l=2.52e-6 m=1
C_LVS_CC12_459 vcp bp9 cap_cmomi w=2.67e-6 l=2.52e-6 m=1
C_LVS_CC12_460 vcp bp9 cap_cmomi w=2.67e-6 l=2.52e-6 m=1
C_LVS_CC12_461 vcp bp9 cap_cmomi w=2.67e-6 l=2.52e-6 m=1
C_LVS_CC12_462 vcp bp9 cap_cmomi w=2.67e-6 l=2.52e-6 m=1
C_LVS_CC12_463 vcp bp9 cap_cmomi w=2.67e-6 l=2.52e-6 m=1
C_LVS_CC12_464 vcp bp9 cap_cmomi w=2.67e-6 l=2.52e-6 m=1
C_LVS_CC12_465 vcp bp9 cap_cmomi w=2.67e-6 l=2.52e-6 m=1
C_LVS_CC12_466 vcp bp9 cap_cmomi w=2.67e-6 l=2.52e-6 m=1
C_LVS_CC12_467 vcp bp9 cap_cmomi w=2.67e-6 l=2.52e-6 m=1
C_LVS_CC12_468 vcp bp9 cap_cmomi w=2.67e-6 l=2.52e-6 m=1
C_LVS_CC12_469 vcp bp9 cap_cmomi w=2.67e-6 l=2.52e-6 m=1
C_LVS_CC12_470 vcp bp9 cap_cmomi w=2.67e-6 l=2.52e-6 m=1
C_LVS_CC12_471 vcp bp9 cap_cmomi w=2.67e-6 l=2.52e-6 m=1
C_LVS_CC12_472 vcp bp9 cap_cmomi w=2.67e-6 l=2.52e-6 m=1
C_LVS_CC12_473 vcp bp9 cap_cmomi w=2.67e-6 l=2.52e-6 m=1
C_LVS_CC12_474 vcp bp9 cap_cmomi w=2.67e-6 l=2.52e-6 m=1
C_LVS_CC12_475 vcp bp9 cap_cmomi w=2.67e-6 l=2.52e-6 m=1
C_LVS_CC12_476 vcp bp9 cap_cmomi w=2.67e-6 l=2.52e-6 m=1
C_LVS_CC12_477 vcp bp9 cap_cmomi w=2.67e-6 l=2.52e-6 m=1
C_LVS_CC12_478 vcp bp9 cap_cmomi w=2.67e-6 l=2.52e-6 m=1
C_LVS_CC12_479 vcp bp9 cap_cmomi w=2.67e-6 l=2.52e-6 m=1
C_LVS_CC12_480 vcp bp9 cap_cmomi w=2.67e-6 l=2.52e-6 m=1
C_LVS_CC12_481 vcp bp9 cap_cmomi w=2.67e-6 l=2.52e-6 m=1
C_LVS_CC12_482 vcp bp9 cap_cmomi w=2.67e-6 l=2.52e-6 m=1
C_LVS_CC12_483 vcp bp9 cap_cmomi w=2.67e-6 l=2.52e-6 m=1
C_LVS_CC12_484 vcp bp9 cap_cmomi w=2.67e-6 l=2.52e-6 m=1
C_LVS_CC12_485 vcp bp9 cap_cmomi w=2.67e-6 l=2.52e-6 m=1
C_LVS_CC12_486 vcp bp9 cap_cmomi w=2.67e-6 l=2.52e-6 m=1
C_LVS_CC12_487 vcp bp9 cap_cmomi w=2.67e-6 l=2.52e-6 m=1
C_LVS_CC12_488 vcp bp9 cap_cmomi w=2.67e-6 l=2.52e-6 m=1
C_LVS_CC12_489 vcp bp9 cap_cmomi w=2.67e-6 l=2.52e-6 m=1
C_LVS_CC12_490 vcp bp9 cap_cmomi w=2.67e-6 l=2.52e-6 m=1
C_LVS_CC12_491 vcp bp9 cap_cmomi w=2.67e-6 l=2.52e-6 m=1
C_LVS_CC12_492 vcp bp9 cap_cmomi w=2.67e-6 l=2.52e-6 m=1
C_LVS_CC12_493 vcp bp9 cap_cmomi w=2.67e-6 l=2.52e-6 m=1
C_LVS_CC12_494 vcp bp9 cap_cmomi w=2.67e-6 l=2.52e-6 m=1
C_LVS_CC12_495 vcp bp9 cap_cmomi w=2.67e-6 l=2.52e-6 m=1
C_LVS_CC12_496 vcp bp9 cap_cmomi w=2.67e-6 l=2.52e-6 m=1
C_LVS_CC12_497 vcp bp9 cap_cmomi w=2.67e-6 l=2.52e-6 m=1
C_LVS_CC12_498 vcp bp9 cap_cmomi w=2.67e-6 l=2.52e-6 m=1
C_LVS_CC12_499 vcp bp9 cap_cmomi w=2.67e-6 l=2.52e-6 m=1
C_LVS_CC12_500 vcp bp9 cap_cmomi w=2.67e-6 l=2.52e-6 m=1
C_LVS_CC12_501 vcp bp9 cap_cmomi w=2.67e-6 l=2.52e-6 m=1
C_LVS_CC12_502 vcp bp9 cap_cmomi w=2.67e-6 l=2.52e-6 m=1
C_LVS_CC12_503 vcp bp9 cap_cmomi w=2.67e-6 l=2.52e-6 m=1
C_LVS_CC12_504 vcp bp9 cap_cmomi w=2.67e-6 l=2.52e-6 m=1
C_LVS_CC12_505 vcp bp9 cap_cmomi w=2.67e-6 l=2.52e-6 m=1
C_LVS_CC12_506 vcp bp9 cap_cmomi w=2.67e-6 l=2.52e-6 m=1
C_LVS_CC12_507 vcp bp9 cap_cmomi w=2.67e-6 l=2.52e-6 m=1
C_LVS_CC12_508 vcp bp9 cap_cmomi w=2.67e-6 l=2.52e-6 m=1
C_LVS_CC12_509 vcp bp9 cap_cmomi w=2.67e-6 l=2.52e-6 m=1
C_LVS_CC12_510 vcp bp9 cap_cmomi w=2.67e-6 l=2.52e-6 m=1
C_LVS_CC12_511 vcp bp9 cap_cmomi w=2.67e-6 l=2.52e-6 m=1
C_LVS_CC12_512 vcp bp9 cap_cmomi w=2.67e-6 l=2.52e-6 m=1
C_LVS_CC11_1 vcn bnd cap_cmomi w=2.67e-6 l=2.52e-6 m=1
C_LVS_CC13_1 vcn bn0 cap_cmomi w=2.67e-6 l=2.52e-6 m=1
C_LVS_CC14_1 vcn bn1 cap_cmomi w=2.67e-6 l=2.52e-6 m=1
C_LVS_CC14_2 vcn bn1 cap_cmomi w=2.67e-6 l=2.52e-6 m=1
C_LVS_CC15_1 vcn bn2 cap_cmomi w=2.67e-6 l=2.52e-6 m=1
C_LVS_CC15_2 vcn bn2 cap_cmomi w=2.67e-6 l=2.52e-6 m=1
C_LVS_CC15_3 vcn bn2 cap_cmomi w=2.67e-6 l=2.52e-6 m=1
C_LVS_CC15_4 vcn bn2 cap_cmomi w=2.67e-6 l=2.52e-6 m=1
C_LVS_CC16_1 vcn bn3 cap_cmomi w=2.67e-6 l=2.52e-6 m=1
C_LVS_CC16_2 vcn bn3 cap_cmomi w=2.67e-6 l=2.52e-6 m=1
C_LVS_CC16_3 vcn bn3 cap_cmomi w=2.67e-6 l=2.52e-6 m=1
C_LVS_CC16_4 vcn bn3 cap_cmomi w=2.67e-6 l=2.52e-6 m=1
C_LVS_CC16_5 vcn bn3 cap_cmomi w=2.67e-6 l=2.52e-6 m=1
C_LVS_CC16_6 vcn bn3 cap_cmomi w=2.67e-6 l=2.52e-6 m=1
C_LVS_CC16_7 vcn bn3 cap_cmomi w=2.67e-6 l=2.52e-6 m=1
C_LVS_CC16_8 vcn bn3 cap_cmomi w=2.67e-6 l=2.52e-6 m=1
C_LVS_CC17_1 vcn bn4 cap_cmomi w=2.67e-6 l=2.52e-6 m=1
C_LVS_CC17_2 vcn bn4 cap_cmomi w=2.67e-6 l=2.52e-6 m=1
C_LVS_CC17_3 vcn bn4 cap_cmomi w=2.67e-6 l=2.52e-6 m=1
C_LVS_CC17_4 vcn bn4 cap_cmomi w=2.67e-6 l=2.52e-6 m=1
C_LVS_CC17_5 vcn bn4 cap_cmomi w=2.67e-6 l=2.52e-6 m=1
C_LVS_CC17_6 vcn bn4 cap_cmomi w=2.67e-6 l=2.52e-6 m=1
C_LVS_CC17_7 vcn bn4 cap_cmomi w=2.67e-6 l=2.52e-6 m=1
C_LVS_CC17_8 vcn bn4 cap_cmomi w=2.67e-6 l=2.52e-6 m=1
C_LVS_CC17_9 vcn bn4 cap_cmomi w=2.67e-6 l=2.52e-6 m=1
C_LVS_CC17_10 vcn bn4 cap_cmomi w=2.67e-6 l=2.52e-6 m=1
C_LVS_CC17_11 vcn bn4 cap_cmomi w=2.67e-6 l=2.52e-6 m=1
C_LVS_CC17_12 vcn bn4 cap_cmomi w=2.67e-6 l=2.52e-6 m=1
C_LVS_CC17_13 vcn bn4 cap_cmomi w=2.67e-6 l=2.52e-6 m=1
C_LVS_CC17_14 vcn bn4 cap_cmomi w=2.67e-6 l=2.52e-6 m=1
C_LVS_CC17_15 vcn bn4 cap_cmomi w=2.67e-6 l=2.52e-6 m=1
C_LVS_CC17_16 vcn bn4 cap_cmomi w=2.67e-6 l=2.52e-6 m=1
C_LVS_CC18_1 vcn bn5 cap_cmomi w=2.67e-6 l=2.52e-6 m=1
C_LVS_CC18_2 vcn bn5 cap_cmomi w=2.67e-6 l=2.52e-6 m=1
C_LVS_CC18_3 vcn bn5 cap_cmomi w=2.67e-6 l=2.52e-6 m=1
C_LVS_CC18_4 vcn bn5 cap_cmomi w=2.67e-6 l=2.52e-6 m=1
C_LVS_CC18_5 vcn bn5 cap_cmomi w=2.67e-6 l=2.52e-6 m=1
C_LVS_CC18_6 vcn bn5 cap_cmomi w=2.67e-6 l=2.52e-6 m=1
C_LVS_CC18_7 vcn bn5 cap_cmomi w=2.67e-6 l=2.52e-6 m=1
C_LVS_CC18_8 vcn bn5 cap_cmomi w=2.67e-6 l=2.52e-6 m=1
C_LVS_CC18_9 vcn bn5 cap_cmomi w=2.67e-6 l=2.52e-6 m=1
C_LVS_CC18_10 vcn bn5 cap_cmomi w=2.67e-6 l=2.52e-6 m=1
C_LVS_CC18_11 vcn bn5 cap_cmomi w=2.67e-6 l=2.52e-6 m=1
C_LVS_CC18_12 vcn bn5 cap_cmomi w=2.67e-6 l=2.52e-6 m=1
C_LVS_CC18_13 vcn bn5 cap_cmomi w=2.67e-6 l=2.52e-6 m=1
C_LVS_CC18_14 vcn bn5 cap_cmomi w=2.67e-6 l=2.52e-6 m=1
C_LVS_CC18_15 vcn bn5 cap_cmomi w=2.67e-6 l=2.52e-6 m=1
C_LVS_CC18_16 vcn bn5 cap_cmomi w=2.67e-6 l=2.52e-6 m=1
C_LVS_CC18_17 vcn bn5 cap_cmomi w=2.67e-6 l=2.52e-6 m=1
C_LVS_CC18_18 vcn bn5 cap_cmomi w=2.67e-6 l=2.52e-6 m=1
C_LVS_CC18_19 vcn bn5 cap_cmomi w=2.67e-6 l=2.52e-6 m=1
C_LVS_CC18_20 vcn bn5 cap_cmomi w=2.67e-6 l=2.52e-6 m=1
C_LVS_CC18_21 vcn bn5 cap_cmomi w=2.67e-6 l=2.52e-6 m=1
C_LVS_CC18_22 vcn bn5 cap_cmomi w=2.67e-6 l=2.52e-6 m=1
C_LVS_CC18_23 vcn bn5 cap_cmomi w=2.67e-6 l=2.52e-6 m=1
C_LVS_CC18_24 vcn bn5 cap_cmomi w=2.67e-6 l=2.52e-6 m=1
C_LVS_CC18_25 vcn bn5 cap_cmomi w=2.67e-6 l=2.52e-6 m=1
C_LVS_CC18_26 vcn bn5 cap_cmomi w=2.67e-6 l=2.52e-6 m=1
C_LVS_CC18_27 vcn bn5 cap_cmomi w=2.67e-6 l=2.52e-6 m=1
C_LVS_CC18_28 vcn bn5 cap_cmomi w=2.67e-6 l=2.52e-6 m=1
C_LVS_CC18_29 vcn bn5 cap_cmomi w=2.67e-6 l=2.52e-6 m=1
C_LVS_CC18_30 vcn bn5 cap_cmomi w=2.67e-6 l=2.52e-6 m=1
C_LVS_CC18_31 vcn bn5 cap_cmomi w=2.67e-6 l=2.52e-6 m=1
C_LVS_CC18_32 vcn bn5 cap_cmomi w=2.67e-6 l=2.52e-6 m=1
C_LVS_CC19_1 vcn bn6 cap_cmomi w=2.67e-6 l=2.52e-6 m=1
C_LVS_CC19_2 vcn bn6 cap_cmomi w=2.67e-6 l=2.52e-6 m=1
C_LVS_CC19_3 vcn bn6 cap_cmomi w=2.67e-6 l=2.52e-6 m=1
C_LVS_CC19_4 vcn bn6 cap_cmomi w=2.67e-6 l=2.52e-6 m=1
C_LVS_CC19_5 vcn bn6 cap_cmomi w=2.67e-6 l=2.52e-6 m=1
C_LVS_CC19_6 vcn bn6 cap_cmomi w=2.67e-6 l=2.52e-6 m=1
C_LVS_CC19_7 vcn bn6 cap_cmomi w=2.67e-6 l=2.52e-6 m=1
C_LVS_CC19_8 vcn bn6 cap_cmomi w=2.67e-6 l=2.52e-6 m=1
C_LVS_CC19_9 vcn bn6 cap_cmomi w=2.67e-6 l=2.52e-6 m=1
C_LVS_CC19_10 vcn bn6 cap_cmomi w=2.67e-6 l=2.52e-6 m=1
C_LVS_CC19_11 vcn bn6 cap_cmomi w=2.67e-6 l=2.52e-6 m=1
C_LVS_CC19_12 vcn bn6 cap_cmomi w=2.67e-6 l=2.52e-6 m=1
C_LVS_CC19_13 vcn bn6 cap_cmomi w=2.67e-6 l=2.52e-6 m=1
C_LVS_CC19_14 vcn bn6 cap_cmomi w=2.67e-6 l=2.52e-6 m=1
C_LVS_CC19_15 vcn bn6 cap_cmomi w=2.67e-6 l=2.52e-6 m=1
C_LVS_CC19_16 vcn bn6 cap_cmomi w=2.67e-6 l=2.52e-6 m=1
C_LVS_CC19_17 vcn bn6 cap_cmomi w=2.67e-6 l=2.52e-6 m=1
C_LVS_CC19_18 vcn bn6 cap_cmomi w=2.67e-6 l=2.52e-6 m=1
C_LVS_CC19_19 vcn bn6 cap_cmomi w=2.67e-6 l=2.52e-6 m=1
C_LVS_CC19_20 vcn bn6 cap_cmomi w=2.67e-6 l=2.52e-6 m=1
C_LVS_CC19_21 vcn bn6 cap_cmomi w=2.67e-6 l=2.52e-6 m=1
C_LVS_CC19_22 vcn bn6 cap_cmomi w=2.67e-6 l=2.52e-6 m=1
C_LVS_CC19_23 vcn bn6 cap_cmomi w=2.67e-6 l=2.52e-6 m=1
C_LVS_CC19_24 vcn bn6 cap_cmomi w=2.67e-6 l=2.52e-6 m=1
C_LVS_CC19_25 vcn bn6 cap_cmomi w=2.67e-6 l=2.52e-6 m=1
C_LVS_CC19_26 vcn bn6 cap_cmomi w=2.67e-6 l=2.52e-6 m=1
C_LVS_CC19_27 vcn bn6 cap_cmomi w=2.67e-6 l=2.52e-6 m=1
C_LVS_CC19_28 vcn bn6 cap_cmomi w=2.67e-6 l=2.52e-6 m=1
C_LVS_CC19_29 vcn bn6 cap_cmomi w=2.67e-6 l=2.52e-6 m=1
C_LVS_CC19_30 vcn bn6 cap_cmomi w=2.67e-6 l=2.52e-6 m=1
C_LVS_CC19_31 vcn bn6 cap_cmomi w=2.67e-6 l=2.52e-6 m=1
C_LVS_CC19_32 vcn bn6 cap_cmomi w=2.67e-6 l=2.52e-6 m=1
C_LVS_CC19_33 vcn bn6 cap_cmomi w=2.67e-6 l=2.52e-6 m=1
C_LVS_CC19_34 vcn bn6 cap_cmomi w=2.67e-6 l=2.52e-6 m=1
C_LVS_CC19_35 vcn bn6 cap_cmomi w=2.67e-6 l=2.52e-6 m=1
C_LVS_CC19_36 vcn bn6 cap_cmomi w=2.67e-6 l=2.52e-6 m=1
C_LVS_CC19_37 vcn bn6 cap_cmomi w=2.67e-6 l=2.52e-6 m=1
C_LVS_CC19_38 vcn bn6 cap_cmomi w=2.67e-6 l=2.52e-6 m=1
C_LVS_CC19_39 vcn bn6 cap_cmomi w=2.67e-6 l=2.52e-6 m=1
C_LVS_CC19_40 vcn bn6 cap_cmomi w=2.67e-6 l=2.52e-6 m=1
C_LVS_CC19_41 vcn bn6 cap_cmomi w=2.67e-6 l=2.52e-6 m=1
C_LVS_CC19_42 vcn bn6 cap_cmomi w=2.67e-6 l=2.52e-6 m=1
C_LVS_CC19_43 vcn bn6 cap_cmomi w=2.67e-6 l=2.52e-6 m=1
C_LVS_CC19_44 vcn bn6 cap_cmomi w=2.67e-6 l=2.52e-6 m=1
C_LVS_CC19_45 vcn bn6 cap_cmomi w=2.67e-6 l=2.52e-6 m=1
C_LVS_CC19_46 vcn bn6 cap_cmomi w=2.67e-6 l=2.52e-6 m=1
C_LVS_CC19_47 vcn bn6 cap_cmomi w=2.67e-6 l=2.52e-6 m=1
C_LVS_CC19_48 vcn bn6 cap_cmomi w=2.67e-6 l=2.52e-6 m=1
C_LVS_CC19_49 vcn bn6 cap_cmomi w=2.67e-6 l=2.52e-6 m=1
C_LVS_CC19_50 vcn bn6 cap_cmomi w=2.67e-6 l=2.52e-6 m=1
C_LVS_CC19_51 vcn bn6 cap_cmomi w=2.67e-6 l=2.52e-6 m=1
C_LVS_CC19_52 vcn bn6 cap_cmomi w=2.67e-6 l=2.52e-6 m=1
C_LVS_CC19_53 vcn bn6 cap_cmomi w=2.67e-6 l=2.52e-6 m=1
C_LVS_CC19_54 vcn bn6 cap_cmomi w=2.67e-6 l=2.52e-6 m=1
C_LVS_CC19_55 vcn bn6 cap_cmomi w=2.67e-6 l=2.52e-6 m=1
C_LVS_CC19_56 vcn bn6 cap_cmomi w=2.67e-6 l=2.52e-6 m=1
C_LVS_CC19_57 vcn bn6 cap_cmomi w=2.67e-6 l=2.52e-6 m=1
C_LVS_CC19_58 vcn bn6 cap_cmomi w=2.67e-6 l=2.52e-6 m=1
C_LVS_CC19_59 vcn bn6 cap_cmomi w=2.67e-6 l=2.52e-6 m=1
C_LVS_CC19_60 vcn bn6 cap_cmomi w=2.67e-6 l=2.52e-6 m=1
C_LVS_CC19_61 vcn bn6 cap_cmomi w=2.67e-6 l=2.52e-6 m=1
C_LVS_CC19_62 vcn bn6 cap_cmomi w=2.67e-6 l=2.52e-6 m=1
C_LVS_CC19_63 vcn bn6 cap_cmomi w=2.67e-6 l=2.52e-6 m=1
C_LVS_CC19_64 vcn bn6 cap_cmomi w=2.67e-6 l=2.52e-6 m=1
C_LVS_CC20_1 vcn bn7 cap_cmomi w=2.67e-6 l=2.52e-6 m=1
C_LVS_CC20_2 vcn bn7 cap_cmomi w=2.67e-6 l=2.52e-6 m=1
C_LVS_CC20_3 vcn bn7 cap_cmomi w=2.67e-6 l=2.52e-6 m=1
C_LVS_CC20_4 vcn bn7 cap_cmomi w=2.67e-6 l=2.52e-6 m=1
C_LVS_CC20_5 vcn bn7 cap_cmomi w=2.67e-6 l=2.52e-6 m=1
C_LVS_CC20_6 vcn bn7 cap_cmomi w=2.67e-6 l=2.52e-6 m=1
C_LVS_CC20_7 vcn bn7 cap_cmomi w=2.67e-6 l=2.52e-6 m=1
C_LVS_CC20_8 vcn bn7 cap_cmomi w=2.67e-6 l=2.52e-6 m=1
C_LVS_CC20_9 vcn bn7 cap_cmomi w=2.67e-6 l=2.52e-6 m=1
C_LVS_CC20_10 vcn bn7 cap_cmomi w=2.67e-6 l=2.52e-6 m=1
C_LVS_CC20_11 vcn bn7 cap_cmomi w=2.67e-6 l=2.52e-6 m=1
C_LVS_CC20_12 vcn bn7 cap_cmomi w=2.67e-6 l=2.52e-6 m=1
C_LVS_CC20_13 vcn bn7 cap_cmomi w=2.67e-6 l=2.52e-6 m=1
C_LVS_CC20_14 vcn bn7 cap_cmomi w=2.67e-6 l=2.52e-6 m=1
C_LVS_CC20_15 vcn bn7 cap_cmomi w=2.67e-6 l=2.52e-6 m=1
C_LVS_CC20_16 vcn bn7 cap_cmomi w=2.67e-6 l=2.52e-6 m=1
C_LVS_CC20_17 vcn bn7 cap_cmomi w=2.67e-6 l=2.52e-6 m=1
C_LVS_CC20_18 vcn bn7 cap_cmomi w=2.67e-6 l=2.52e-6 m=1
C_LVS_CC20_19 vcn bn7 cap_cmomi w=2.67e-6 l=2.52e-6 m=1
C_LVS_CC20_20 vcn bn7 cap_cmomi w=2.67e-6 l=2.52e-6 m=1
C_LVS_CC20_21 vcn bn7 cap_cmomi w=2.67e-6 l=2.52e-6 m=1
C_LVS_CC20_22 vcn bn7 cap_cmomi w=2.67e-6 l=2.52e-6 m=1
C_LVS_CC20_23 vcn bn7 cap_cmomi w=2.67e-6 l=2.52e-6 m=1
C_LVS_CC20_24 vcn bn7 cap_cmomi w=2.67e-6 l=2.52e-6 m=1
C_LVS_CC20_25 vcn bn7 cap_cmomi w=2.67e-6 l=2.52e-6 m=1
C_LVS_CC20_26 vcn bn7 cap_cmomi w=2.67e-6 l=2.52e-6 m=1
C_LVS_CC20_27 vcn bn7 cap_cmomi w=2.67e-6 l=2.52e-6 m=1
C_LVS_CC20_28 vcn bn7 cap_cmomi w=2.67e-6 l=2.52e-6 m=1
C_LVS_CC20_29 vcn bn7 cap_cmomi w=2.67e-6 l=2.52e-6 m=1
C_LVS_CC20_30 vcn bn7 cap_cmomi w=2.67e-6 l=2.52e-6 m=1
C_LVS_CC20_31 vcn bn7 cap_cmomi w=2.67e-6 l=2.52e-6 m=1
C_LVS_CC20_32 vcn bn7 cap_cmomi w=2.67e-6 l=2.52e-6 m=1
C_LVS_CC20_33 vcn bn7 cap_cmomi w=2.67e-6 l=2.52e-6 m=1
C_LVS_CC20_34 vcn bn7 cap_cmomi w=2.67e-6 l=2.52e-6 m=1
C_LVS_CC20_35 vcn bn7 cap_cmomi w=2.67e-6 l=2.52e-6 m=1
C_LVS_CC20_36 vcn bn7 cap_cmomi w=2.67e-6 l=2.52e-6 m=1
C_LVS_CC20_37 vcn bn7 cap_cmomi w=2.67e-6 l=2.52e-6 m=1
C_LVS_CC20_38 vcn bn7 cap_cmomi w=2.67e-6 l=2.52e-6 m=1
C_LVS_CC20_39 vcn bn7 cap_cmomi w=2.67e-6 l=2.52e-6 m=1
C_LVS_CC20_40 vcn bn7 cap_cmomi w=2.67e-6 l=2.52e-6 m=1
C_LVS_CC20_41 vcn bn7 cap_cmomi w=2.67e-6 l=2.52e-6 m=1
C_LVS_CC20_42 vcn bn7 cap_cmomi w=2.67e-6 l=2.52e-6 m=1
C_LVS_CC20_43 vcn bn7 cap_cmomi w=2.67e-6 l=2.52e-6 m=1
C_LVS_CC20_44 vcn bn7 cap_cmomi w=2.67e-6 l=2.52e-6 m=1
C_LVS_CC20_45 vcn bn7 cap_cmomi w=2.67e-6 l=2.52e-6 m=1
C_LVS_CC20_46 vcn bn7 cap_cmomi w=2.67e-6 l=2.52e-6 m=1
C_LVS_CC20_47 vcn bn7 cap_cmomi w=2.67e-6 l=2.52e-6 m=1
C_LVS_CC20_48 vcn bn7 cap_cmomi w=2.67e-6 l=2.52e-6 m=1
C_LVS_CC20_49 vcn bn7 cap_cmomi w=2.67e-6 l=2.52e-6 m=1
C_LVS_CC20_50 vcn bn7 cap_cmomi w=2.67e-6 l=2.52e-6 m=1
C_LVS_CC20_51 vcn bn7 cap_cmomi w=2.67e-6 l=2.52e-6 m=1
C_LVS_CC20_52 vcn bn7 cap_cmomi w=2.67e-6 l=2.52e-6 m=1
C_LVS_CC20_53 vcn bn7 cap_cmomi w=2.67e-6 l=2.52e-6 m=1
C_LVS_CC20_54 vcn bn7 cap_cmomi w=2.67e-6 l=2.52e-6 m=1
C_LVS_CC20_55 vcn bn7 cap_cmomi w=2.67e-6 l=2.52e-6 m=1
C_LVS_CC20_56 vcn bn7 cap_cmomi w=2.67e-6 l=2.52e-6 m=1
C_LVS_CC20_57 vcn bn7 cap_cmomi w=2.67e-6 l=2.52e-6 m=1
C_LVS_CC20_58 vcn bn7 cap_cmomi w=2.67e-6 l=2.52e-6 m=1
C_LVS_CC20_59 vcn bn7 cap_cmomi w=2.67e-6 l=2.52e-6 m=1
C_LVS_CC20_60 vcn bn7 cap_cmomi w=2.67e-6 l=2.52e-6 m=1
C_LVS_CC20_61 vcn bn7 cap_cmomi w=2.67e-6 l=2.52e-6 m=1
C_LVS_CC20_62 vcn bn7 cap_cmomi w=2.67e-6 l=2.52e-6 m=1
C_LVS_CC20_63 vcn bn7 cap_cmomi w=2.67e-6 l=2.52e-6 m=1
C_LVS_CC20_64 vcn bn7 cap_cmomi w=2.67e-6 l=2.52e-6 m=1
C_LVS_CC20_65 vcn bn7 cap_cmomi w=2.67e-6 l=2.52e-6 m=1
C_LVS_CC20_66 vcn bn7 cap_cmomi w=2.67e-6 l=2.52e-6 m=1
C_LVS_CC20_67 vcn bn7 cap_cmomi w=2.67e-6 l=2.52e-6 m=1
C_LVS_CC20_68 vcn bn7 cap_cmomi w=2.67e-6 l=2.52e-6 m=1
C_LVS_CC20_69 vcn bn7 cap_cmomi w=2.67e-6 l=2.52e-6 m=1
C_LVS_CC20_70 vcn bn7 cap_cmomi w=2.67e-6 l=2.52e-6 m=1
C_LVS_CC20_71 vcn bn7 cap_cmomi w=2.67e-6 l=2.52e-6 m=1
C_LVS_CC20_72 vcn bn7 cap_cmomi w=2.67e-6 l=2.52e-6 m=1
C_LVS_CC20_73 vcn bn7 cap_cmomi w=2.67e-6 l=2.52e-6 m=1
C_LVS_CC20_74 vcn bn7 cap_cmomi w=2.67e-6 l=2.52e-6 m=1
C_LVS_CC20_75 vcn bn7 cap_cmomi w=2.67e-6 l=2.52e-6 m=1
C_LVS_CC20_76 vcn bn7 cap_cmomi w=2.67e-6 l=2.52e-6 m=1
C_LVS_CC20_77 vcn bn7 cap_cmomi w=2.67e-6 l=2.52e-6 m=1
C_LVS_CC20_78 vcn bn7 cap_cmomi w=2.67e-6 l=2.52e-6 m=1
C_LVS_CC20_79 vcn bn7 cap_cmomi w=2.67e-6 l=2.52e-6 m=1
C_LVS_CC20_80 vcn bn7 cap_cmomi w=2.67e-6 l=2.52e-6 m=1
C_LVS_CC20_81 vcn bn7 cap_cmomi w=2.67e-6 l=2.52e-6 m=1
C_LVS_CC20_82 vcn bn7 cap_cmomi w=2.67e-6 l=2.52e-6 m=1
C_LVS_CC20_83 vcn bn7 cap_cmomi w=2.67e-6 l=2.52e-6 m=1
C_LVS_CC20_84 vcn bn7 cap_cmomi w=2.67e-6 l=2.52e-6 m=1
C_LVS_CC20_85 vcn bn7 cap_cmomi w=2.67e-6 l=2.52e-6 m=1
C_LVS_CC20_86 vcn bn7 cap_cmomi w=2.67e-6 l=2.52e-6 m=1
C_LVS_CC20_87 vcn bn7 cap_cmomi w=2.67e-6 l=2.52e-6 m=1
C_LVS_CC20_88 vcn bn7 cap_cmomi w=2.67e-6 l=2.52e-6 m=1
C_LVS_CC20_89 vcn bn7 cap_cmomi w=2.67e-6 l=2.52e-6 m=1
C_LVS_CC20_90 vcn bn7 cap_cmomi w=2.67e-6 l=2.52e-6 m=1
C_LVS_CC20_91 vcn bn7 cap_cmomi w=2.67e-6 l=2.52e-6 m=1
C_LVS_CC20_92 vcn bn7 cap_cmomi w=2.67e-6 l=2.52e-6 m=1
C_LVS_CC20_93 vcn bn7 cap_cmomi w=2.67e-6 l=2.52e-6 m=1
C_LVS_CC20_94 vcn bn7 cap_cmomi w=2.67e-6 l=2.52e-6 m=1
C_LVS_CC20_95 vcn bn7 cap_cmomi w=2.67e-6 l=2.52e-6 m=1
C_LVS_CC20_96 vcn bn7 cap_cmomi w=2.67e-6 l=2.52e-6 m=1
C_LVS_CC20_97 vcn bn7 cap_cmomi w=2.67e-6 l=2.52e-6 m=1
C_LVS_CC20_98 vcn bn7 cap_cmomi w=2.67e-6 l=2.52e-6 m=1
C_LVS_CC20_99 vcn bn7 cap_cmomi w=2.67e-6 l=2.52e-6 m=1
C_LVS_CC20_100 vcn bn7 cap_cmomi w=2.67e-6 l=2.52e-6 m=1
C_LVS_CC20_101 vcn bn7 cap_cmomi w=2.67e-6 l=2.52e-6 m=1
C_LVS_CC20_102 vcn bn7 cap_cmomi w=2.67e-6 l=2.52e-6 m=1
C_LVS_CC20_103 vcn bn7 cap_cmomi w=2.67e-6 l=2.52e-6 m=1
C_LVS_CC20_104 vcn bn7 cap_cmomi w=2.67e-6 l=2.52e-6 m=1
C_LVS_CC20_105 vcn bn7 cap_cmomi w=2.67e-6 l=2.52e-6 m=1
C_LVS_CC20_106 vcn bn7 cap_cmomi w=2.67e-6 l=2.52e-6 m=1
C_LVS_CC20_107 vcn bn7 cap_cmomi w=2.67e-6 l=2.52e-6 m=1
C_LVS_CC20_108 vcn bn7 cap_cmomi w=2.67e-6 l=2.52e-6 m=1
C_LVS_CC20_109 vcn bn7 cap_cmomi w=2.67e-6 l=2.52e-6 m=1
C_LVS_CC20_110 vcn bn7 cap_cmomi w=2.67e-6 l=2.52e-6 m=1
C_LVS_CC20_111 vcn bn7 cap_cmomi w=2.67e-6 l=2.52e-6 m=1
C_LVS_CC20_112 vcn bn7 cap_cmomi w=2.67e-6 l=2.52e-6 m=1
C_LVS_CC20_113 vcn bn7 cap_cmomi w=2.67e-6 l=2.52e-6 m=1
C_LVS_CC20_114 vcn bn7 cap_cmomi w=2.67e-6 l=2.52e-6 m=1
C_LVS_CC20_115 vcn bn7 cap_cmomi w=2.67e-6 l=2.52e-6 m=1
C_LVS_CC20_116 vcn bn7 cap_cmomi w=2.67e-6 l=2.52e-6 m=1
C_LVS_CC20_117 vcn bn7 cap_cmomi w=2.67e-6 l=2.52e-6 m=1
C_LVS_CC20_118 vcn bn7 cap_cmomi w=2.67e-6 l=2.52e-6 m=1
C_LVS_CC20_119 vcn bn7 cap_cmomi w=2.67e-6 l=2.52e-6 m=1
C_LVS_CC20_120 vcn bn7 cap_cmomi w=2.67e-6 l=2.52e-6 m=1
C_LVS_CC20_121 vcn bn7 cap_cmomi w=2.67e-6 l=2.52e-6 m=1
C_LVS_CC20_122 vcn bn7 cap_cmomi w=2.67e-6 l=2.52e-6 m=1
C_LVS_CC20_123 vcn bn7 cap_cmomi w=2.67e-6 l=2.52e-6 m=1
C_LVS_CC20_124 vcn bn7 cap_cmomi w=2.67e-6 l=2.52e-6 m=1
C_LVS_CC20_125 vcn bn7 cap_cmomi w=2.67e-6 l=2.52e-6 m=1
C_LVS_CC20_126 vcn bn7 cap_cmomi w=2.67e-6 l=2.52e-6 m=1
C_LVS_CC20_127 vcn bn7 cap_cmomi w=2.67e-6 l=2.52e-6 m=1
C_LVS_CC20_128 vcn bn7 cap_cmomi w=2.67e-6 l=2.52e-6 m=1
C_LVS_CC21_1 vcn bn8 cap_cmomi w=2.67e-6 l=2.52e-6 m=1
C_LVS_CC21_2 vcn bn8 cap_cmomi w=2.67e-6 l=2.52e-6 m=1
C_LVS_CC21_3 vcn bn8 cap_cmomi w=2.67e-6 l=2.52e-6 m=1
C_LVS_CC21_4 vcn bn8 cap_cmomi w=2.67e-6 l=2.52e-6 m=1
C_LVS_CC21_5 vcn bn8 cap_cmomi w=2.67e-6 l=2.52e-6 m=1
C_LVS_CC21_6 vcn bn8 cap_cmomi w=2.67e-6 l=2.52e-6 m=1
C_LVS_CC21_7 vcn bn8 cap_cmomi w=2.67e-6 l=2.52e-6 m=1
C_LVS_CC21_8 vcn bn8 cap_cmomi w=2.67e-6 l=2.52e-6 m=1
C_LVS_CC21_9 vcn bn8 cap_cmomi w=2.67e-6 l=2.52e-6 m=1
C_LVS_CC21_10 vcn bn8 cap_cmomi w=2.67e-6 l=2.52e-6 m=1
C_LVS_CC21_11 vcn bn8 cap_cmomi w=2.67e-6 l=2.52e-6 m=1
C_LVS_CC21_12 vcn bn8 cap_cmomi w=2.67e-6 l=2.52e-6 m=1
C_LVS_CC21_13 vcn bn8 cap_cmomi w=2.67e-6 l=2.52e-6 m=1
C_LVS_CC21_14 vcn bn8 cap_cmomi w=2.67e-6 l=2.52e-6 m=1
C_LVS_CC21_15 vcn bn8 cap_cmomi w=2.67e-6 l=2.52e-6 m=1
C_LVS_CC21_16 vcn bn8 cap_cmomi w=2.67e-6 l=2.52e-6 m=1
C_LVS_CC21_17 vcn bn8 cap_cmomi w=2.67e-6 l=2.52e-6 m=1
C_LVS_CC21_18 vcn bn8 cap_cmomi w=2.67e-6 l=2.52e-6 m=1
C_LVS_CC21_19 vcn bn8 cap_cmomi w=2.67e-6 l=2.52e-6 m=1
C_LVS_CC21_20 vcn bn8 cap_cmomi w=2.67e-6 l=2.52e-6 m=1
C_LVS_CC21_21 vcn bn8 cap_cmomi w=2.67e-6 l=2.52e-6 m=1
C_LVS_CC21_22 vcn bn8 cap_cmomi w=2.67e-6 l=2.52e-6 m=1
C_LVS_CC21_23 vcn bn8 cap_cmomi w=2.67e-6 l=2.52e-6 m=1
C_LVS_CC21_24 vcn bn8 cap_cmomi w=2.67e-6 l=2.52e-6 m=1
C_LVS_CC21_25 vcn bn8 cap_cmomi w=2.67e-6 l=2.52e-6 m=1
C_LVS_CC21_26 vcn bn8 cap_cmomi w=2.67e-6 l=2.52e-6 m=1
C_LVS_CC21_27 vcn bn8 cap_cmomi w=2.67e-6 l=2.52e-6 m=1
C_LVS_CC21_28 vcn bn8 cap_cmomi w=2.67e-6 l=2.52e-6 m=1
C_LVS_CC21_29 vcn bn8 cap_cmomi w=2.67e-6 l=2.52e-6 m=1
C_LVS_CC21_30 vcn bn8 cap_cmomi w=2.67e-6 l=2.52e-6 m=1
C_LVS_CC21_31 vcn bn8 cap_cmomi w=2.67e-6 l=2.52e-6 m=1
C_LVS_CC21_32 vcn bn8 cap_cmomi w=2.67e-6 l=2.52e-6 m=1
C_LVS_CC21_33 vcn bn8 cap_cmomi w=2.67e-6 l=2.52e-6 m=1
C_LVS_CC21_34 vcn bn8 cap_cmomi w=2.67e-6 l=2.52e-6 m=1
C_LVS_CC21_35 vcn bn8 cap_cmomi w=2.67e-6 l=2.52e-6 m=1
C_LVS_CC21_36 vcn bn8 cap_cmomi w=2.67e-6 l=2.52e-6 m=1
C_LVS_CC21_37 vcn bn8 cap_cmomi w=2.67e-6 l=2.52e-6 m=1
C_LVS_CC21_38 vcn bn8 cap_cmomi w=2.67e-6 l=2.52e-6 m=1
C_LVS_CC21_39 vcn bn8 cap_cmomi w=2.67e-6 l=2.52e-6 m=1
C_LVS_CC21_40 vcn bn8 cap_cmomi w=2.67e-6 l=2.52e-6 m=1
C_LVS_CC21_41 vcn bn8 cap_cmomi w=2.67e-6 l=2.52e-6 m=1
C_LVS_CC21_42 vcn bn8 cap_cmomi w=2.67e-6 l=2.52e-6 m=1
C_LVS_CC21_43 vcn bn8 cap_cmomi w=2.67e-6 l=2.52e-6 m=1
C_LVS_CC21_44 vcn bn8 cap_cmomi w=2.67e-6 l=2.52e-6 m=1
C_LVS_CC21_45 vcn bn8 cap_cmomi w=2.67e-6 l=2.52e-6 m=1
C_LVS_CC21_46 vcn bn8 cap_cmomi w=2.67e-6 l=2.52e-6 m=1
C_LVS_CC21_47 vcn bn8 cap_cmomi w=2.67e-6 l=2.52e-6 m=1
C_LVS_CC21_48 vcn bn8 cap_cmomi w=2.67e-6 l=2.52e-6 m=1
C_LVS_CC21_49 vcn bn8 cap_cmomi w=2.67e-6 l=2.52e-6 m=1
C_LVS_CC21_50 vcn bn8 cap_cmomi w=2.67e-6 l=2.52e-6 m=1
C_LVS_CC21_51 vcn bn8 cap_cmomi w=2.67e-6 l=2.52e-6 m=1
C_LVS_CC21_52 vcn bn8 cap_cmomi w=2.67e-6 l=2.52e-6 m=1
C_LVS_CC21_53 vcn bn8 cap_cmomi w=2.67e-6 l=2.52e-6 m=1
C_LVS_CC21_54 vcn bn8 cap_cmomi w=2.67e-6 l=2.52e-6 m=1
C_LVS_CC21_55 vcn bn8 cap_cmomi w=2.67e-6 l=2.52e-6 m=1
C_LVS_CC21_56 vcn bn8 cap_cmomi w=2.67e-6 l=2.52e-6 m=1
C_LVS_CC21_57 vcn bn8 cap_cmomi w=2.67e-6 l=2.52e-6 m=1
C_LVS_CC21_58 vcn bn8 cap_cmomi w=2.67e-6 l=2.52e-6 m=1
C_LVS_CC21_59 vcn bn8 cap_cmomi w=2.67e-6 l=2.52e-6 m=1
C_LVS_CC21_60 vcn bn8 cap_cmomi w=2.67e-6 l=2.52e-6 m=1
C_LVS_CC21_61 vcn bn8 cap_cmomi w=2.67e-6 l=2.52e-6 m=1
C_LVS_CC21_62 vcn bn8 cap_cmomi w=2.67e-6 l=2.52e-6 m=1
C_LVS_CC21_63 vcn bn8 cap_cmomi w=2.67e-6 l=2.52e-6 m=1
C_LVS_CC21_64 vcn bn8 cap_cmomi w=2.67e-6 l=2.52e-6 m=1
C_LVS_CC21_65 vcn bn8 cap_cmomi w=2.67e-6 l=2.52e-6 m=1
C_LVS_CC21_66 vcn bn8 cap_cmomi w=2.67e-6 l=2.52e-6 m=1
C_LVS_CC21_67 vcn bn8 cap_cmomi w=2.67e-6 l=2.52e-6 m=1
C_LVS_CC21_68 vcn bn8 cap_cmomi w=2.67e-6 l=2.52e-6 m=1
C_LVS_CC21_69 vcn bn8 cap_cmomi w=2.67e-6 l=2.52e-6 m=1
C_LVS_CC21_70 vcn bn8 cap_cmomi w=2.67e-6 l=2.52e-6 m=1
C_LVS_CC21_71 vcn bn8 cap_cmomi w=2.67e-6 l=2.52e-6 m=1
C_LVS_CC21_72 vcn bn8 cap_cmomi w=2.67e-6 l=2.52e-6 m=1
C_LVS_CC21_73 vcn bn8 cap_cmomi w=2.67e-6 l=2.52e-6 m=1
C_LVS_CC21_74 vcn bn8 cap_cmomi w=2.67e-6 l=2.52e-6 m=1
C_LVS_CC21_75 vcn bn8 cap_cmomi w=2.67e-6 l=2.52e-6 m=1
C_LVS_CC21_76 vcn bn8 cap_cmomi w=2.67e-6 l=2.52e-6 m=1
C_LVS_CC21_77 vcn bn8 cap_cmomi w=2.67e-6 l=2.52e-6 m=1
C_LVS_CC21_78 vcn bn8 cap_cmomi w=2.67e-6 l=2.52e-6 m=1
C_LVS_CC21_79 vcn bn8 cap_cmomi w=2.67e-6 l=2.52e-6 m=1
C_LVS_CC21_80 vcn bn8 cap_cmomi w=2.67e-6 l=2.52e-6 m=1
C_LVS_CC21_81 vcn bn8 cap_cmomi w=2.67e-6 l=2.52e-6 m=1
C_LVS_CC21_82 vcn bn8 cap_cmomi w=2.67e-6 l=2.52e-6 m=1
C_LVS_CC21_83 vcn bn8 cap_cmomi w=2.67e-6 l=2.52e-6 m=1
C_LVS_CC21_84 vcn bn8 cap_cmomi w=2.67e-6 l=2.52e-6 m=1
C_LVS_CC21_85 vcn bn8 cap_cmomi w=2.67e-6 l=2.52e-6 m=1
C_LVS_CC21_86 vcn bn8 cap_cmomi w=2.67e-6 l=2.52e-6 m=1
C_LVS_CC21_87 vcn bn8 cap_cmomi w=2.67e-6 l=2.52e-6 m=1
C_LVS_CC21_88 vcn bn8 cap_cmomi w=2.67e-6 l=2.52e-6 m=1
C_LVS_CC21_89 vcn bn8 cap_cmomi w=2.67e-6 l=2.52e-6 m=1
C_LVS_CC21_90 vcn bn8 cap_cmomi w=2.67e-6 l=2.52e-6 m=1
C_LVS_CC21_91 vcn bn8 cap_cmomi w=2.67e-6 l=2.52e-6 m=1
C_LVS_CC21_92 vcn bn8 cap_cmomi w=2.67e-6 l=2.52e-6 m=1
C_LVS_CC21_93 vcn bn8 cap_cmomi w=2.67e-6 l=2.52e-6 m=1
C_LVS_CC21_94 vcn bn8 cap_cmomi w=2.67e-6 l=2.52e-6 m=1
C_LVS_CC21_95 vcn bn8 cap_cmomi w=2.67e-6 l=2.52e-6 m=1
C_LVS_CC21_96 vcn bn8 cap_cmomi w=2.67e-6 l=2.52e-6 m=1
C_LVS_CC21_97 vcn bn8 cap_cmomi w=2.67e-6 l=2.52e-6 m=1
C_LVS_CC21_98 vcn bn8 cap_cmomi w=2.67e-6 l=2.52e-6 m=1
C_LVS_CC21_99 vcn bn8 cap_cmomi w=2.67e-6 l=2.52e-6 m=1
C_LVS_CC21_100 vcn bn8 cap_cmomi w=2.67e-6 l=2.52e-6 m=1
C_LVS_CC21_101 vcn bn8 cap_cmomi w=2.67e-6 l=2.52e-6 m=1
C_LVS_CC21_102 vcn bn8 cap_cmomi w=2.67e-6 l=2.52e-6 m=1
C_LVS_CC21_103 vcn bn8 cap_cmomi w=2.67e-6 l=2.52e-6 m=1
C_LVS_CC21_104 vcn bn8 cap_cmomi w=2.67e-6 l=2.52e-6 m=1
C_LVS_CC21_105 vcn bn8 cap_cmomi w=2.67e-6 l=2.52e-6 m=1
C_LVS_CC21_106 vcn bn8 cap_cmomi w=2.67e-6 l=2.52e-6 m=1
C_LVS_CC21_107 vcn bn8 cap_cmomi w=2.67e-6 l=2.52e-6 m=1
C_LVS_CC21_108 vcn bn8 cap_cmomi w=2.67e-6 l=2.52e-6 m=1
C_LVS_CC21_109 vcn bn8 cap_cmomi w=2.67e-6 l=2.52e-6 m=1
C_LVS_CC21_110 vcn bn8 cap_cmomi w=2.67e-6 l=2.52e-6 m=1
C_LVS_CC21_111 vcn bn8 cap_cmomi w=2.67e-6 l=2.52e-6 m=1
C_LVS_CC21_112 vcn bn8 cap_cmomi w=2.67e-6 l=2.52e-6 m=1
C_LVS_CC21_113 vcn bn8 cap_cmomi w=2.67e-6 l=2.52e-6 m=1
C_LVS_CC21_114 vcn bn8 cap_cmomi w=2.67e-6 l=2.52e-6 m=1
C_LVS_CC21_115 vcn bn8 cap_cmomi w=2.67e-6 l=2.52e-6 m=1
C_LVS_CC21_116 vcn bn8 cap_cmomi w=2.67e-6 l=2.52e-6 m=1
C_LVS_CC21_117 vcn bn8 cap_cmomi w=2.67e-6 l=2.52e-6 m=1
C_LVS_CC21_118 vcn bn8 cap_cmomi w=2.67e-6 l=2.52e-6 m=1
C_LVS_CC21_119 vcn bn8 cap_cmomi w=2.67e-6 l=2.52e-6 m=1
C_LVS_CC21_120 vcn bn8 cap_cmomi w=2.67e-6 l=2.52e-6 m=1
C_LVS_CC21_121 vcn bn8 cap_cmomi w=2.67e-6 l=2.52e-6 m=1
C_LVS_CC21_122 vcn bn8 cap_cmomi w=2.67e-6 l=2.52e-6 m=1
C_LVS_CC21_123 vcn bn8 cap_cmomi w=2.67e-6 l=2.52e-6 m=1
C_LVS_CC21_124 vcn bn8 cap_cmomi w=2.67e-6 l=2.52e-6 m=1
C_LVS_CC21_125 vcn bn8 cap_cmomi w=2.67e-6 l=2.52e-6 m=1
C_LVS_CC21_126 vcn bn8 cap_cmomi w=2.67e-6 l=2.52e-6 m=1
C_LVS_CC21_127 vcn bn8 cap_cmomi w=2.67e-6 l=2.52e-6 m=1
C_LVS_CC21_128 vcn bn8 cap_cmomi w=2.67e-6 l=2.52e-6 m=1
C_LVS_CC21_129 vcn bn8 cap_cmomi w=2.67e-6 l=2.52e-6 m=1
C_LVS_CC21_130 vcn bn8 cap_cmomi w=2.67e-6 l=2.52e-6 m=1
C_LVS_CC21_131 vcn bn8 cap_cmomi w=2.67e-6 l=2.52e-6 m=1
C_LVS_CC21_132 vcn bn8 cap_cmomi w=2.67e-6 l=2.52e-6 m=1
C_LVS_CC21_133 vcn bn8 cap_cmomi w=2.67e-6 l=2.52e-6 m=1
C_LVS_CC21_134 vcn bn8 cap_cmomi w=2.67e-6 l=2.52e-6 m=1
C_LVS_CC21_135 vcn bn8 cap_cmomi w=2.67e-6 l=2.52e-6 m=1
C_LVS_CC21_136 vcn bn8 cap_cmomi w=2.67e-6 l=2.52e-6 m=1
C_LVS_CC21_137 vcn bn8 cap_cmomi w=2.67e-6 l=2.52e-6 m=1
C_LVS_CC21_138 vcn bn8 cap_cmomi w=2.67e-6 l=2.52e-6 m=1
C_LVS_CC21_139 vcn bn8 cap_cmomi w=2.67e-6 l=2.52e-6 m=1
C_LVS_CC21_140 vcn bn8 cap_cmomi w=2.67e-6 l=2.52e-6 m=1
C_LVS_CC21_141 vcn bn8 cap_cmomi w=2.67e-6 l=2.52e-6 m=1
C_LVS_CC21_142 vcn bn8 cap_cmomi w=2.67e-6 l=2.52e-6 m=1
C_LVS_CC21_143 vcn bn8 cap_cmomi w=2.67e-6 l=2.52e-6 m=1
C_LVS_CC21_144 vcn bn8 cap_cmomi w=2.67e-6 l=2.52e-6 m=1
C_LVS_CC21_145 vcn bn8 cap_cmomi w=2.67e-6 l=2.52e-6 m=1
C_LVS_CC21_146 vcn bn8 cap_cmomi w=2.67e-6 l=2.52e-6 m=1
C_LVS_CC21_147 vcn bn8 cap_cmomi w=2.67e-6 l=2.52e-6 m=1
C_LVS_CC21_148 vcn bn8 cap_cmomi w=2.67e-6 l=2.52e-6 m=1
C_LVS_CC21_149 vcn bn8 cap_cmomi w=2.67e-6 l=2.52e-6 m=1
C_LVS_CC21_150 vcn bn8 cap_cmomi w=2.67e-6 l=2.52e-6 m=1
C_LVS_CC21_151 vcn bn8 cap_cmomi w=2.67e-6 l=2.52e-6 m=1
C_LVS_CC21_152 vcn bn8 cap_cmomi w=2.67e-6 l=2.52e-6 m=1
C_LVS_CC21_153 vcn bn8 cap_cmomi w=2.67e-6 l=2.52e-6 m=1
C_LVS_CC21_154 vcn bn8 cap_cmomi w=2.67e-6 l=2.52e-6 m=1
C_LVS_CC21_155 vcn bn8 cap_cmomi w=2.67e-6 l=2.52e-6 m=1
C_LVS_CC21_156 vcn bn8 cap_cmomi w=2.67e-6 l=2.52e-6 m=1
C_LVS_CC21_157 vcn bn8 cap_cmomi w=2.67e-6 l=2.52e-6 m=1
C_LVS_CC21_158 vcn bn8 cap_cmomi w=2.67e-6 l=2.52e-6 m=1
C_LVS_CC21_159 vcn bn8 cap_cmomi w=2.67e-6 l=2.52e-6 m=1
C_LVS_CC21_160 vcn bn8 cap_cmomi w=2.67e-6 l=2.52e-6 m=1
C_LVS_CC21_161 vcn bn8 cap_cmomi w=2.67e-6 l=2.52e-6 m=1
C_LVS_CC21_162 vcn bn8 cap_cmomi w=2.67e-6 l=2.52e-6 m=1
C_LVS_CC21_163 vcn bn8 cap_cmomi w=2.67e-6 l=2.52e-6 m=1
C_LVS_CC21_164 vcn bn8 cap_cmomi w=2.67e-6 l=2.52e-6 m=1
C_LVS_CC21_165 vcn bn8 cap_cmomi w=2.67e-6 l=2.52e-6 m=1
C_LVS_CC21_166 vcn bn8 cap_cmomi w=2.67e-6 l=2.52e-6 m=1
C_LVS_CC21_167 vcn bn8 cap_cmomi w=2.67e-6 l=2.52e-6 m=1
C_LVS_CC21_168 vcn bn8 cap_cmomi w=2.67e-6 l=2.52e-6 m=1
C_LVS_CC21_169 vcn bn8 cap_cmomi w=2.67e-6 l=2.52e-6 m=1
C_LVS_CC21_170 vcn bn8 cap_cmomi w=2.67e-6 l=2.52e-6 m=1
C_LVS_CC21_171 vcn bn8 cap_cmomi w=2.67e-6 l=2.52e-6 m=1
C_LVS_CC21_172 vcn bn8 cap_cmomi w=2.67e-6 l=2.52e-6 m=1
C_LVS_CC21_173 vcn bn8 cap_cmomi w=2.67e-6 l=2.52e-6 m=1
C_LVS_CC21_174 vcn bn8 cap_cmomi w=2.67e-6 l=2.52e-6 m=1
C_LVS_CC21_175 vcn bn8 cap_cmomi w=2.67e-6 l=2.52e-6 m=1
C_LVS_CC21_176 vcn bn8 cap_cmomi w=2.67e-6 l=2.52e-6 m=1
C_LVS_CC21_177 vcn bn8 cap_cmomi w=2.67e-6 l=2.52e-6 m=1
C_LVS_CC21_178 vcn bn8 cap_cmomi w=2.67e-6 l=2.52e-6 m=1
C_LVS_CC21_179 vcn bn8 cap_cmomi w=2.67e-6 l=2.52e-6 m=1
C_LVS_CC21_180 vcn bn8 cap_cmomi w=2.67e-6 l=2.52e-6 m=1
C_LVS_CC21_181 vcn bn8 cap_cmomi w=2.67e-6 l=2.52e-6 m=1
C_LVS_CC21_182 vcn bn8 cap_cmomi w=2.67e-6 l=2.52e-6 m=1
C_LVS_CC21_183 vcn bn8 cap_cmomi w=2.67e-6 l=2.52e-6 m=1
C_LVS_CC21_184 vcn bn8 cap_cmomi w=2.67e-6 l=2.52e-6 m=1
C_LVS_CC21_185 vcn bn8 cap_cmomi w=2.67e-6 l=2.52e-6 m=1
C_LVS_CC21_186 vcn bn8 cap_cmomi w=2.67e-6 l=2.52e-6 m=1
C_LVS_CC21_187 vcn bn8 cap_cmomi w=2.67e-6 l=2.52e-6 m=1
C_LVS_CC21_188 vcn bn8 cap_cmomi w=2.67e-6 l=2.52e-6 m=1
C_LVS_CC21_189 vcn bn8 cap_cmomi w=2.67e-6 l=2.52e-6 m=1
C_LVS_CC21_190 vcn bn8 cap_cmomi w=2.67e-6 l=2.52e-6 m=1
C_LVS_CC21_191 vcn bn8 cap_cmomi w=2.67e-6 l=2.52e-6 m=1
C_LVS_CC21_192 vcn bn8 cap_cmomi w=2.67e-6 l=2.52e-6 m=1
C_LVS_CC21_193 vcn bn8 cap_cmomi w=2.67e-6 l=2.52e-6 m=1
C_LVS_CC21_194 vcn bn8 cap_cmomi w=2.67e-6 l=2.52e-6 m=1
C_LVS_CC21_195 vcn bn8 cap_cmomi w=2.67e-6 l=2.52e-6 m=1
C_LVS_CC21_196 vcn bn8 cap_cmomi w=2.67e-6 l=2.52e-6 m=1
C_LVS_CC21_197 vcn bn8 cap_cmomi w=2.67e-6 l=2.52e-6 m=1
C_LVS_CC21_198 vcn bn8 cap_cmomi w=2.67e-6 l=2.52e-6 m=1
C_LVS_CC21_199 vcn bn8 cap_cmomi w=2.67e-6 l=2.52e-6 m=1
C_LVS_CC21_200 vcn bn8 cap_cmomi w=2.67e-6 l=2.52e-6 m=1
C_LVS_CC21_201 vcn bn8 cap_cmomi w=2.67e-6 l=2.52e-6 m=1
C_LVS_CC21_202 vcn bn8 cap_cmomi w=2.67e-6 l=2.52e-6 m=1
C_LVS_CC21_203 vcn bn8 cap_cmomi w=2.67e-6 l=2.52e-6 m=1
C_LVS_CC21_204 vcn bn8 cap_cmomi w=2.67e-6 l=2.52e-6 m=1
C_LVS_CC21_205 vcn bn8 cap_cmomi w=2.67e-6 l=2.52e-6 m=1
C_LVS_CC21_206 vcn bn8 cap_cmomi w=2.67e-6 l=2.52e-6 m=1
C_LVS_CC21_207 vcn bn8 cap_cmomi w=2.67e-6 l=2.52e-6 m=1
C_LVS_CC21_208 vcn bn8 cap_cmomi w=2.67e-6 l=2.52e-6 m=1
C_LVS_CC21_209 vcn bn8 cap_cmomi w=2.67e-6 l=2.52e-6 m=1
C_LVS_CC21_210 vcn bn8 cap_cmomi w=2.67e-6 l=2.52e-6 m=1
C_LVS_CC21_211 vcn bn8 cap_cmomi w=2.67e-6 l=2.52e-6 m=1
C_LVS_CC21_212 vcn bn8 cap_cmomi w=2.67e-6 l=2.52e-6 m=1
C_LVS_CC21_213 vcn bn8 cap_cmomi w=2.67e-6 l=2.52e-6 m=1
C_LVS_CC21_214 vcn bn8 cap_cmomi w=2.67e-6 l=2.52e-6 m=1
C_LVS_CC21_215 vcn bn8 cap_cmomi w=2.67e-6 l=2.52e-6 m=1
C_LVS_CC21_216 vcn bn8 cap_cmomi w=2.67e-6 l=2.52e-6 m=1
C_LVS_CC21_217 vcn bn8 cap_cmomi w=2.67e-6 l=2.52e-6 m=1
C_LVS_CC21_218 vcn bn8 cap_cmomi w=2.67e-6 l=2.52e-6 m=1
C_LVS_CC21_219 vcn bn8 cap_cmomi w=2.67e-6 l=2.52e-6 m=1
C_LVS_CC21_220 vcn bn8 cap_cmomi w=2.67e-6 l=2.52e-6 m=1
C_LVS_CC21_221 vcn bn8 cap_cmomi w=2.67e-6 l=2.52e-6 m=1
C_LVS_CC21_222 vcn bn8 cap_cmomi w=2.67e-6 l=2.52e-6 m=1
C_LVS_CC21_223 vcn bn8 cap_cmomi w=2.67e-6 l=2.52e-6 m=1
C_LVS_CC21_224 vcn bn8 cap_cmomi w=2.67e-6 l=2.52e-6 m=1
C_LVS_CC21_225 vcn bn8 cap_cmomi w=2.67e-6 l=2.52e-6 m=1
C_LVS_CC21_226 vcn bn8 cap_cmomi w=2.67e-6 l=2.52e-6 m=1
C_LVS_CC21_227 vcn bn8 cap_cmomi w=2.67e-6 l=2.52e-6 m=1
C_LVS_CC21_228 vcn bn8 cap_cmomi w=2.67e-6 l=2.52e-6 m=1
C_LVS_CC21_229 vcn bn8 cap_cmomi w=2.67e-6 l=2.52e-6 m=1
C_LVS_CC21_230 vcn bn8 cap_cmomi w=2.67e-6 l=2.52e-6 m=1
C_LVS_CC21_231 vcn bn8 cap_cmomi w=2.67e-6 l=2.52e-6 m=1
C_LVS_CC21_232 vcn bn8 cap_cmomi w=2.67e-6 l=2.52e-6 m=1
C_LVS_CC21_233 vcn bn8 cap_cmomi w=2.67e-6 l=2.52e-6 m=1
C_LVS_CC21_234 vcn bn8 cap_cmomi w=2.67e-6 l=2.52e-6 m=1
C_LVS_CC21_235 vcn bn8 cap_cmomi w=2.67e-6 l=2.52e-6 m=1
C_LVS_CC21_236 vcn bn8 cap_cmomi w=2.67e-6 l=2.52e-6 m=1
C_LVS_CC21_237 vcn bn8 cap_cmomi w=2.67e-6 l=2.52e-6 m=1
C_LVS_CC21_238 vcn bn8 cap_cmomi w=2.67e-6 l=2.52e-6 m=1
C_LVS_CC21_239 vcn bn8 cap_cmomi w=2.67e-6 l=2.52e-6 m=1
C_LVS_CC21_240 vcn bn8 cap_cmomi w=2.67e-6 l=2.52e-6 m=1
C_LVS_CC21_241 vcn bn8 cap_cmomi w=2.67e-6 l=2.52e-6 m=1
C_LVS_CC21_242 vcn bn8 cap_cmomi w=2.67e-6 l=2.52e-6 m=1
C_LVS_CC21_243 vcn bn8 cap_cmomi w=2.67e-6 l=2.52e-6 m=1
C_LVS_CC21_244 vcn bn8 cap_cmomi w=2.67e-6 l=2.52e-6 m=1
C_LVS_CC21_245 vcn bn8 cap_cmomi w=2.67e-6 l=2.52e-6 m=1
C_LVS_CC21_246 vcn bn8 cap_cmomi w=2.67e-6 l=2.52e-6 m=1
C_LVS_CC21_247 vcn bn8 cap_cmomi w=2.67e-6 l=2.52e-6 m=1
C_LVS_CC21_248 vcn bn8 cap_cmomi w=2.67e-6 l=2.52e-6 m=1
C_LVS_CC21_249 vcn bn8 cap_cmomi w=2.67e-6 l=2.52e-6 m=1
C_LVS_CC21_250 vcn bn8 cap_cmomi w=2.67e-6 l=2.52e-6 m=1
C_LVS_CC21_251 vcn bn8 cap_cmomi w=2.67e-6 l=2.52e-6 m=1
C_LVS_CC21_252 vcn bn8 cap_cmomi w=2.67e-6 l=2.52e-6 m=1
C_LVS_CC21_253 vcn bn8 cap_cmomi w=2.67e-6 l=2.52e-6 m=1
C_LVS_CC21_254 vcn bn8 cap_cmomi w=2.67e-6 l=2.52e-6 m=1
C_LVS_CC21_255 vcn bn8 cap_cmomi w=2.67e-6 l=2.52e-6 m=1
C_LVS_CC21_256 vcn bn8 cap_cmomi w=2.67e-6 l=2.52e-6 m=1
C_LVS_CC22_1 vcn bn9 cap_cmomi w=2.67e-6 l=2.52e-6 m=1
C_LVS_CC22_2 vcn bn9 cap_cmomi w=2.67e-6 l=2.52e-6 m=1
C_LVS_CC22_3 vcn bn9 cap_cmomi w=2.67e-6 l=2.52e-6 m=1
C_LVS_CC22_4 vcn bn9 cap_cmomi w=2.67e-6 l=2.52e-6 m=1
C_LVS_CC22_5 vcn bn9 cap_cmomi w=2.67e-6 l=2.52e-6 m=1
C_LVS_CC22_6 vcn bn9 cap_cmomi w=2.67e-6 l=2.52e-6 m=1
C_LVS_CC22_7 vcn bn9 cap_cmomi w=2.67e-6 l=2.52e-6 m=1
C_LVS_CC22_8 vcn bn9 cap_cmomi w=2.67e-6 l=2.52e-6 m=1
C_LVS_CC22_9 vcn bn9 cap_cmomi w=2.67e-6 l=2.52e-6 m=1
C_LVS_CC22_10 vcn bn9 cap_cmomi w=2.67e-6 l=2.52e-6 m=1
C_LVS_CC22_11 vcn bn9 cap_cmomi w=2.67e-6 l=2.52e-6 m=1
C_LVS_CC22_12 vcn bn9 cap_cmomi w=2.67e-6 l=2.52e-6 m=1
C_LVS_CC22_13 vcn bn9 cap_cmomi w=2.67e-6 l=2.52e-6 m=1
C_LVS_CC22_14 vcn bn9 cap_cmomi w=2.67e-6 l=2.52e-6 m=1
C_LVS_CC22_15 vcn bn9 cap_cmomi w=2.67e-6 l=2.52e-6 m=1
C_LVS_CC22_16 vcn bn9 cap_cmomi w=2.67e-6 l=2.52e-6 m=1
C_LVS_CC22_17 vcn bn9 cap_cmomi w=2.67e-6 l=2.52e-6 m=1
C_LVS_CC22_18 vcn bn9 cap_cmomi w=2.67e-6 l=2.52e-6 m=1
C_LVS_CC22_19 vcn bn9 cap_cmomi w=2.67e-6 l=2.52e-6 m=1
C_LVS_CC22_20 vcn bn9 cap_cmomi w=2.67e-6 l=2.52e-6 m=1
C_LVS_CC22_21 vcn bn9 cap_cmomi w=2.67e-6 l=2.52e-6 m=1
C_LVS_CC22_22 vcn bn9 cap_cmomi w=2.67e-6 l=2.52e-6 m=1
C_LVS_CC22_23 vcn bn9 cap_cmomi w=2.67e-6 l=2.52e-6 m=1
C_LVS_CC22_24 vcn bn9 cap_cmomi w=2.67e-6 l=2.52e-6 m=1
C_LVS_CC22_25 vcn bn9 cap_cmomi w=2.67e-6 l=2.52e-6 m=1
C_LVS_CC22_26 vcn bn9 cap_cmomi w=2.67e-6 l=2.52e-6 m=1
C_LVS_CC22_27 vcn bn9 cap_cmomi w=2.67e-6 l=2.52e-6 m=1
C_LVS_CC22_28 vcn bn9 cap_cmomi w=2.67e-6 l=2.52e-6 m=1
C_LVS_CC22_29 vcn bn9 cap_cmomi w=2.67e-6 l=2.52e-6 m=1
C_LVS_CC22_30 vcn bn9 cap_cmomi w=2.67e-6 l=2.52e-6 m=1
C_LVS_CC22_31 vcn bn9 cap_cmomi w=2.67e-6 l=2.52e-6 m=1
C_LVS_CC22_32 vcn bn9 cap_cmomi w=2.67e-6 l=2.52e-6 m=1
C_LVS_CC22_33 vcn bn9 cap_cmomi w=2.67e-6 l=2.52e-6 m=1
C_LVS_CC22_34 vcn bn9 cap_cmomi w=2.67e-6 l=2.52e-6 m=1
C_LVS_CC22_35 vcn bn9 cap_cmomi w=2.67e-6 l=2.52e-6 m=1
C_LVS_CC22_36 vcn bn9 cap_cmomi w=2.67e-6 l=2.52e-6 m=1
C_LVS_CC22_37 vcn bn9 cap_cmomi w=2.67e-6 l=2.52e-6 m=1
C_LVS_CC22_38 vcn bn9 cap_cmomi w=2.67e-6 l=2.52e-6 m=1
C_LVS_CC22_39 vcn bn9 cap_cmomi w=2.67e-6 l=2.52e-6 m=1
C_LVS_CC22_40 vcn bn9 cap_cmomi w=2.67e-6 l=2.52e-6 m=1
C_LVS_CC22_41 vcn bn9 cap_cmomi w=2.67e-6 l=2.52e-6 m=1
C_LVS_CC22_42 vcn bn9 cap_cmomi w=2.67e-6 l=2.52e-6 m=1
C_LVS_CC22_43 vcn bn9 cap_cmomi w=2.67e-6 l=2.52e-6 m=1
C_LVS_CC22_44 vcn bn9 cap_cmomi w=2.67e-6 l=2.52e-6 m=1
C_LVS_CC22_45 vcn bn9 cap_cmomi w=2.67e-6 l=2.52e-6 m=1
C_LVS_CC22_46 vcn bn9 cap_cmomi w=2.67e-6 l=2.52e-6 m=1
C_LVS_CC22_47 vcn bn9 cap_cmomi w=2.67e-6 l=2.52e-6 m=1
C_LVS_CC22_48 vcn bn9 cap_cmomi w=2.67e-6 l=2.52e-6 m=1
C_LVS_CC22_49 vcn bn9 cap_cmomi w=2.67e-6 l=2.52e-6 m=1
C_LVS_CC22_50 vcn bn9 cap_cmomi w=2.67e-6 l=2.52e-6 m=1
C_LVS_CC22_51 vcn bn9 cap_cmomi w=2.67e-6 l=2.52e-6 m=1
C_LVS_CC22_52 vcn bn9 cap_cmomi w=2.67e-6 l=2.52e-6 m=1
C_LVS_CC22_53 vcn bn9 cap_cmomi w=2.67e-6 l=2.52e-6 m=1
C_LVS_CC22_54 vcn bn9 cap_cmomi w=2.67e-6 l=2.52e-6 m=1
C_LVS_CC22_55 vcn bn9 cap_cmomi w=2.67e-6 l=2.52e-6 m=1
C_LVS_CC22_56 vcn bn9 cap_cmomi w=2.67e-6 l=2.52e-6 m=1
C_LVS_CC22_57 vcn bn9 cap_cmomi w=2.67e-6 l=2.52e-6 m=1
C_LVS_CC22_58 vcn bn9 cap_cmomi w=2.67e-6 l=2.52e-6 m=1
C_LVS_CC22_59 vcn bn9 cap_cmomi w=2.67e-6 l=2.52e-6 m=1
C_LVS_CC22_60 vcn bn9 cap_cmomi w=2.67e-6 l=2.52e-6 m=1
C_LVS_CC22_61 vcn bn9 cap_cmomi w=2.67e-6 l=2.52e-6 m=1
C_LVS_CC22_62 vcn bn9 cap_cmomi w=2.67e-6 l=2.52e-6 m=1
C_LVS_CC22_63 vcn bn9 cap_cmomi w=2.67e-6 l=2.52e-6 m=1
C_LVS_CC22_64 vcn bn9 cap_cmomi w=2.67e-6 l=2.52e-6 m=1
C_LVS_CC22_65 vcn bn9 cap_cmomi w=2.67e-6 l=2.52e-6 m=1
C_LVS_CC22_66 vcn bn9 cap_cmomi w=2.67e-6 l=2.52e-6 m=1
C_LVS_CC22_67 vcn bn9 cap_cmomi w=2.67e-6 l=2.52e-6 m=1
C_LVS_CC22_68 vcn bn9 cap_cmomi w=2.67e-6 l=2.52e-6 m=1
C_LVS_CC22_69 vcn bn9 cap_cmomi w=2.67e-6 l=2.52e-6 m=1
C_LVS_CC22_70 vcn bn9 cap_cmomi w=2.67e-6 l=2.52e-6 m=1
C_LVS_CC22_71 vcn bn9 cap_cmomi w=2.67e-6 l=2.52e-6 m=1
C_LVS_CC22_72 vcn bn9 cap_cmomi w=2.67e-6 l=2.52e-6 m=1
C_LVS_CC22_73 vcn bn9 cap_cmomi w=2.67e-6 l=2.52e-6 m=1
C_LVS_CC22_74 vcn bn9 cap_cmomi w=2.67e-6 l=2.52e-6 m=1
C_LVS_CC22_75 vcn bn9 cap_cmomi w=2.67e-6 l=2.52e-6 m=1
C_LVS_CC22_76 vcn bn9 cap_cmomi w=2.67e-6 l=2.52e-6 m=1
C_LVS_CC22_77 vcn bn9 cap_cmomi w=2.67e-6 l=2.52e-6 m=1
C_LVS_CC22_78 vcn bn9 cap_cmomi w=2.67e-6 l=2.52e-6 m=1
C_LVS_CC22_79 vcn bn9 cap_cmomi w=2.67e-6 l=2.52e-6 m=1
C_LVS_CC22_80 vcn bn9 cap_cmomi w=2.67e-6 l=2.52e-6 m=1
C_LVS_CC22_81 vcn bn9 cap_cmomi w=2.67e-6 l=2.52e-6 m=1
C_LVS_CC22_82 vcn bn9 cap_cmomi w=2.67e-6 l=2.52e-6 m=1
C_LVS_CC22_83 vcn bn9 cap_cmomi w=2.67e-6 l=2.52e-6 m=1
C_LVS_CC22_84 vcn bn9 cap_cmomi w=2.67e-6 l=2.52e-6 m=1
C_LVS_CC22_85 vcn bn9 cap_cmomi w=2.67e-6 l=2.52e-6 m=1
C_LVS_CC22_86 vcn bn9 cap_cmomi w=2.67e-6 l=2.52e-6 m=1
C_LVS_CC22_87 vcn bn9 cap_cmomi w=2.67e-6 l=2.52e-6 m=1
C_LVS_CC22_88 vcn bn9 cap_cmomi w=2.67e-6 l=2.52e-6 m=1
C_LVS_CC22_89 vcn bn9 cap_cmomi w=2.67e-6 l=2.52e-6 m=1
C_LVS_CC22_90 vcn bn9 cap_cmomi w=2.67e-6 l=2.52e-6 m=1
C_LVS_CC22_91 vcn bn9 cap_cmomi w=2.67e-6 l=2.52e-6 m=1
C_LVS_CC22_92 vcn bn9 cap_cmomi w=2.67e-6 l=2.52e-6 m=1
C_LVS_CC22_93 vcn bn9 cap_cmomi w=2.67e-6 l=2.52e-6 m=1
C_LVS_CC22_94 vcn bn9 cap_cmomi w=2.67e-6 l=2.52e-6 m=1
C_LVS_CC22_95 vcn bn9 cap_cmomi w=2.67e-6 l=2.52e-6 m=1
C_LVS_CC22_96 vcn bn9 cap_cmomi w=2.67e-6 l=2.52e-6 m=1
C_LVS_CC22_97 vcn bn9 cap_cmomi w=2.67e-6 l=2.52e-6 m=1
C_LVS_CC22_98 vcn bn9 cap_cmomi w=2.67e-6 l=2.52e-6 m=1
C_LVS_CC22_99 vcn bn9 cap_cmomi w=2.67e-6 l=2.52e-6 m=1
C_LVS_CC22_100 vcn bn9 cap_cmomi w=2.67e-6 l=2.52e-6 m=1
C_LVS_CC22_101 vcn bn9 cap_cmomi w=2.67e-6 l=2.52e-6 m=1
C_LVS_CC22_102 vcn bn9 cap_cmomi w=2.67e-6 l=2.52e-6 m=1
C_LVS_CC22_103 vcn bn9 cap_cmomi w=2.67e-6 l=2.52e-6 m=1
C_LVS_CC22_104 vcn bn9 cap_cmomi w=2.67e-6 l=2.52e-6 m=1
C_LVS_CC22_105 vcn bn9 cap_cmomi w=2.67e-6 l=2.52e-6 m=1
C_LVS_CC22_106 vcn bn9 cap_cmomi w=2.67e-6 l=2.52e-6 m=1
C_LVS_CC22_107 vcn bn9 cap_cmomi w=2.67e-6 l=2.52e-6 m=1
C_LVS_CC22_108 vcn bn9 cap_cmomi w=2.67e-6 l=2.52e-6 m=1
C_LVS_CC22_109 vcn bn9 cap_cmomi w=2.67e-6 l=2.52e-6 m=1
C_LVS_CC22_110 vcn bn9 cap_cmomi w=2.67e-6 l=2.52e-6 m=1
C_LVS_CC22_111 vcn bn9 cap_cmomi w=2.67e-6 l=2.52e-6 m=1
C_LVS_CC22_112 vcn bn9 cap_cmomi w=2.67e-6 l=2.52e-6 m=1
C_LVS_CC22_113 vcn bn9 cap_cmomi w=2.67e-6 l=2.52e-6 m=1
C_LVS_CC22_114 vcn bn9 cap_cmomi w=2.67e-6 l=2.52e-6 m=1
C_LVS_CC22_115 vcn bn9 cap_cmomi w=2.67e-6 l=2.52e-6 m=1
C_LVS_CC22_116 vcn bn9 cap_cmomi w=2.67e-6 l=2.52e-6 m=1
C_LVS_CC22_117 vcn bn9 cap_cmomi w=2.67e-6 l=2.52e-6 m=1
C_LVS_CC22_118 vcn bn9 cap_cmomi w=2.67e-6 l=2.52e-6 m=1
C_LVS_CC22_119 vcn bn9 cap_cmomi w=2.67e-6 l=2.52e-6 m=1
C_LVS_CC22_120 vcn bn9 cap_cmomi w=2.67e-6 l=2.52e-6 m=1
C_LVS_CC22_121 vcn bn9 cap_cmomi w=2.67e-6 l=2.52e-6 m=1
C_LVS_CC22_122 vcn bn9 cap_cmomi w=2.67e-6 l=2.52e-6 m=1
C_LVS_CC22_123 vcn bn9 cap_cmomi w=2.67e-6 l=2.52e-6 m=1
C_LVS_CC22_124 vcn bn9 cap_cmomi w=2.67e-6 l=2.52e-6 m=1
C_LVS_CC22_125 vcn bn9 cap_cmomi w=2.67e-6 l=2.52e-6 m=1
C_LVS_CC22_126 vcn bn9 cap_cmomi w=2.67e-6 l=2.52e-6 m=1
C_LVS_CC22_127 vcn bn9 cap_cmomi w=2.67e-6 l=2.52e-6 m=1
C_LVS_CC22_128 vcn bn9 cap_cmomi w=2.67e-6 l=2.52e-6 m=1
C_LVS_CC22_129 vcn bn9 cap_cmomi w=2.67e-6 l=2.52e-6 m=1
C_LVS_CC22_130 vcn bn9 cap_cmomi w=2.67e-6 l=2.52e-6 m=1
C_LVS_CC22_131 vcn bn9 cap_cmomi w=2.67e-6 l=2.52e-6 m=1
C_LVS_CC22_132 vcn bn9 cap_cmomi w=2.67e-6 l=2.52e-6 m=1
C_LVS_CC22_133 vcn bn9 cap_cmomi w=2.67e-6 l=2.52e-6 m=1
C_LVS_CC22_134 vcn bn9 cap_cmomi w=2.67e-6 l=2.52e-6 m=1
C_LVS_CC22_135 vcn bn9 cap_cmomi w=2.67e-6 l=2.52e-6 m=1
C_LVS_CC22_136 vcn bn9 cap_cmomi w=2.67e-6 l=2.52e-6 m=1
C_LVS_CC22_137 vcn bn9 cap_cmomi w=2.67e-6 l=2.52e-6 m=1
C_LVS_CC22_138 vcn bn9 cap_cmomi w=2.67e-6 l=2.52e-6 m=1
C_LVS_CC22_139 vcn bn9 cap_cmomi w=2.67e-6 l=2.52e-6 m=1
C_LVS_CC22_140 vcn bn9 cap_cmomi w=2.67e-6 l=2.52e-6 m=1
C_LVS_CC22_141 vcn bn9 cap_cmomi w=2.67e-6 l=2.52e-6 m=1
C_LVS_CC22_142 vcn bn9 cap_cmomi w=2.67e-6 l=2.52e-6 m=1
C_LVS_CC22_143 vcn bn9 cap_cmomi w=2.67e-6 l=2.52e-6 m=1
C_LVS_CC22_144 vcn bn9 cap_cmomi w=2.67e-6 l=2.52e-6 m=1
C_LVS_CC22_145 vcn bn9 cap_cmomi w=2.67e-6 l=2.52e-6 m=1
C_LVS_CC22_146 vcn bn9 cap_cmomi w=2.67e-6 l=2.52e-6 m=1
C_LVS_CC22_147 vcn bn9 cap_cmomi w=2.67e-6 l=2.52e-6 m=1
C_LVS_CC22_148 vcn bn9 cap_cmomi w=2.67e-6 l=2.52e-6 m=1
C_LVS_CC22_149 vcn bn9 cap_cmomi w=2.67e-6 l=2.52e-6 m=1
C_LVS_CC22_150 vcn bn9 cap_cmomi w=2.67e-6 l=2.52e-6 m=1
C_LVS_CC22_151 vcn bn9 cap_cmomi w=2.67e-6 l=2.52e-6 m=1
C_LVS_CC22_152 vcn bn9 cap_cmomi w=2.67e-6 l=2.52e-6 m=1
C_LVS_CC22_153 vcn bn9 cap_cmomi w=2.67e-6 l=2.52e-6 m=1
C_LVS_CC22_154 vcn bn9 cap_cmomi w=2.67e-6 l=2.52e-6 m=1
C_LVS_CC22_155 vcn bn9 cap_cmomi w=2.67e-6 l=2.52e-6 m=1
C_LVS_CC22_156 vcn bn9 cap_cmomi w=2.67e-6 l=2.52e-6 m=1
C_LVS_CC22_157 vcn bn9 cap_cmomi w=2.67e-6 l=2.52e-6 m=1
C_LVS_CC22_158 vcn bn9 cap_cmomi w=2.67e-6 l=2.52e-6 m=1
C_LVS_CC22_159 vcn bn9 cap_cmomi w=2.67e-6 l=2.52e-6 m=1
C_LVS_CC22_160 vcn bn9 cap_cmomi w=2.67e-6 l=2.52e-6 m=1
C_LVS_CC22_161 vcn bn9 cap_cmomi w=2.67e-6 l=2.52e-6 m=1
C_LVS_CC22_162 vcn bn9 cap_cmomi w=2.67e-6 l=2.52e-6 m=1
C_LVS_CC22_163 vcn bn9 cap_cmomi w=2.67e-6 l=2.52e-6 m=1
C_LVS_CC22_164 vcn bn9 cap_cmomi w=2.67e-6 l=2.52e-6 m=1
C_LVS_CC22_165 vcn bn9 cap_cmomi w=2.67e-6 l=2.52e-6 m=1
C_LVS_CC22_166 vcn bn9 cap_cmomi w=2.67e-6 l=2.52e-6 m=1
C_LVS_CC22_167 vcn bn9 cap_cmomi w=2.67e-6 l=2.52e-6 m=1
C_LVS_CC22_168 vcn bn9 cap_cmomi w=2.67e-6 l=2.52e-6 m=1
C_LVS_CC22_169 vcn bn9 cap_cmomi w=2.67e-6 l=2.52e-6 m=1
C_LVS_CC22_170 vcn bn9 cap_cmomi w=2.67e-6 l=2.52e-6 m=1
C_LVS_CC22_171 vcn bn9 cap_cmomi w=2.67e-6 l=2.52e-6 m=1
C_LVS_CC22_172 vcn bn9 cap_cmomi w=2.67e-6 l=2.52e-6 m=1
C_LVS_CC22_173 vcn bn9 cap_cmomi w=2.67e-6 l=2.52e-6 m=1
C_LVS_CC22_174 vcn bn9 cap_cmomi w=2.67e-6 l=2.52e-6 m=1
C_LVS_CC22_175 vcn bn9 cap_cmomi w=2.67e-6 l=2.52e-6 m=1
C_LVS_CC22_176 vcn bn9 cap_cmomi w=2.67e-6 l=2.52e-6 m=1
C_LVS_CC22_177 vcn bn9 cap_cmomi w=2.67e-6 l=2.52e-6 m=1
C_LVS_CC22_178 vcn bn9 cap_cmomi w=2.67e-6 l=2.52e-6 m=1
C_LVS_CC22_179 vcn bn9 cap_cmomi w=2.67e-6 l=2.52e-6 m=1
C_LVS_CC22_180 vcn bn9 cap_cmomi w=2.67e-6 l=2.52e-6 m=1
C_LVS_CC22_181 vcn bn9 cap_cmomi w=2.67e-6 l=2.52e-6 m=1
C_LVS_CC22_182 vcn bn9 cap_cmomi w=2.67e-6 l=2.52e-6 m=1
C_LVS_CC22_183 vcn bn9 cap_cmomi w=2.67e-6 l=2.52e-6 m=1
C_LVS_CC22_184 vcn bn9 cap_cmomi w=2.67e-6 l=2.52e-6 m=1
C_LVS_CC22_185 vcn bn9 cap_cmomi w=2.67e-6 l=2.52e-6 m=1
C_LVS_CC22_186 vcn bn9 cap_cmomi w=2.67e-6 l=2.52e-6 m=1
C_LVS_CC22_187 vcn bn9 cap_cmomi w=2.67e-6 l=2.52e-6 m=1
C_LVS_CC22_188 vcn bn9 cap_cmomi w=2.67e-6 l=2.52e-6 m=1
C_LVS_CC22_189 vcn bn9 cap_cmomi w=2.67e-6 l=2.52e-6 m=1
C_LVS_CC22_190 vcn bn9 cap_cmomi w=2.67e-6 l=2.52e-6 m=1
C_LVS_CC22_191 vcn bn9 cap_cmomi w=2.67e-6 l=2.52e-6 m=1
C_LVS_CC22_192 vcn bn9 cap_cmomi w=2.67e-6 l=2.52e-6 m=1
C_LVS_CC22_193 vcn bn9 cap_cmomi w=2.67e-6 l=2.52e-6 m=1
C_LVS_CC22_194 vcn bn9 cap_cmomi w=2.67e-6 l=2.52e-6 m=1
C_LVS_CC22_195 vcn bn9 cap_cmomi w=2.67e-6 l=2.52e-6 m=1
C_LVS_CC22_196 vcn bn9 cap_cmomi w=2.67e-6 l=2.52e-6 m=1
C_LVS_CC22_197 vcn bn9 cap_cmomi w=2.67e-6 l=2.52e-6 m=1
C_LVS_CC22_198 vcn bn9 cap_cmomi w=2.67e-6 l=2.52e-6 m=1
C_LVS_CC22_199 vcn bn9 cap_cmomi w=2.67e-6 l=2.52e-6 m=1
C_LVS_CC22_200 vcn bn9 cap_cmomi w=2.67e-6 l=2.52e-6 m=1
C_LVS_CC22_201 vcn bn9 cap_cmomi w=2.67e-6 l=2.52e-6 m=1
C_LVS_CC22_202 vcn bn9 cap_cmomi w=2.67e-6 l=2.52e-6 m=1
C_LVS_CC22_203 vcn bn9 cap_cmomi w=2.67e-6 l=2.52e-6 m=1
C_LVS_CC22_204 vcn bn9 cap_cmomi w=2.67e-6 l=2.52e-6 m=1
C_LVS_CC22_205 vcn bn9 cap_cmomi w=2.67e-6 l=2.52e-6 m=1
C_LVS_CC22_206 vcn bn9 cap_cmomi w=2.67e-6 l=2.52e-6 m=1
C_LVS_CC22_207 vcn bn9 cap_cmomi w=2.67e-6 l=2.52e-6 m=1
C_LVS_CC22_208 vcn bn9 cap_cmomi w=2.67e-6 l=2.52e-6 m=1
C_LVS_CC22_209 vcn bn9 cap_cmomi w=2.67e-6 l=2.52e-6 m=1
C_LVS_CC22_210 vcn bn9 cap_cmomi w=2.67e-6 l=2.52e-6 m=1
C_LVS_CC22_211 vcn bn9 cap_cmomi w=2.67e-6 l=2.52e-6 m=1
C_LVS_CC22_212 vcn bn9 cap_cmomi w=2.67e-6 l=2.52e-6 m=1
C_LVS_CC22_213 vcn bn9 cap_cmomi w=2.67e-6 l=2.52e-6 m=1
C_LVS_CC22_214 vcn bn9 cap_cmomi w=2.67e-6 l=2.52e-6 m=1
C_LVS_CC22_215 vcn bn9 cap_cmomi w=2.67e-6 l=2.52e-6 m=1
C_LVS_CC22_216 vcn bn9 cap_cmomi w=2.67e-6 l=2.52e-6 m=1
C_LVS_CC22_217 vcn bn9 cap_cmomi w=2.67e-6 l=2.52e-6 m=1
C_LVS_CC22_218 vcn bn9 cap_cmomi w=2.67e-6 l=2.52e-6 m=1
C_LVS_CC22_219 vcn bn9 cap_cmomi w=2.67e-6 l=2.52e-6 m=1
C_LVS_CC22_220 vcn bn9 cap_cmomi w=2.67e-6 l=2.52e-6 m=1
C_LVS_CC22_221 vcn bn9 cap_cmomi w=2.67e-6 l=2.52e-6 m=1
C_LVS_CC22_222 vcn bn9 cap_cmomi w=2.67e-6 l=2.52e-6 m=1
C_LVS_CC22_223 vcn bn9 cap_cmomi w=2.67e-6 l=2.52e-6 m=1
C_LVS_CC22_224 vcn bn9 cap_cmomi w=2.67e-6 l=2.52e-6 m=1
C_LVS_CC22_225 vcn bn9 cap_cmomi w=2.67e-6 l=2.52e-6 m=1
C_LVS_CC22_226 vcn bn9 cap_cmomi w=2.67e-6 l=2.52e-6 m=1
C_LVS_CC22_227 vcn bn9 cap_cmomi w=2.67e-6 l=2.52e-6 m=1
C_LVS_CC22_228 vcn bn9 cap_cmomi w=2.67e-6 l=2.52e-6 m=1
C_LVS_CC22_229 vcn bn9 cap_cmomi w=2.67e-6 l=2.52e-6 m=1
C_LVS_CC22_230 vcn bn9 cap_cmomi w=2.67e-6 l=2.52e-6 m=1
C_LVS_CC22_231 vcn bn9 cap_cmomi w=2.67e-6 l=2.52e-6 m=1
C_LVS_CC22_232 vcn bn9 cap_cmomi w=2.67e-6 l=2.52e-6 m=1
C_LVS_CC22_233 vcn bn9 cap_cmomi w=2.67e-6 l=2.52e-6 m=1
C_LVS_CC22_234 vcn bn9 cap_cmomi w=2.67e-6 l=2.52e-6 m=1
C_LVS_CC22_235 vcn bn9 cap_cmomi w=2.67e-6 l=2.52e-6 m=1
C_LVS_CC22_236 vcn bn9 cap_cmomi w=2.67e-6 l=2.52e-6 m=1
C_LVS_CC22_237 vcn bn9 cap_cmomi w=2.67e-6 l=2.52e-6 m=1
C_LVS_CC22_238 vcn bn9 cap_cmomi w=2.67e-6 l=2.52e-6 m=1
C_LVS_CC22_239 vcn bn9 cap_cmomi w=2.67e-6 l=2.52e-6 m=1
C_LVS_CC22_240 vcn bn9 cap_cmomi w=2.67e-6 l=2.52e-6 m=1
C_LVS_CC22_241 vcn bn9 cap_cmomi w=2.67e-6 l=2.52e-6 m=1
C_LVS_CC22_242 vcn bn9 cap_cmomi w=2.67e-6 l=2.52e-6 m=1
C_LVS_CC22_243 vcn bn9 cap_cmomi w=2.67e-6 l=2.52e-6 m=1
C_LVS_CC22_244 vcn bn9 cap_cmomi w=2.67e-6 l=2.52e-6 m=1
C_LVS_CC22_245 vcn bn9 cap_cmomi w=2.67e-6 l=2.52e-6 m=1
C_LVS_CC22_246 vcn bn9 cap_cmomi w=2.67e-6 l=2.52e-6 m=1
C_LVS_CC22_247 vcn bn9 cap_cmomi w=2.67e-6 l=2.52e-6 m=1
C_LVS_CC22_248 vcn bn9 cap_cmomi w=2.67e-6 l=2.52e-6 m=1
C_LVS_CC22_249 vcn bn9 cap_cmomi w=2.67e-6 l=2.52e-6 m=1
C_LVS_CC22_250 vcn bn9 cap_cmomi w=2.67e-6 l=2.52e-6 m=1
C_LVS_CC22_251 vcn bn9 cap_cmomi w=2.67e-6 l=2.52e-6 m=1
C_LVS_CC22_252 vcn bn9 cap_cmomi w=2.67e-6 l=2.52e-6 m=1
C_LVS_CC22_253 vcn bn9 cap_cmomi w=2.67e-6 l=2.52e-6 m=1
C_LVS_CC22_254 vcn bn9 cap_cmomi w=2.67e-6 l=2.52e-6 m=1
C_LVS_CC22_255 vcn bn9 cap_cmomi w=2.67e-6 l=2.52e-6 m=1
C_LVS_CC22_256 vcn bn9 cap_cmomi w=2.67e-6 l=2.52e-6 m=1
C_LVS_CC22_257 vcn bn9 cap_cmomi w=2.67e-6 l=2.52e-6 m=1
C_LVS_CC22_258 vcn bn9 cap_cmomi w=2.67e-6 l=2.52e-6 m=1
C_LVS_CC22_259 vcn bn9 cap_cmomi w=2.67e-6 l=2.52e-6 m=1
C_LVS_CC22_260 vcn bn9 cap_cmomi w=2.67e-6 l=2.52e-6 m=1
C_LVS_CC22_261 vcn bn9 cap_cmomi w=2.67e-6 l=2.52e-6 m=1
C_LVS_CC22_262 vcn bn9 cap_cmomi w=2.67e-6 l=2.52e-6 m=1
C_LVS_CC22_263 vcn bn9 cap_cmomi w=2.67e-6 l=2.52e-6 m=1
C_LVS_CC22_264 vcn bn9 cap_cmomi w=2.67e-6 l=2.52e-6 m=1
C_LVS_CC22_265 vcn bn9 cap_cmomi w=2.67e-6 l=2.52e-6 m=1
C_LVS_CC22_266 vcn bn9 cap_cmomi w=2.67e-6 l=2.52e-6 m=1
C_LVS_CC22_267 vcn bn9 cap_cmomi w=2.67e-6 l=2.52e-6 m=1
C_LVS_CC22_268 vcn bn9 cap_cmomi w=2.67e-6 l=2.52e-6 m=1
C_LVS_CC22_269 vcn bn9 cap_cmomi w=2.67e-6 l=2.52e-6 m=1
C_LVS_CC22_270 vcn bn9 cap_cmomi w=2.67e-6 l=2.52e-6 m=1
C_LVS_CC22_271 vcn bn9 cap_cmomi w=2.67e-6 l=2.52e-6 m=1
C_LVS_CC22_272 vcn bn9 cap_cmomi w=2.67e-6 l=2.52e-6 m=1
C_LVS_CC22_273 vcn bn9 cap_cmomi w=2.67e-6 l=2.52e-6 m=1
C_LVS_CC22_274 vcn bn9 cap_cmomi w=2.67e-6 l=2.52e-6 m=1
C_LVS_CC22_275 vcn bn9 cap_cmomi w=2.67e-6 l=2.52e-6 m=1
C_LVS_CC22_276 vcn bn9 cap_cmomi w=2.67e-6 l=2.52e-6 m=1
C_LVS_CC22_277 vcn bn9 cap_cmomi w=2.67e-6 l=2.52e-6 m=1
C_LVS_CC22_278 vcn bn9 cap_cmomi w=2.67e-6 l=2.52e-6 m=1
C_LVS_CC22_279 vcn bn9 cap_cmomi w=2.67e-6 l=2.52e-6 m=1
C_LVS_CC22_280 vcn bn9 cap_cmomi w=2.67e-6 l=2.52e-6 m=1
C_LVS_CC22_281 vcn bn9 cap_cmomi w=2.67e-6 l=2.52e-6 m=1
C_LVS_CC22_282 vcn bn9 cap_cmomi w=2.67e-6 l=2.52e-6 m=1
C_LVS_CC22_283 vcn bn9 cap_cmomi w=2.67e-6 l=2.52e-6 m=1
C_LVS_CC22_284 vcn bn9 cap_cmomi w=2.67e-6 l=2.52e-6 m=1
C_LVS_CC22_285 vcn bn9 cap_cmomi w=2.67e-6 l=2.52e-6 m=1
C_LVS_CC22_286 vcn bn9 cap_cmomi w=2.67e-6 l=2.52e-6 m=1
C_LVS_CC22_287 vcn bn9 cap_cmomi w=2.67e-6 l=2.52e-6 m=1
C_LVS_CC22_288 vcn bn9 cap_cmomi w=2.67e-6 l=2.52e-6 m=1
C_LVS_CC22_289 vcn bn9 cap_cmomi w=2.67e-6 l=2.52e-6 m=1
C_LVS_CC22_290 vcn bn9 cap_cmomi w=2.67e-6 l=2.52e-6 m=1
C_LVS_CC22_291 vcn bn9 cap_cmomi w=2.67e-6 l=2.52e-6 m=1
C_LVS_CC22_292 vcn bn9 cap_cmomi w=2.67e-6 l=2.52e-6 m=1
C_LVS_CC22_293 vcn bn9 cap_cmomi w=2.67e-6 l=2.52e-6 m=1
C_LVS_CC22_294 vcn bn9 cap_cmomi w=2.67e-6 l=2.52e-6 m=1
C_LVS_CC22_295 vcn bn9 cap_cmomi w=2.67e-6 l=2.52e-6 m=1
C_LVS_CC22_296 vcn bn9 cap_cmomi w=2.67e-6 l=2.52e-6 m=1
C_LVS_CC22_297 vcn bn9 cap_cmomi w=2.67e-6 l=2.52e-6 m=1
C_LVS_CC22_298 vcn bn9 cap_cmomi w=2.67e-6 l=2.52e-6 m=1
C_LVS_CC22_299 vcn bn9 cap_cmomi w=2.67e-6 l=2.52e-6 m=1
C_LVS_CC22_300 vcn bn9 cap_cmomi w=2.67e-6 l=2.52e-6 m=1
C_LVS_CC22_301 vcn bn9 cap_cmomi w=2.67e-6 l=2.52e-6 m=1
C_LVS_CC22_302 vcn bn9 cap_cmomi w=2.67e-6 l=2.52e-6 m=1
C_LVS_CC22_303 vcn bn9 cap_cmomi w=2.67e-6 l=2.52e-6 m=1
C_LVS_CC22_304 vcn bn9 cap_cmomi w=2.67e-6 l=2.52e-6 m=1
C_LVS_CC22_305 vcn bn9 cap_cmomi w=2.67e-6 l=2.52e-6 m=1
C_LVS_CC22_306 vcn bn9 cap_cmomi w=2.67e-6 l=2.52e-6 m=1
C_LVS_CC22_307 vcn bn9 cap_cmomi w=2.67e-6 l=2.52e-6 m=1
C_LVS_CC22_308 vcn bn9 cap_cmomi w=2.67e-6 l=2.52e-6 m=1
C_LVS_CC22_309 vcn bn9 cap_cmomi w=2.67e-6 l=2.52e-6 m=1
C_LVS_CC22_310 vcn bn9 cap_cmomi w=2.67e-6 l=2.52e-6 m=1
C_LVS_CC22_311 vcn bn9 cap_cmomi w=2.67e-6 l=2.52e-6 m=1
C_LVS_CC22_312 vcn bn9 cap_cmomi w=2.67e-6 l=2.52e-6 m=1
C_LVS_CC22_313 vcn bn9 cap_cmomi w=2.67e-6 l=2.52e-6 m=1
C_LVS_CC22_314 vcn bn9 cap_cmomi w=2.67e-6 l=2.52e-6 m=1
C_LVS_CC22_315 vcn bn9 cap_cmomi w=2.67e-6 l=2.52e-6 m=1
C_LVS_CC22_316 vcn bn9 cap_cmomi w=2.67e-6 l=2.52e-6 m=1
C_LVS_CC22_317 vcn bn9 cap_cmomi w=2.67e-6 l=2.52e-6 m=1
C_LVS_CC22_318 vcn bn9 cap_cmomi w=2.67e-6 l=2.52e-6 m=1
C_LVS_CC22_319 vcn bn9 cap_cmomi w=2.67e-6 l=2.52e-6 m=1
C_LVS_CC22_320 vcn bn9 cap_cmomi w=2.67e-6 l=2.52e-6 m=1
C_LVS_CC22_321 vcn bn9 cap_cmomi w=2.67e-6 l=2.52e-6 m=1
C_LVS_CC22_322 vcn bn9 cap_cmomi w=2.67e-6 l=2.52e-6 m=1
C_LVS_CC22_323 vcn bn9 cap_cmomi w=2.67e-6 l=2.52e-6 m=1
C_LVS_CC22_324 vcn bn9 cap_cmomi w=2.67e-6 l=2.52e-6 m=1
C_LVS_CC22_325 vcn bn9 cap_cmomi w=2.67e-6 l=2.52e-6 m=1
C_LVS_CC22_326 vcn bn9 cap_cmomi w=2.67e-6 l=2.52e-6 m=1
C_LVS_CC22_327 vcn bn9 cap_cmomi w=2.67e-6 l=2.52e-6 m=1
C_LVS_CC22_328 vcn bn9 cap_cmomi w=2.67e-6 l=2.52e-6 m=1
C_LVS_CC22_329 vcn bn9 cap_cmomi w=2.67e-6 l=2.52e-6 m=1
C_LVS_CC22_330 vcn bn9 cap_cmomi w=2.67e-6 l=2.52e-6 m=1
C_LVS_CC22_331 vcn bn9 cap_cmomi w=2.67e-6 l=2.52e-6 m=1
C_LVS_CC22_332 vcn bn9 cap_cmomi w=2.67e-6 l=2.52e-6 m=1
C_LVS_CC22_333 vcn bn9 cap_cmomi w=2.67e-6 l=2.52e-6 m=1
C_LVS_CC22_334 vcn bn9 cap_cmomi w=2.67e-6 l=2.52e-6 m=1
C_LVS_CC22_335 vcn bn9 cap_cmomi w=2.67e-6 l=2.52e-6 m=1
C_LVS_CC22_336 vcn bn9 cap_cmomi w=2.67e-6 l=2.52e-6 m=1
C_LVS_CC22_337 vcn bn9 cap_cmomi w=2.67e-6 l=2.52e-6 m=1
C_LVS_CC22_338 vcn bn9 cap_cmomi w=2.67e-6 l=2.52e-6 m=1
C_LVS_CC22_339 vcn bn9 cap_cmomi w=2.67e-6 l=2.52e-6 m=1
C_LVS_CC22_340 vcn bn9 cap_cmomi w=2.67e-6 l=2.52e-6 m=1
C_LVS_CC22_341 vcn bn9 cap_cmomi w=2.67e-6 l=2.52e-6 m=1
C_LVS_CC22_342 vcn bn9 cap_cmomi w=2.67e-6 l=2.52e-6 m=1
C_LVS_CC22_343 vcn bn9 cap_cmomi w=2.67e-6 l=2.52e-6 m=1
C_LVS_CC22_344 vcn bn9 cap_cmomi w=2.67e-6 l=2.52e-6 m=1
C_LVS_CC22_345 vcn bn9 cap_cmomi w=2.67e-6 l=2.52e-6 m=1
C_LVS_CC22_346 vcn bn9 cap_cmomi w=2.67e-6 l=2.52e-6 m=1
C_LVS_CC22_347 vcn bn9 cap_cmomi w=2.67e-6 l=2.52e-6 m=1
C_LVS_CC22_348 vcn bn9 cap_cmomi w=2.67e-6 l=2.52e-6 m=1
C_LVS_CC22_349 vcn bn9 cap_cmomi w=2.67e-6 l=2.52e-6 m=1
C_LVS_CC22_350 vcn bn9 cap_cmomi w=2.67e-6 l=2.52e-6 m=1
C_LVS_CC22_351 vcn bn9 cap_cmomi w=2.67e-6 l=2.52e-6 m=1
C_LVS_CC22_352 vcn bn9 cap_cmomi w=2.67e-6 l=2.52e-6 m=1
C_LVS_CC22_353 vcn bn9 cap_cmomi w=2.67e-6 l=2.52e-6 m=1
C_LVS_CC22_354 vcn bn9 cap_cmomi w=2.67e-6 l=2.52e-6 m=1
C_LVS_CC22_355 vcn bn9 cap_cmomi w=2.67e-6 l=2.52e-6 m=1
C_LVS_CC22_356 vcn bn9 cap_cmomi w=2.67e-6 l=2.52e-6 m=1
C_LVS_CC22_357 vcn bn9 cap_cmomi w=2.67e-6 l=2.52e-6 m=1
C_LVS_CC22_358 vcn bn9 cap_cmomi w=2.67e-6 l=2.52e-6 m=1
C_LVS_CC22_359 vcn bn9 cap_cmomi w=2.67e-6 l=2.52e-6 m=1
C_LVS_CC22_360 vcn bn9 cap_cmomi w=2.67e-6 l=2.52e-6 m=1
C_LVS_CC22_361 vcn bn9 cap_cmomi w=2.67e-6 l=2.52e-6 m=1
C_LVS_CC22_362 vcn bn9 cap_cmomi w=2.67e-6 l=2.52e-6 m=1
C_LVS_CC22_363 vcn bn9 cap_cmomi w=2.67e-6 l=2.52e-6 m=1
C_LVS_CC22_364 vcn bn9 cap_cmomi w=2.67e-6 l=2.52e-6 m=1
C_LVS_CC22_365 vcn bn9 cap_cmomi w=2.67e-6 l=2.52e-6 m=1
C_LVS_CC22_366 vcn bn9 cap_cmomi w=2.67e-6 l=2.52e-6 m=1
C_LVS_CC22_367 vcn bn9 cap_cmomi w=2.67e-6 l=2.52e-6 m=1
C_LVS_CC22_368 vcn bn9 cap_cmomi w=2.67e-6 l=2.52e-6 m=1
C_LVS_CC22_369 vcn bn9 cap_cmomi w=2.67e-6 l=2.52e-6 m=1
C_LVS_CC22_370 vcn bn9 cap_cmomi w=2.67e-6 l=2.52e-6 m=1
C_LVS_CC22_371 vcn bn9 cap_cmomi w=2.67e-6 l=2.52e-6 m=1
C_LVS_CC22_372 vcn bn9 cap_cmomi w=2.67e-6 l=2.52e-6 m=1
C_LVS_CC22_373 vcn bn9 cap_cmomi w=2.67e-6 l=2.52e-6 m=1
C_LVS_CC22_374 vcn bn9 cap_cmomi w=2.67e-6 l=2.52e-6 m=1
C_LVS_CC22_375 vcn bn9 cap_cmomi w=2.67e-6 l=2.52e-6 m=1
C_LVS_CC22_376 vcn bn9 cap_cmomi w=2.67e-6 l=2.52e-6 m=1
C_LVS_CC22_377 vcn bn9 cap_cmomi w=2.67e-6 l=2.52e-6 m=1
C_LVS_CC22_378 vcn bn9 cap_cmomi w=2.67e-6 l=2.52e-6 m=1
C_LVS_CC22_379 vcn bn9 cap_cmomi w=2.67e-6 l=2.52e-6 m=1
C_LVS_CC22_380 vcn bn9 cap_cmomi w=2.67e-6 l=2.52e-6 m=1
C_LVS_CC22_381 vcn bn9 cap_cmomi w=2.67e-6 l=2.52e-6 m=1
C_LVS_CC22_382 vcn bn9 cap_cmomi w=2.67e-6 l=2.52e-6 m=1
C_LVS_CC22_383 vcn bn9 cap_cmomi w=2.67e-6 l=2.52e-6 m=1
C_LVS_CC22_384 vcn bn9 cap_cmomi w=2.67e-6 l=2.52e-6 m=1
C_LVS_CC22_385 vcn bn9 cap_cmomi w=2.67e-6 l=2.52e-6 m=1
C_LVS_CC22_386 vcn bn9 cap_cmomi w=2.67e-6 l=2.52e-6 m=1
C_LVS_CC22_387 vcn bn9 cap_cmomi w=2.67e-6 l=2.52e-6 m=1
C_LVS_CC22_388 vcn bn9 cap_cmomi w=2.67e-6 l=2.52e-6 m=1
C_LVS_CC22_389 vcn bn9 cap_cmomi w=2.67e-6 l=2.52e-6 m=1
C_LVS_CC22_390 vcn bn9 cap_cmomi w=2.67e-6 l=2.52e-6 m=1
C_LVS_CC22_391 vcn bn9 cap_cmomi w=2.67e-6 l=2.52e-6 m=1
C_LVS_CC22_392 vcn bn9 cap_cmomi w=2.67e-6 l=2.52e-6 m=1
C_LVS_CC22_393 vcn bn9 cap_cmomi w=2.67e-6 l=2.52e-6 m=1
C_LVS_CC22_394 vcn bn9 cap_cmomi w=2.67e-6 l=2.52e-6 m=1
C_LVS_CC22_395 vcn bn9 cap_cmomi w=2.67e-6 l=2.52e-6 m=1
C_LVS_CC22_396 vcn bn9 cap_cmomi w=2.67e-6 l=2.52e-6 m=1
C_LVS_CC22_397 vcn bn9 cap_cmomi w=2.67e-6 l=2.52e-6 m=1
C_LVS_CC22_398 vcn bn9 cap_cmomi w=2.67e-6 l=2.52e-6 m=1
C_LVS_CC22_399 vcn bn9 cap_cmomi w=2.67e-6 l=2.52e-6 m=1
C_LVS_CC22_400 vcn bn9 cap_cmomi w=2.67e-6 l=2.52e-6 m=1
C_LVS_CC22_401 vcn bn9 cap_cmomi w=2.67e-6 l=2.52e-6 m=1
C_LVS_CC22_402 vcn bn9 cap_cmomi w=2.67e-6 l=2.52e-6 m=1
C_LVS_CC22_403 vcn bn9 cap_cmomi w=2.67e-6 l=2.52e-6 m=1
C_LVS_CC22_404 vcn bn9 cap_cmomi w=2.67e-6 l=2.52e-6 m=1
C_LVS_CC22_405 vcn bn9 cap_cmomi w=2.67e-6 l=2.52e-6 m=1
C_LVS_CC22_406 vcn bn9 cap_cmomi w=2.67e-6 l=2.52e-6 m=1
C_LVS_CC22_407 vcn bn9 cap_cmomi w=2.67e-6 l=2.52e-6 m=1
C_LVS_CC22_408 vcn bn9 cap_cmomi w=2.67e-6 l=2.52e-6 m=1
C_LVS_CC22_409 vcn bn9 cap_cmomi w=2.67e-6 l=2.52e-6 m=1
C_LVS_CC22_410 vcn bn9 cap_cmomi w=2.67e-6 l=2.52e-6 m=1
C_LVS_CC22_411 vcn bn9 cap_cmomi w=2.67e-6 l=2.52e-6 m=1
C_LVS_CC22_412 vcn bn9 cap_cmomi w=2.67e-6 l=2.52e-6 m=1
C_LVS_CC22_413 vcn bn9 cap_cmomi w=2.67e-6 l=2.52e-6 m=1
C_LVS_CC22_414 vcn bn9 cap_cmomi w=2.67e-6 l=2.52e-6 m=1
C_LVS_CC22_415 vcn bn9 cap_cmomi w=2.67e-6 l=2.52e-6 m=1
C_LVS_CC22_416 vcn bn9 cap_cmomi w=2.67e-6 l=2.52e-6 m=1
C_LVS_CC22_417 vcn bn9 cap_cmomi w=2.67e-6 l=2.52e-6 m=1
C_LVS_CC22_418 vcn bn9 cap_cmomi w=2.67e-6 l=2.52e-6 m=1
C_LVS_CC22_419 vcn bn9 cap_cmomi w=2.67e-6 l=2.52e-6 m=1
C_LVS_CC22_420 vcn bn9 cap_cmomi w=2.67e-6 l=2.52e-6 m=1
C_LVS_CC22_421 vcn bn9 cap_cmomi w=2.67e-6 l=2.52e-6 m=1
C_LVS_CC22_422 vcn bn9 cap_cmomi w=2.67e-6 l=2.52e-6 m=1
C_LVS_CC22_423 vcn bn9 cap_cmomi w=2.67e-6 l=2.52e-6 m=1
C_LVS_CC22_424 vcn bn9 cap_cmomi w=2.67e-6 l=2.52e-6 m=1
C_LVS_CC22_425 vcn bn9 cap_cmomi w=2.67e-6 l=2.52e-6 m=1
C_LVS_CC22_426 vcn bn9 cap_cmomi w=2.67e-6 l=2.52e-6 m=1
C_LVS_CC22_427 vcn bn9 cap_cmomi w=2.67e-6 l=2.52e-6 m=1
C_LVS_CC22_428 vcn bn9 cap_cmomi w=2.67e-6 l=2.52e-6 m=1
C_LVS_CC22_429 vcn bn9 cap_cmomi w=2.67e-6 l=2.52e-6 m=1
C_LVS_CC22_430 vcn bn9 cap_cmomi w=2.67e-6 l=2.52e-6 m=1
C_LVS_CC22_431 vcn bn9 cap_cmomi w=2.67e-6 l=2.52e-6 m=1
C_LVS_CC22_432 vcn bn9 cap_cmomi w=2.67e-6 l=2.52e-6 m=1
C_LVS_CC22_433 vcn bn9 cap_cmomi w=2.67e-6 l=2.52e-6 m=1
C_LVS_CC22_434 vcn bn9 cap_cmomi w=2.67e-6 l=2.52e-6 m=1
C_LVS_CC22_435 vcn bn9 cap_cmomi w=2.67e-6 l=2.52e-6 m=1
C_LVS_CC22_436 vcn bn9 cap_cmomi w=2.67e-6 l=2.52e-6 m=1
C_LVS_CC22_437 vcn bn9 cap_cmomi w=2.67e-6 l=2.52e-6 m=1
C_LVS_CC22_438 vcn bn9 cap_cmomi w=2.67e-6 l=2.52e-6 m=1
C_LVS_CC22_439 vcn bn9 cap_cmomi w=2.67e-6 l=2.52e-6 m=1
C_LVS_CC22_440 vcn bn9 cap_cmomi w=2.67e-6 l=2.52e-6 m=1
C_LVS_CC22_441 vcn bn9 cap_cmomi w=2.67e-6 l=2.52e-6 m=1
C_LVS_CC22_442 vcn bn9 cap_cmomi w=2.67e-6 l=2.52e-6 m=1
C_LVS_CC22_443 vcn bn9 cap_cmomi w=2.67e-6 l=2.52e-6 m=1
C_LVS_CC22_444 vcn bn9 cap_cmomi w=2.67e-6 l=2.52e-6 m=1
C_LVS_CC22_445 vcn bn9 cap_cmomi w=2.67e-6 l=2.52e-6 m=1
C_LVS_CC22_446 vcn bn9 cap_cmomi w=2.67e-6 l=2.52e-6 m=1
C_LVS_CC22_447 vcn bn9 cap_cmomi w=2.67e-6 l=2.52e-6 m=1
C_LVS_CC22_448 vcn bn9 cap_cmomi w=2.67e-6 l=2.52e-6 m=1
C_LVS_CC22_449 vcn bn9 cap_cmomi w=2.67e-6 l=2.52e-6 m=1
C_LVS_CC22_450 vcn bn9 cap_cmomi w=2.67e-6 l=2.52e-6 m=1
C_LVS_CC22_451 vcn bn9 cap_cmomi w=2.67e-6 l=2.52e-6 m=1
C_LVS_CC22_452 vcn bn9 cap_cmomi w=2.67e-6 l=2.52e-6 m=1
C_LVS_CC22_453 vcn bn9 cap_cmomi w=2.67e-6 l=2.52e-6 m=1
C_LVS_CC22_454 vcn bn9 cap_cmomi w=2.67e-6 l=2.52e-6 m=1
C_LVS_CC22_455 vcn bn9 cap_cmomi w=2.67e-6 l=2.52e-6 m=1
C_LVS_CC22_456 vcn bn9 cap_cmomi w=2.67e-6 l=2.52e-6 m=1
C_LVS_CC22_457 vcn bn9 cap_cmomi w=2.67e-6 l=2.52e-6 m=1
C_LVS_CC22_458 vcn bn9 cap_cmomi w=2.67e-6 l=2.52e-6 m=1
C_LVS_CC22_459 vcn bn9 cap_cmomi w=2.67e-6 l=2.52e-6 m=1
C_LVS_CC22_460 vcn bn9 cap_cmomi w=2.67e-6 l=2.52e-6 m=1
C_LVS_CC22_461 vcn bn9 cap_cmomi w=2.67e-6 l=2.52e-6 m=1
C_LVS_CC22_462 vcn bn9 cap_cmomi w=2.67e-6 l=2.52e-6 m=1
C_LVS_CC22_463 vcn bn9 cap_cmomi w=2.67e-6 l=2.52e-6 m=1
C_LVS_CC22_464 vcn bn9 cap_cmomi w=2.67e-6 l=2.52e-6 m=1
C_LVS_CC22_465 vcn bn9 cap_cmomi w=2.67e-6 l=2.52e-6 m=1
C_LVS_CC22_466 vcn bn9 cap_cmomi w=2.67e-6 l=2.52e-6 m=1
C_LVS_CC22_467 vcn bn9 cap_cmomi w=2.67e-6 l=2.52e-6 m=1
C_LVS_CC22_468 vcn bn9 cap_cmomi w=2.67e-6 l=2.52e-6 m=1
C_LVS_CC22_469 vcn bn9 cap_cmomi w=2.67e-6 l=2.52e-6 m=1
C_LVS_CC22_470 vcn bn9 cap_cmomi w=2.67e-6 l=2.52e-6 m=1
C_LVS_CC22_471 vcn bn9 cap_cmomi w=2.67e-6 l=2.52e-6 m=1
C_LVS_CC22_472 vcn bn9 cap_cmomi w=2.67e-6 l=2.52e-6 m=1
C_LVS_CC22_473 vcn bn9 cap_cmomi w=2.67e-6 l=2.52e-6 m=1
C_LVS_CC22_474 vcn bn9 cap_cmomi w=2.67e-6 l=2.52e-6 m=1
C_LVS_CC22_475 vcn bn9 cap_cmomi w=2.67e-6 l=2.52e-6 m=1
C_LVS_CC22_476 vcn bn9 cap_cmomi w=2.67e-6 l=2.52e-6 m=1
C_LVS_CC22_477 vcn bn9 cap_cmomi w=2.67e-6 l=2.52e-6 m=1
C_LVS_CC22_478 vcn bn9 cap_cmomi w=2.67e-6 l=2.52e-6 m=1
C_LVS_CC22_479 vcn bn9 cap_cmomi w=2.67e-6 l=2.52e-6 m=1
C_LVS_CC22_480 vcn bn9 cap_cmomi w=2.67e-6 l=2.52e-6 m=1
C_LVS_CC22_481 vcn bn9 cap_cmomi w=2.67e-6 l=2.52e-6 m=1
C_LVS_CC22_482 vcn bn9 cap_cmomi w=2.67e-6 l=2.52e-6 m=1
C_LVS_CC22_483 vcn bn9 cap_cmomi w=2.67e-6 l=2.52e-6 m=1
C_LVS_CC22_484 vcn bn9 cap_cmomi w=2.67e-6 l=2.52e-6 m=1
C_LVS_CC22_485 vcn bn9 cap_cmomi w=2.67e-6 l=2.52e-6 m=1
C_LVS_CC22_486 vcn bn9 cap_cmomi w=2.67e-6 l=2.52e-6 m=1
C_LVS_CC22_487 vcn bn9 cap_cmomi w=2.67e-6 l=2.52e-6 m=1
C_LVS_CC22_488 vcn bn9 cap_cmomi w=2.67e-6 l=2.52e-6 m=1
C_LVS_CC22_489 vcn bn9 cap_cmomi w=2.67e-6 l=2.52e-6 m=1
C_LVS_CC22_490 vcn bn9 cap_cmomi w=2.67e-6 l=2.52e-6 m=1
C_LVS_CC22_491 vcn bn9 cap_cmomi w=2.67e-6 l=2.52e-6 m=1
C_LVS_CC22_492 vcn bn9 cap_cmomi w=2.67e-6 l=2.52e-6 m=1
C_LVS_CC22_493 vcn bn9 cap_cmomi w=2.67e-6 l=2.52e-6 m=1
C_LVS_CC22_494 vcn bn9 cap_cmomi w=2.67e-6 l=2.52e-6 m=1
C_LVS_CC22_495 vcn bn9 cap_cmomi w=2.67e-6 l=2.52e-6 m=1
C_LVS_CC22_496 vcn bn9 cap_cmomi w=2.67e-6 l=2.52e-6 m=1
C_LVS_CC22_497 vcn bn9 cap_cmomi w=2.67e-6 l=2.52e-6 m=1
C_LVS_CC22_498 vcn bn9 cap_cmomi w=2.67e-6 l=2.52e-6 m=1
C_LVS_CC22_499 vcn bn9 cap_cmomi w=2.67e-6 l=2.52e-6 m=1
C_LVS_CC22_500 vcn bn9 cap_cmomi w=2.67e-6 l=2.52e-6 m=1
C_LVS_CC22_501 vcn bn9 cap_cmomi w=2.67e-6 l=2.52e-6 m=1
C_LVS_CC22_502 vcn bn9 cap_cmomi w=2.67e-6 l=2.52e-6 m=1
C_LVS_CC22_503 vcn bn9 cap_cmomi w=2.67e-6 l=2.52e-6 m=1
C_LVS_CC22_504 vcn bn9 cap_cmomi w=2.67e-6 l=2.52e-6 m=1
C_LVS_CC22_505 vcn bn9 cap_cmomi w=2.67e-6 l=2.52e-6 m=1
C_LVS_CC22_506 vcn bn9 cap_cmomi w=2.67e-6 l=2.52e-6 m=1
C_LVS_CC22_507 vcn bn9 cap_cmomi w=2.67e-6 l=2.52e-6 m=1
C_LVS_CC22_508 vcn bn9 cap_cmomi w=2.67e-6 l=2.52e-6 m=1
C_LVS_CC22_509 vcn bn9 cap_cmomi w=2.67e-6 l=2.52e-6 m=1
C_LVS_CC22_510 vcn bn9 cap_cmomi w=2.67e-6 l=2.52e-6 m=1
C_LVS_CC22_511 vcn bn9 cap_cmomi w=2.67e-6 l=2.52e-6 m=1
C_LVS_CC22_512 vcn bn9 cap_cmomi w=2.67e-6 l=2.52e-6 m=1
.ends

* Auto-generated self-contained LVS reference
* IHP stdcell transistor masters + exact frozen post-P&R top connectivity
************************************************************************
*
* Copyright 2023 IHP PDK Authors
*
* Licensed under the Apache License, Version 2.0 (the "License");
* you may not use this file except in compliance with the License.
* You may obtain a copy of the License at
*
*    https://www.apache.org/licenses/LICENSE-2.0
*
* Unless required by applicable law or agreed to in writing, software
* distributed under the License is distributed on an "AS IS" BASIS,
* WITHOUT WARRANTIES OR CONDITIONS OF ANY KIND, either express or implied.
* See the License for the specific language governing permissions and
* limitations under the License.
*
************************************************************************

************************************************************************
* Library Name: sg13cmos5l_stdcell
* Cell Name:    sg13cmos5l_a21o_1
* View Name:    schematic
************************************************************************

.SUBCKT sg13cmos5l_a21o_1 X A1 A2 B1 VDD VSS
*.PININFO A1:I A2:I B1:I X:O VDD:B VSS:B
MN0 net1 A1 net2 VSS sg13_lv_nmos m=1 w=640.00n l=130.00n ng=1
MN1 net2 A2 VSS VSS sg13_lv_nmos m=1 w=640.00n l=130.00n ng=1
MN2 net1 B1 VSS VSS sg13_lv_nmos m=1 w=640.00n l=130.00n ng=1
MN3 X net1 VSS VSS sg13_lv_nmos m=1 w=740.00n l=130.00n ng=1
MP2 net1 B1 net3 VDD sg13_lv_pmos m=1 w=1.000u l=130.00n ng=1
MP0 net3 A1 VDD VDD sg13_lv_pmos m=1 w=1.000u l=130.00n ng=1
MP1 net3 A2 VDD VDD sg13_lv_pmos m=1 w=1.000u l=130.00n ng=1
MP3 X net1 VDD VDD sg13_lv_pmos m=1 w=1.12u l=130.00n ng=1
.ENDS

************************************************************************
* Library Name: sg13cmos5l_stdcell
* Cell Name:    sg13cmos5l_a21o_2
* View Name:    schematic
************************************************************************

.SUBCKT sg13cmos5l_a21o_2 X A1 A2 B1 VDD VSS
*.PININFO A1:I A2:I B1:I X:O VDD:B VSS:B
MN0 net1 A1 net2 VSS sg13_lv_nmos m=1 w=740.00n l=130.00n ng=1
MN1 net2 A2 VSS VSS sg13_lv_nmos m=1 w=740.00n l=130.00n ng=1
MN2 net1 B1 VSS VSS sg13_lv_nmos m=1 w=740.00n l=130.00n ng=1
MN3 X net1 VSS VSS sg13_lv_nmos m=1 w=1.48u l=130.00n ng=2
MP2 net1 B1 net3 VDD sg13_lv_pmos m=1 w=1.000u l=130.00n ng=1
MP0 net3 A1 VDD VDD sg13_lv_pmos m=1 w=1.000u l=130.00n ng=1
MP1 net3 A2 VDD VDD sg13_lv_pmos m=1 w=1.000u l=130.00n ng=1
MP3 X net1 VDD VDD sg13_lv_pmos m=1 w=2.24u l=130.00n ng=2
.ENDS

************************************************************************
* Library Name: sg13cmos5l_stdcell
* Cell Name:    sg13cmos5l_a21oi_1
* View Name:    schematic
************************************************************************

.SUBCKT sg13cmos5l_a21oi_1 Y A1 A2 B1 VDD VSS
*.PININFO A1:I A2:I B1:I Y:O VDD:B VSS:B
MN0 Y B1 VSS VSS sg13_lv_nmos m=1 w=740.00n l=130.00n ng=1
MN2 net1 A2 VSS VSS sg13_lv_nmos m=1 w=740.00n l=130.00n ng=1
MN1 Y A1 net1 VSS sg13_lv_nmos m=1 w=740.00n l=130.00n ng=1
MP2 Y B1 net2 VDD sg13_lv_pmos m=1 w=1.12u l=130.00n ng=1
MP1 net2 A2 VDD VDD sg13_lv_pmos m=1 w=1.12u l=130.00n ng=1
MP0 net2 A1 VDD VDD sg13_lv_pmos m=1 w=1.12u l=130.00n ng=1
.ENDS

************************************************************************
* Library Name: sg13cmos5l_stdcell
* Cell Name:    sg13cmos5l_a21oi_2
* View Name:    schematic
************************************************************************

.SUBCKT sg13cmos5l_a21oi_2 Y A1 A2 B1 VDD VSS
*.PININFO A1:I A2:I B1:I Y:O VDD:B VSS:B
MN0 Y B1 VSS VSS sg13_lv_nmos m=1 w=1.48u l=130.00n ng=2
MN2 net2 A2 VSS VSS sg13_lv_nmos m=1 w=1.48u l=130.00n ng=2
MN1 Y A1 net2 VSS sg13_lv_nmos m=1 w=1.48u l=130.00n ng=2
MP2 Y B1 net1 VDD sg13_lv_pmos m=1 w=2.24u l=130.00n ng=2
MP1 net1 A2 VDD VDD sg13_lv_pmos m=1 w=2.24u l=130.00n ng=2
MP0 net1 A1 VDD VDD sg13_lv_pmos m=1 w=2.24u l=130.00n ng=2
.ENDS

************************************************************************
* Library Name: sg13cmos5l_stdcell
* Cell Name:    sg13cmos5l_a221oi_1
* View Name:    schematic
************************************************************************

.SUBCKT sg13cmos5l_a221oi_1 Y A1 A2 B1 B2 C1 VDD VSS
*.PININFO A1:I A2:I B1:I B2:I C1:I Y:O VDD:B VSS:B
MP2 Y C1 net3 VDD sg13_lv_pmos m=1 w=1.12u l=130.00n ng=1
MP4 net3 B2 net1 VDD sg13_lv_pmos m=1 w=1.12u l=130.00n ng=1
MP1 net3 B1 net1 VDD sg13_lv_pmos m=1 w=1.12u l=130.00n ng=1
MP3 net1 A2 VDD VDD sg13_lv_pmos m=1 w=1.12u l=130.00n ng=1
MP0 net1 A1 VDD VDD sg13_lv_pmos m=1 w=1.12u l=130.00n ng=1
MN4 Y C1 VSS VSS sg13_lv_nmos m=1 w=740.00n l=130.00n ng=1
MN3 net4 B2 VSS VSS sg13_lv_nmos m=1 w=740.00n l=130.00n ng=1
MN2 Y B1 net4 VSS sg13_lv_nmos m=1 w=740.00n l=130.00n ng=1
MN1 net2 A2 VSS VSS sg13_lv_nmos m=1 w=740.00n l=130.00n ng=1
MN0 Y A1 net2 VSS sg13_lv_nmos m=1 w=740.00n l=130.00n ng=1
.ENDS

************************************************************************
* Library Name: sg13cmos5l_stdcell
* Cell Name:    sg13cmos5l_and2_1
* View Name:    schematic
************************************************************************

.SUBCKT sg13cmos5l_and2_1 X A B VDD VSS
*.PININFO A:I B:I X:O VDD:B VSS:B
MN0 net4 A net2 VSS sg13_lv_nmos m=1 w=640.00n l=130.00n ng=1
MN2 X net4 VSS VSS sg13_lv_nmos m=1 w=740.00n l=130.00n ng=1
MN1 net2 B VSS VSS sg13_lv_nmos m=1 w=640.00n l=130.00n ng=1
MP0 net4 B VDD VDD sg13_lv_pmos m=1 w=840.00n l=130.00n ng=1
MP2 X net4 VDD VDD sg13_lv_pmos m=1 w=1.12u l=130.00n ng=1
MP1 net4 A VDD VDD sg13_lv_pmos m=1 w=840.00n l=130.00n ng=1
.ENDS

************************************************************************
* Library Name: sg13cmos5l_stdcell
* Cell Name:    sg13cmos5l_and2_2
* View Name:    schematic
************************************************************************

.SUBCKT sg13cmos5l_and2_2 X A B VDD VSS
*.PININFO A:I B:I X:O VDD:B VSS:B
MN0 net1 A net2 VSS sg13_lv_nmos m=1 w=640.00n l=130.00n ng=1
MN2 X net1 VSS VSS sg13_lv_nmos m=1 w=1.48u l=130.00n ng=2
MN1 net2 B VSS VSS sg13_lv_nmos m=1 w=640.00n l=130.00n ng=1
MP0 net1 B VDD VDD sg13_lv_pmos m=1 w=840.00n l=130.00n ng=1
MP2 X net1 VDD VDD sg13_lv_pmos m=1 w=2.24u l=130.00n ng=2
MP1 net1 A VDD VDD sg13_lv_pmos m=1 w=840.00n l=130.00n ng=1
.ENDS

************************************************************************
* Library Name: sg13cmos5l_stdcell
* Cell Name:    sg13cmos5l_and3_1
* View Name:    schematic
************************************************************************

.SUBCKT sg13cmos5l_and3_1 X A B C VDD VSS
*.PININFO A:I B:I C:I X:O VDD:B VSS:B
MN2 net3 C VSS VSS sg13_lv_nmos m=1 w=640.00n l=130.00n ng=1
MN3 X net2 VSS VSS sg13_lv_nmos m=1 w=740.00n l=130.00n ng=1
MN0 net2 A net1 VSS sg13_lv_nmos m=1 w=640.00n l=130.00n ng=1
MN1 net1 B net3 VSS sg13_lv_nmos m=1 w=640.00n l=130.00n ng=1
MP3 X net2 VDD VDD sg13_lv_pmos m=1 w=1.12u l=130.00n ng=1
MP1 net2 B VDD VDD sg13_lv_pmos m=1 w=840.00n l=130.00n ng=1
MP2 net2 A VDD VDD sg13_lv_pmos m=1 w=840.00n l=130.00n ng=1
MP0 net2 C VDD VDD sg13_lv_pmos m=1 w=840.00n l=130.00n ng=1
.ENDS

************************************************************************
* Library Name: sg13cmos5l_stdcell
* Cell Name:    sg13cmos5l_and3_2
* View Name:    schematic
************************************************************************

.SUBCKT sg13cmos5l_and3_2 X A B C VDD VSS
*.PININFO A:I B:I C:I X:O VDD:B VSS:B
MN2 net3 C VSS VSS sg13_lv_nmos m=1 w=640.00n l=130.00n ng=1
MN3 X net2 VSS VSS sg13_lv_nmos m=1 w=1.48u l=130.00n ng=2
MN0 net2 A net1 VSS sg13_lv_nmos m=1 w=640.00n l=130.00n ng=1
MN1 net1 B net3 VSS sg13_lv_nmos m=1 w=640.00n l=130.00n ng=1
MP3 X net2 VDD VDD sg13_lv_pmos m=1 w=2.24u l=130.00n ng=2
MP1 net2 B VDD VDD sg13_lv_pmos m=1 w=840.00n l=130.00n ng=1
MP2 net2 A VDD VDD sg13_lv_pmos m=1 w=840.00n l=130.00n ng=1
MP0 net2 C VDD VDD sg13_lv_pmos m=1 w=840.00n l=130.00n ng=1
.ENDS

************************************************************************
* Library Name: sg13cmos5l_stdcell
* Cell Name:    sg13cmos5l_and4_1
* View Name:    schematic
************************************************************************

.SUBCKT sg13cmos5l_and4_1 X A B C D VDD VSS
*.PININFO A:I B:I C:I D:I X:O VDD:B VSS:B
MN3 net17 D VSS VSS sg13_lv_nmos m=1 w=640.00n l=130.00n ng=1
MN2 net16 C net17 VSS sg13_lv_nmos m=1 w=640.00n l=130.00n ng=1
MN1 net15 B net16 VSS sg13_lv_nmos m=1 w=640.00n l=130.00n ng=1
MN0 net1 A net15 VSS sg13_lv_nmos m=1 w=640.00n l=130.00n ng=1
MN4 X net1 VSS VSS sg13_lv_nmos m=1 w=740.00n l=130.00n ng=1
MP3 net1 A VDD VDD sg13_lv_pmos m=1 w=840.00n l=130.00n ng=1
MP4 X net1 VDD VDD sg13_lv_pmos m=1 w=1.12u l=130.00n ng=1
MP0 net1 D VDD VDD sg13_lv_pmos m=1 w=840.00n l=130.00n ng=1
MP1 net1 C VDD VDD sg13_lv_pmos m=1 w=840.00n l=130.00n ng=1
MP2 net1 B VDD VDD sg13_lv_pmos m=1 w=840.00n l=130.00n ng=1
.ENDS

************************************************************************
* Library Name: sg13cmos5l_stdcell
* Cell Name:    sg13cmos5l_and4_2
* View Name:    schematic
************************************************************************

.SUBCKT sg13cmos5l_and4_2 X A B C D VDD VSS
*.PININFO A:I B:I C:I D:I X:O VDD:B VSS:B
MN3 net17 D VSS VSS sg13_lv_nmos m=1 w=640.00n l=130.00n ng=1
MN2 net16 C net17 VSS sg13_lv_nmos m=1 w=640.00n l=130.00n ng=1
MN1 net15 B net16 VSS sg13_lv_nmos m=1 w=640.00n l=130.00n ng=1
MN0 net1 A net15 VSS sg13_lv_nmos m=1 w=640.00n l=130.00n ng=1
MN4 X net1 VSS VSS sg13_lv_nmos m=1 w=1.48u l=130.00n ng=2
MP3 net1 A VDD VDD sg13_lv_pmos m=1 w=840.00n l=130.00n ng=1
MP4 X net1 VDD VDD sg13_lv_pmos m=1 w=2.24u l=130.00n ng=2
MP0 net1 D VDD VDD sg13_lv_pmos m=1 w=840.00n l=130.00n ng=1
MP1 net1 C VDD VDD sg13_lv_pmos m=1 w=840.00n l=130.00n ng=1
MP2 net1 B VDD VDD sg13_lv_pmos m=1 w=840.00n l=130.00n ng=1
.ENDS

************************************************************************
* Library Name: sg13cmos5l_stdcell
* Cell Name:    sg13cmos5l_antennanp
* View Name:    schematic
************************************************************************

.SUBCKT sg13cmos5l_antennanp A VDD VSS
*.PININFO A:I VDD:B VSS:B
DD1 VSS A dantenna m=1 w=780n l=780n a=608.4f p=3.12u
DD0 A VDD dpantenna m=1 w=1.05u l=1.34u a=1.407p p=4.78u
.ENDS

************************************************************************
* Library Name: sg13cmos5l_stdcell
* Cell Name:    sg13cmos5l_buf_1
* View Name:    schematic
************************************************************************

.SUBCKT sg13cmos5l_buf_1 X A VDD VSS
*.PININFO A:I X:O VDD:B VSS:B
MN0 net1 A VSS VSS sg13_lv_nmos m=1 w=550.00n l=130.00n ng=1
MN1 X net1 VSS VSS sg13_lv_nmos m=1 w=740.00n l=130.00n ng=1
MP1 X net1 VDD VDD sg13_lv_pmos m=1 w=1.12u l=130.00n ng=1
MP0 net1 A VDD VDD sg13_lv_pmos m=1 w=840.00n l=130.00n ng=1
.ENDS

************************************************************************
* Library Name: sg13cmos5l_stdcell
* Cell Name:    sg13cmos5l_buf_16
* View Name:    schematic
************************************************************************

.SUBCKT sg13cmos5l_buf_16 X A VDD VSS
*.PININFO A:I X:O VDD:B VSS:B
MN0 net1 A VSS VSS sg13_lv_nmos m=1 w=4.44u l=130.00n ng=6
MN1 X net1 VSS VSS sg13_lv_nmos m=1 w=11.84u l=130.00n ng=16
MP1 X net1 VDD VDD sg13_lv_pmos m=1 w=17.92u l=130.00n ng=16
MP0 net1 A VDD VDD sg13_lv_pmos m=1 w=6.72u l=130.00n ng=6
.ENDS

************************************************************************
* Library Name: sg13cmos5l_stdcell
* Cell Name:    sg13cmos5l_buf_2
* View Name:    schematic
************************************************************************

.SUBCKT sg13cmos5l_buf_2 X A VDD VSS
*.PININFO A:I X:O VDD:B VSS:B
MN0 net1 A VSS VSS sg13_lv_nmos m=1 w=640.00n l=130.00n ng=1
MN1 X net1 VSS VSS sg13_lv_nmos m=1 w=1.48u l=130.00n ng=2
MP1 X net1 VDD VDD sg13_lv_pmos m=1 w=2.24u l=130.00n ng=2
MP0 net1 A VDD VDD sg13_lv_pmos m=1 w=1.000u l=130.00n ng=1
.ENDS

************************************************************************
* Library Name: sg13cmos5l_stdcell
* Cell Name:    sg13cmos5l_buf_4
* View Name:    schematic
************************************************************************

.SUBCKT sg13cmos5l_buf_4 X A VDD VSS
*.PININFO A:I X:O VDD:B VSS:B
MN0 net1 A VSS VSS sg13_lv_nmos m=1 w=740.00n l=130.00n ng=1
MN1 X net1 VSS VSS sg13_lv_nmos m=1 w=2.96u l=130.00n ng=4
MP1 X net1 VDD VDD sg13_lv_pmos m=1 w=4.48u l=130.00n ng=4
MP0 net1 A VDD VDD sg13_lv_pmos m=1 w=1.68u l=130.00n ng=2
.ENDS

************************************************************************
* Library Name: sg13cmos5l_stdcell
* Cell Name:    sg13cmos5l_buf_8
* View Name:    schematic
************************************************************************

.SUBCKT sg13cmos5l_buf_8 X A VDD VSS
*.PININFO A:I X:O VDD:B VSS:B
MN0 net1 A VSS VSS sg13_lv_nmos m=1 w=2.22u l=130.00n ng=3
MN1 X net1 VSS VSS sg13_lv_nmos m=1 w=5.92u l=130.00n ng=8
MP1 X net1 VDD VDD sg13_lv_pmos m=1 w=8.96u l=130.00n ng=8
MP0 net1 A VDD VDD sg13_lv_pmos m=1 w=3.36u l=130.00n ng=3
.ENDS

************************************************************************
* Library Name: sg13cmos5l_stdcell
* Cell Name:    sg13cmos5l_decap_4
* View Name:    schematic
************************************************************************

.SUBCKT sg13cmos5l_decap_4 VDD VSS
*.PININFO VDD:B VSS:B
MN0 VSS VDD VSS VSS sg13_lv_nmos m=1 w=420.00n l=1.000u ng=1
MP0 VDD VSS VDD VDD sg13_lv_pmos m=1 w=1.000u l=1.000u ng=1
.ENDS

************************************************************************
* Library Name: sg13cmos5l_stdcell
* Cell Name:    sg13cmos5l_decap_8
* View Name:    schematic
************************************************************************

.SUBCKT sg13cmos5l_decap_8 VDD VSS
*.PININFO VDD:B VSS:B
MN0 VSS VDD VSS VSS sg13_lv_nmos m=1 w=840.00n l=1.000u ng=2
MP0 VDD VSS VDD VDD sg13_lv_pmos m=1 w=2.000u l=1.000u ng=2
.ENDS

************************************************************************
* Library Name: sg13cmos5l_stdcell
* Cell Name:    sg13cmos5l_dfrbp_1
* View Name:    schematic
************************************************************************

.SUBCKT sg13cmos5l_dfrbp_1 Q Q_N CLK D RESET_B VDD VSS
*.PININFO CLK:I D:I RESET_B:I Q:O Q_N:O VDD:B VSS:B
MN11 net12 net2 VSS VSS sg13_lv_nmos m=1 w=420.00n l=130.00n ng=1
MN10 net5 clkneg net12 VSS sg13_lv_nmos m=1 w=420.00n l=130.00n ng=1
MN12 net2 net5 net11 VSS sg13_lv_nmos m=1 w=420.00n l=130.00n ng=1
MN13 net11 RESET_B VSS VSS sg13_lv_nmos m=1 w=420.00n l=130.00n ng=1
MN14 Q_N net5 VSS VSS sg13_lv_nmos m=1 w=740.00n l=130.00n ng=1
MN0 Db D net10 VSS sg13_lv_nmos m=1 w=420.00n l=130.00n ng=1
MN1 net10 RESET_B VSS VSS sg13_lv_nmos m=1 w=420.00n l=130.00n ng=1
MN4 Db clkneg net6 VSS sg13_lv_nmos m=1 w=420.00n l=130.00n ng=1
MN5 net6 clkpos net9 VSS sg13_lv_nmos m=1 w=420.00n l=130.00n ng=1
MN6 net9 net4 net8 VSS sg13_lv_nmos m=1 w=420.00n l=130.00n ng=1
MN7 net8 RESET_B VSS VSS sg13_lv_nmos m=1 w=420.00n l=130.00n ng=1
MN8 net4 net6 VSS VSS sg13_lv_nmos m=1 w=740.00n l=130.00n ng=1
MN2 clkneg CLK VSS VSS sg13_lv_nmos m=1 w=740.00n l=130.00n ng=1
MN9 net4 clkpos net5 VSS sg13_lv_nmos m=1 w=740.00n l=130.00n ng=1
MN3 clkpos clkneg VSS VSS sg13_lv_nmos m=1 w=740.00n l=130.00n ng=1
MN16 Q net1 VSS VSS sg13_lv_nmos m=1 w=740.00n l=130.00n ng=1
MN15 net1 net5 VSS VSS sg13_lv_nmos m=1 w=740.00n l=130.00n ng=1
MP11 net5 clkpos net3 VDD sg13_lv_pmos m=1 w=420.00n l=130.00n ng=1
MP12 net2 net5 VDD VDD sg13_lv_pmos m=1 w=420.00n l=130.00n ng=1
MP13 net2 RESET_B VDD VDD sg13_lv_pmos m=1 w=420.00n l=130.00n ng=1
MP14 Q_N net5 VDD VDD sg13_lv_pmos m=1 w=1.12u l=130.00n ng=1
MP4 Db clkpos net6 VDD sg13_lv_pmos m=1 w=420.00n l=130.00n ng=1
MP0 Db RESET_B VDD VDD sg13_lv_pmos m=1 w=420.00n l=130.00n ng=1
MP1 Db D VDD VDD sg13_lv_pmos m=1 w=420.00n l=130.00n ng=1
MP5 net7 net4 VDD VDD sg13_lv_pmos m=1 w=420.00n l=130.00n ng=1
MP6 net6 clkneg net7 VDD sg13_lv_pmos m=1 w=420.00n l=130.00n ng=1
MP7 net6 RESET_B VDD VDD sg13_lv_pmos m=1 w=420.00n l=130.00n ng=1
MP2 clkneg CLK VDD VDD sg13_lv_pmos m=1 w=1.12u l=130.00n ng=1
MP3 clkpos clkneg VDD VDD sg13_lv_pmos m=1 w=1.12u l=130.00n ng=1
MP8 net4 net6 VDD VDD sg13_lv_pmos m=1 w=1.000u l=130.00n ng=1
MP9 net4 clkneg net5 VDD sg13_lv_pmos m=1 w=1.000u l=130.00n ng=1
MP16 Q net1 VDD VDD sg13_lv_pmos m=1 w=1.12u l=130.00n ng=1
MP10 net3 net2 VDD VDD sg13_lv_pmos m=1 w=420.00n l=130.00n ng=1
MP15 net1 net5 VDD VDD sg13_lv_pmos m=1 w=1.12u l=130.00n ng=1
.ENDS

************************************************************************
* Library Name: sg13cmos5l_stdcell
* Cell Name:    sg13cmos5l_dfrbp_2
* View Name:    schematic
************************************************************************

.SUBCKT sg13cmos5l_dfrbp_2 Q Q_N CLK D RESET_B VDD VSS
*.PININFO CLK:I D:I RESET_B:I Q:O Q_N:O VDD:B VSS:B
MN11 net12 net2 VSS VSS sg13_lv_nmos m=1 w=420.00n l=130.00n ng=1
MN10 net5 clkneg net12 VSS sg13_lv_nmos m=1 w=420.00n l=130.00n ng=1
MN12 net2 net5 net11 VSS sg13_lv_nmos m=1 w=420.00n l=130.00n ng=1
MN13 net11 RESET_B VSS VSS sg13_lv_nmos m=1 w=420.00n l=130.00n ng=1
MN14 Q_N net5 VSS VSS sg13_lv_nmos m=1 w=1.48u l=130.00n ng=2
MN0 Db D net10 VSS sg13_lv_nmos m=1 w=420.00n l=130.00n ng=1
MN1 net10 RESET_B VSS VSS sg13_lv_nmos m=1 w=420.00n l=130.00n ng=1
MN4 Db clkneg net6 VSS sg13_lv_nmos m=1 w=420.00n l=130.00n ng=1
MN5 net6 clkpos net9 VSS sg13_lv_nmos m=1 w=420.00n l=130.00n ng=1
MN6 net9 net4 net8 VSS sg13_lv_nmos m=1 w=420.00n l=130.00n ng=1
MN7 net8 RESET_B VSS VSS sg13_lv_nmos m=1 w=420.00n l=130.00n ng=1
MN8 net4 net6 VSS VSS sg13_lv_nmos m=1 w=740.00n l=130.00n ng=1
MN2 clkneg CLK VSS VSS sg13_lv_nmos m=1 w=740.00n l=130.00n ng=1
MN9 net4 clkpos net5 VSS sg13_lv_nmos m=1 w=740.00n l=130.00n ng=1
MN3 clkpos clkneg VSS VSS sg13_lv_nmos m=1 w=740.00n l=130.00n ng=1
MN16 Q net1 VSS VSS sg13_lv_nmos m=1 w=1.48u l=130.00n ng=2
MN15 net1 net5 VSS VSS sg13_lv_nmos m=1 w=640.00n l=130.00n ng=1
MP11 net5 clkpos net3 VDD sg13_lv_pmos m=1 w=420.00n l=130.00n ng=1
MP12 net2 net5 VDD VDD sg13_lv_pmos m=1 w=420.00n l=130.00n ng=1
MP13 net2 RESET_B VDD VDD sg13_lv_pmos m=1 w=420.00n l=130.00n ng=1
MP14 Q_N net5 VDD VDD sg13_lv_pmos m=1 w=2.24u l=130.00n ng=2
MP4 Db clkpos net6 VDD sg13_lv_pmos m=1 w=420.00n l=130.00n ng=1
MP0 Db RESET_B VDD VDD sg13_lv_pmos m=1 w=420.00n l=130.00n ng=1
MP1 Db D VDD VDD sg13_lv_pmos m=1 w=420.00n l=130.00n ng=1
MP5 net7 net4 VDD VDD sg13_lv_pmos m=1 w=420.00n l=130.00n ng=1
MP6 net6 clkneg net7 VDD sg13_lv_pmos m=1 w=420.00n l=130.00n ng=1
MP7 net6 RESET_B VDD VDD sg13_lv_pmos m=1 w=420.00n l=130.00n ng=1
MP2 clkneg CLK VDD VDD sg13_lv_pmos m=1 w=1.12u l=130.00n ng=1
MP3 clkpos clkneg VDD VDD sg13_lv_pmos m=1 w=1.12u l=130.00n ng=1
MP8 net4 net6 VDD VDD sg13_lv_pmos m=1 w=1.000u l=130.00n ng=1
MP9 net4 clkneg net5 VDD sg13_lv_pmos m=1 w=1.000u l=130.00n ng=1
MP16 Q net1 VDD VDD sg13_lv_pmos m=1 w=2.24u l=130.00n ng=2
MP10 net3 net2 VDD VDD sg13_lv_pmos m=1 w=420.00n l=130.00n ng=1
MP15 net1 net5 VDD VDD sg13_lv_pmos m=1 w=1.000u l=130.00n ng=1
.ENDS

************************************************************************
* Library Name: sg13cmos5l_stdcell
* Cell Name:    sg13cmos5l_dlhq_1
* View Name:    schematic
************************************************************************

.SUBCKT sg13cmos5l_dlhq_1 Q D GATE VDD VSS
*.PININFO D:I GATE:I Q:O VDD:B VSS:B
MP8 Q qint_b VDD VDD sg13_lv_pmos m=1 w=1.12u l=130.00n ng=1
MP6 qint GATE_BB net8 VDD sg13_lv_pmos m=1 w=420.00n l=130.00n ng=1
MP7 qint_b qint VDD VDD sg13_lv_pmos m=1 w=1.12u l=130.00n ng=1
MP2 Db D VDD VDD sg13_lv_pmos m=1 w=840.00n l=130.00n ng=1
MP0 GATE_B GATE VDD VDD sg13_lv_pmos m=1 w=840.00n l=130.00n ng=1
MP1 GATE_BB GATE_B VDD VDD sg13_lv_pmos m=1 w=840.00n l=130.00n ng=1
MP5 net8 qint_b VDD VDD sg13_lv_pmos m=1 w=420.00n l=130.00n ng=1
MP4 net4 GATE_B qint VDD sg13_lv_pmos m=1 w=1.000u l=130.00n ng=1
MP3 net4 Db VDD VDD sg13_lv_pmos m=1 w=1.000u l=130.00n ng=1
MN0 GATE_B GATE VSS VSS sg13_lv_nmos m=1 w=740.00n l=130.00n ng=1
MN1 GATE_BB GATE_B VSS VSS sg13_lv_nmos m=1 w=740.00n l=130.00n ng=1
MN5 qint GATE_B net9 VSS sg13_lv_nmos m=1 w=420.00n l=130.00n ng=1
MN8 Q qint_b VSS VSS sg13_lv_nmos m=1 w=740.00n l=130.00n ng=1
MN4 net7 Db VSS VSS sg13_lv_nmos m=1 w=740.00n l=130.00n ng=1
MN6 net9 qint_b VSS VSS sg13_lv_nmos m=1 w=420.00n l=130.00n ng=1
MN7 qint_b qint VSS VSS sg13_lv_nmos m=1 w=740.00n l=130.00n ng=1
MN3 qint GATE_BB net7 VSS sg13_lv_nmos m=1 w=740.00n l=130.00n ng=1
MN2 Db D VSS VSS sg13_lv_nmos m=1 w=550.00n l=130.00n ng=1
.ENDS

************************************************************************
* Library Name: sg13cmos5l_stdcell
* Cell Name:    sg13cmos5l_dlhr_1
* View Name:    schematic
************************************************************************

.SUBCKT sg13cmos5l_dlhr_1 Q Q_N D GATE RESET_B VDD VSS
*.PININFO D:I GATE:I RESET_B:I Q:O Q_N:O VDD:B VSS:B
MP8 qint_b RESET_B VDD VDD sg13_lv_pmos m=1 w=1.12u l=130.00n ng=1
MP9 Q qint_b VDD VDD sg13_lv_pmos m=1 w=1.12u l=130.00n ng=1
MP6 qint GATE_BB net11 VDD sg13_lv_pmos m=1 w=420.00n l=130.00n ng=1
MP5 net11 qint_b VDD VDD sg13_lv_pmos m=1 w=420.00n l=130.00n ng=1
MP4 qint GATE_B net2 VDD sg13_lv_pmos m=1 w=1.000u l=130.00n ng=1
MP3 net2 Db VDD VDD sg13_lv_pmos m=1 w=1.000u l=130.00n ng=1
MP2 Db D VDD VDD sg13_lv_pmos m=1 w=840.00n l=130.00n ng=1
MP0 GATE_B GATE VDD VDD sg13_lv_pmos m=1 w=840.00n l=130.00n ng=1
MP11 Q_N qintn_b VDD VDD sg13_lv_pmos m=1 w=1.12u l=130.00n ng=1
MP7 qint_b qint VDD VDD sg13_lv_pmos m=1 w=1.12u l=130.00n ng=1
MP1 GATE_BB GATE_B VDD VDD sg13_lv_pmos m=1 w=840.00n l=130.00n ng=1
MP10 qintn_b qint_b VDD VDD sg13_lv_pmos m=1 w=840.00n l=130.00n ng=1
MN7 qint_b qint net9 VSS sg13_lv_nmos m=1 w=740.00n l=130.00n ng=1
MN8 net9 RESET_B VSS VSS sg13_lv_nmos m=1 w=740.00n l=130.00n ng=1
MN5 qint GATE_B net7 VSS sg13_lv_nmos m=1 w=420.00n l=130.00n ng=1
MN6 net7 qint_b VSS VSS sg13_lv_nmos m=1 w=420.00n l=130.00n ng=1
MN9 Q qint_b VSS VSS sg13_lv_nmos m=1 w=740.00n l=130.00n ng=1
MN3 qint GATE_BB net1 VSS sg13_lv_nmos m=1 w=640.00n l=130.00n ng=1
MN4 net1 Db VSS VSS sg13_lv_nmos m=1 w=640.00n l=130.00n ng=1
MN2 Db D VSS VSS sg13_lv_nmos m=1 w=550.00n l=130.00n ng=1
MN0 GATE_B GATE VSS VSS sg13_lv_nmos m=1 w=740.00n l=130.00n ng=1
MN11 Q_N qintn_b VSS VSS sg13_lv_nmos m=1 w=740.00n l=130.00n ng=1
MN1 GATE_BB GATE_B VSS VSS sg13_lv_nmos m=1 w=740.00n l=130.00n ng=1
MN10 qintn_b qint_b VSS VSS sg13_lv_nmos m=1 w=550.00n l=130.00n ng=1
.ENDS

************************************************************************
* Library Name: sg13cmos5l_stdcell
* Cell Name:    sg13cmos5l_dlhrq_1
* View Name:    schematic
************************************************************************

.SUBCKT sg13cmos5l_dlhrq_1 Q D GATE RESET_B VDD VSS
*.PININFO D:I GATE:I RESET_B:I Q:O VDD:B VSS:B
MN8 net116 RESET_B VSS VSS sg13_lv_nmos m=1 w=740.00n l=130.00n ng=1
MN9 Q qint_b VSS VSS sg13_lv_nmos m=1 w=740.00n l=130.00n ng=1
MN1 GATE_BB GATE_B VSS VSS sg13_lv_nmos m=1 w=740.00n l=130.00n ng=1
MN5 qint GATE_B net89 VSS sg13_lv_nmos m=1 w=420.00n l=130.00n ng=1
MN7 qint_b qint net116 VSS sg13_lv_nmos m=1 w=740.00n l=130.00n ng=1
MN2 Db D VSS VSS sg13_lv_nmos m=1 w=550.00n l=130.00n ng=1
MN4 net61 Db VSS VSS sg13_lv_nmos m=1 w=640.00n l=130.00n ng=1
MN3 qint GATE_BB net61 VSS sg13_lv_nmos m=1 w=640.00n l=130.00n ng=1
MN6 net89 qint_b VSS VSS sg13_lv_nmos m=1 w=420.00n l=130.00n ng=1
MN0 GATE_B GATE VSS VSS sg13_lv_nmos m=1 w=740.00n l=130.00n ng=1
MP3 net60 Db VDD VDD sg13_lv_pmos m=1 w=1.000u l=130.00n ng=1
MP8 qint_b RESET_B VDD VDD sg13_lv_pmos m=1 w=1.000u l=130.00n ng=1
MP6 qint GATE_BB net92 VDD sg13_lv_pmos m=1 w=420.00n l=130.00n ng=1
MP9 Q qint_b VDD VDD sg13_lv_pmos m=1 w=1.12u l=130.00n ng=1
MP5 net92 qint_b VDD VDD sg13_lv_pmos m=1 w=420.00n l=130.00n ng=1
MP0 GATE_B GATE VDD VDD sg13_lv_pmos m=1 w=840.00n l=130.00n ng=1
MP2 Db D VDD VDD sg13_lv_pmos m=1 w=840.00n l=130.00n ng=1
MP4 qint GATE_B net60 VDD sg13_lv_pmos m=1 w=1.000u l=130.00n ng=1
MP1 GATE_BB GATE_B VDD VDD sg13_lv_pmos m=1 w=840.00n l=130.00n ng=1
MP7 qint_b qint VDD VDD sg13_lv_pmos m=1 w=1.000u l=130.00n ng=1
.ENDS

************************************************************************
* Library Name: sg13cmos5l_stdcell
* Cell Name:    sg13cmos5l_dllr_1
* View Name:    schematic
************************************************************************

.SUBCKT sg13cmos5l_dllr_1 Q Q_N D GATE_N RESET_B VDD VSS
*.PININFO D:I GATE_N:I RESET_B:I Q:O Q_N:O VDD:B VSS:B
MN2 Db D VSS VSS sg13_lv_nmos m=1 w=550.00n l=130.00n ng=1
MN0 gnb GATE_N VSS VSS sg13_lv_nmos m=1 w=740.00n l=130.00n ng=1
MN1 gnbb gnb VSS VSS sg13_lv_nmos m=1 w=740.00n l=130.00n ng=1
MN6 net89 qint_b VSS VSS sg13_lv_nmos m=1 w=420.00n l=130.00n ng=1
MN7 qint_b qint net116 VSS sg13_lv_nmos m=1 w=740.00n l=130.00n ng=1
MN8 net116 RESET_B VSS VSS sg13_lv_nmos m=1 w=740.00n l=130.00n ng=1
MN5 qint gnbb net89 VSS sg13_lv_nmos m=1 w=420.00n l=130.00n ng=1
MN11 Q_N qintn_b VSS VSS sg13_lv_nmos m=1 w=740.00n l=130.00n ng=1
MN3 qint gnb net61 VSS sg13_lv_nmos m=1 w=640.00n l=130.00n ng=1
MN10 qintn_b qint_b VSS VSS sg13_lv_nmos m=1 w=550.00n l=130.00n ng=1
MN4 net61 Db VSS VSS sg13_lv_nmos m=1 w=640.00n l=130.00n ng=1
MN9 Q qint_b VSS VSS sg13_lv_nmos m=1 w=740.00n l=130.00n ng=1
MP1 gnbb gnb VDD VDD sg13_lv_pmos m=1 w=840.00n l=130.00n ng=1
MP4 qint gnbb net60 VDD sg13_lv_pmos m=1 w=1.000u l=130.00n ng=1
MP10 qintn_b qint_b VDD VDD sg13_lv_pmos m=1 w=840.00n l=130.00n ng=1
MP11 Q_N qintn_b VDD VDD sg13_lv_pmos m=1 w=1.12u l=130.00n ng=1
MP3 net60 Db VDD VDD sg13_lv_pmos m=1 w=1.000u l=130.00n ng=1
MP5 net92 qint_b VDD VDD sg13_lv_pmos m=1 w=420.00n l=130.00n ng=1
MP8 qint_b RESET_B VDD VDD sg13_lv_pmos m=1 w=1.12u l=130.00n ng=1
MP2 Db D VDD VDD sg13_lv_pmos m=1 w=840.00n l=130.00n ng=1
MP0 gnb GATE_N VDD VDD sg13_lv_pmos m=1 w=840.00n l=130.00n ng=1
MP9 Q qint_b VDD VDD sg13_lv_pmos m=1 w=1.12u l=130.00n ng=1
MP6 qint gnb net92 VDD sg13_lv_pmos m=1 w=420.00n l=130.00n ng=1
MP7 qint_b qint VDD VDD sg13_lv_pmos m=1 w=1.12u l=130.00n ng=1
.ENDS

************************************************************************
* Library Name: sg13cmos5l_stdcell
* Cell Name:    sg13cmos5l_dllrq_1
* View Name:    schematic
************************************************************************

.SUBCKT sg13cmos5l_dllrq_1 Q D GATE_N RESET_B VDD VSS
*.PININFO D:I GATE_N:I RESET_B:I Q:O VDD:B VSS:B
MN5 qint gnbb net89 VSS sg13_lv_nmos m=1 w=420.00n l=130.00n ng=1
MN3 qint gnb net61 VSS sg13_lv_nmos m=1 w=640.00n l=130.00n ng=1
MN8 net116 RESET_B VSS VSS sg13_lv_nmos m=1 w=740.00n l=130.00n ng=1
MN9 Q qint_b VSS VSS sg13_lv_nmos m=1 w=740.00n l=130.00n ng=1
MN4 net61 Db VSS VSS sg13_lv_nmos m=1 w=640.00n l=130.00n ng=1
MN6 net89 qint_b VSS VSS sg13_lv_nmos m=1 w=420.00n l=130.00n ng=1
MN7 qint_b qint net116 VSS sg13_lv_nmos m=1 w=740.00n l=130.00n ng=1
MN2 Db D VSS VSS sg13_lv_nmos m=1 w=550.00n l=130.00n ng=1
MN0 gnb GATE_N VSS VSS sg13_lv_nmos m=1 w=740.00n l=130.00n ng=1
MN1 gnbb gnb VSS VSS sg13_lv_nmos m=1 w=740.00n l=130.00n ng=1
MP3 net59 Db VDD VDD sg13_lv_pmos m=1 w=1.000u l=130.00n ng=1
MP8 qint_b RESET_B VDD VDD sg13_lv_pmos m=1 w=1.000u l=130.00n ng=1
MP0 gnb GATE_N VDD VDD sg13_lv_pmos m=1 w=840.00n l=130.00n ng=1
MP5 net92 qint_b VDD VDD sg13_lv_pmos m=1 w=420.00n l=130.00n ng=1
MP7 qint_b qint VDD VDD sg13_lv_pmos m=1 w=1.000u l=130.00n ng=1
MP9 Q qint_b VDD VDD sg13_lv_pmos m=1 w=1.12u l=130.00n ng=1
MP4 qint gnbb net59 VDD sg13_lv_pmos m=1 w=1.000u l=130.00n ng=1
MP2 Db D VDD VDD sg13_lv_pmos m=1 w=840.00n l=130.00n ng=1
MP1 gnbb gnb VDD VDD sg13_lv_pmos m=1 w=840.00n l=130.00n ng=1
MP6 qint gnb net92 VDD sg13_lv_pmos m=1 w=420.00n l=130.00n ng=1
.ENDS

************************************************************************
* Library Name: sg13cmos5l_stdcell
* Cell Name:    sg13cmos5l_dlygate4sd1_1
* View Name:    schematic
************************************************************************

.SUBCKT sg13cmos5l_dlygate4sd1_1 X A VDD VSS
*.PININFO A:I X:O VDD:B VSS:B
MP3 X net3 VDD VDD sg13_lv_pmos m=1 w=1.12u l=130.00n ng=1
MP2 net3 net2 VDD VDD sg13_lv_pmos m=1 w=1.000u l=130.00n ng=1
MP1 net2 net1 VDD VDD sg13_lv_pmos m=1 w=1.000u l=130.00n ng=1
MP0 net1 A VDD VDD sg13_lv_pmos m=1 w=420.00n l=130.00n ng=1
MN3 X net3 VSS VSS sg13_lv_nmos m=1 w=740.00n l=130.00n ng=1
MN2 net3 net2 VSS VSS sg13_lv_nmos m=1 w=420.00n l=130.00n ng=1
MN1 net2 net1 VSS VSS sg13_lv_nmos m=1 w=420.00n l=130.00n ng=1
MN0 net1 A VSS VSS sg13_lv_nmos m=1 w=420.00n l=130.00n ng=1
.ENDS

************************************************************************
* Library Name: sg13cmos5l_stdcell
* Cell Name:    sg13cmos5l_dlygate4sd2_1
* View Name:    schematic
************************************************************************

.SUBCKT sg13cmos5l_dlygate4sd2_1 X A VDD VSS
*.PININFO A:I X:O VDD:B VSS:B
MP3 X net3 VDD VDD sg13_lv_pmos m=1 w=1.12u l=130.00n ng=1
MP2 net3 net2 VDD VDD sg13_lv_pmos m=1 w=1.000u l=250.00n ng=1
MP1 net2 net1 VDD VDD sg13_lv_pmos m=1 w=1.000u l=250.00n ng=1
MP0 net1 A VDD VDD sg13_lv_pmos m=1 w=420.00n l=130.00n ng=1
MN3 X net3 VSS VSS sg13_lv_nmos m=1 w=740.00n l=130.00n ng=1
MN2 net3 net2 VSS VSS sg13_lv_nmos m=1 w=420.00n l=180.00n ng=1
MN1 net2 net1 VSS VSS sg13_lv_nmos m=1 w=420.00n l=180.00n ng=1
MN0 net1 A VSS VSS sg13_lv_nmos m=1 w=420.00n l=130.00n ng=1
.ENDS

************************************************************************
* Library Name: sg13cmos5l_stdcell
* Cell Name:    sg13cmos5l_dlygate4sd3_1
* View Name:    schematic
************************************************************************

.SUBCKT sg13cmos5l_dlygate4sd3_1 X A VDD VSS
*.PININFO A:I X:O VDD:B VSS:B
MP3 X net3 VDD VDD sg13_lv_pmos m=1 w=1.12u l=130.00n ng=1
MP2 net3 net2 VDD VDD sg13_lv_pmos m=1 w=1.000u l=500.0n ng=1
MP1 net2 net1 VDD VDD sg13_lv_pmos m=1 w=1.000u l=500.0n ng=1
MP0 net1 A VDD VDD sg13_lv_pmos m=1 w=420.00n l=130.00n ng=1
MN3 X net3 VSS VSS sg13_lv_nmos m=1 w=740.00n l=130.00n ng=1
MN2 net3 net2 VSS VSS sg13_lv_nmos m=1 w=420.00n l=500.0n ng=1
MN1 net2 net1 VSS VSS sg13_lv_nmos m=1 w=420.00n l=500.0n ng=1
MN0 net1 A VSS VSS sg13_lv_nmos m=1 w=420.00n l=130.00n ng=1
.ENDS

************************************************************************
* Library Name: sg13cmos5l_stdcell
* Cell Name:    sg13cmos5l_ebufn_2
* View Name:    schematic
************************************************************************

.SUBCKT sg13cmos5l_ebufn_2 Z A TE_B VDD VSS
*.PININFO A:I TE_B:I Z:O VDD:B VSS:B
MN3 net4 net3 VSS VSS sg13_lv_nmos m=1 w=1.48u l=130.00n ng=2
MN2 Z net1 net4 VSS sg13_lv_nmos m=1 w=1.48u l=130.00n ng=2
MN1 net3 TE_B VSS VSS sg13_lv_nmos m=1 w=640.00n l=130.00n ng=1
MN0 net1 A VSS VSS sg13_lv_nmos m=1 w=640.00n l=130.00n ng=1
MP2 net2 TE_B VDD VDD sg13_lv_pmos m=1 w=2.24u l=130.00n ng=2
MP3 Z net1 net2 VDD sg13_lv_pmos m=1 w=2.24u l=130.00n ng=2
MP1 net3 TE_B VDD VDD sg13_lv_pmos m=1 w=1.000u l=130.00n ng=1
MP0 net1 A VDD VDD sg13_lv_pmos m=1 w=1.000u l=130.00n ng=1
.ENDS

************************************************************************
* Library Name: sg13cmos5l_stdcell
* Cell Name:    sg13cmos5l_ebufn_4
* View Name:    schematic
************************************************************************

.SUBCKT sg13cmos5l_ebufn_4 Z A TE_B VDD VSS
*.PININFO A:I TE_B:I Z:O VDD:B VSS:B
MN0 net23 A VSS VSS sg13_lv_nmos m=1 w=740.00n l=130.00n ng=1
MN1 net21 TE_B VSS VSS sg13_lv_nmos m=1 w=740.00n l=130.00n ng=1
MN2 Z net23 net22 VSS sg13_lv_nmos m=1 w=2.96u l=130.00n ng=4
MN3 net22 net21 VSS VSS sg13_lv_nmos m=1 w=2.96u l=130.00n ng=4
MP0 net23 A VDD VDD sg13_lv_pmos m=1 w=1.12u l=130.00n ng=1
MP1 net21 TE_B VDD VDD sg13_lv_pmos m=1 w=1.12u l=130.00n ng=1
MP3 Z net23 net24 VDD sg13_lv_pmos m=1 w=4.48u l=130.00n ng=4
MP2 net24 TE_B VDD VDD sg13_lv_pmos m=1 w=4.48u l=130.00n ng=4
.ENDS

************************************************************************
* Library Name: sg13cmos5l_stdcell
* Cell Name:    sg13cmos5l_ebufn_8
* View Name:    schematic
************************************************************************

.SUBCKT sg13cmos5l_ebufn_8 Z A TE_B VDD VSS
*.PININFO A:I TE_B:I Z:O VDD:B VSS:B
MN3 net23 net22 VSS VSS sg13_lv_nmos m=1 w=5.92u l=130.00n ng=8
MN2 Z net21 net23 VSS sg13_lv_nmos m=1 w=5.92u l=130.00n ng=8
MN1 net22 TE_B VSS VSS sg13_lv_nmos m=1 w=740.00n l=130.00n ng=1
MN0 net21 A VSS VSS sg13_lv_nmos m=1 w=1.48u l=130.00n ng=2
MP2 net24 TE_B VDD VDD sg13_lv_pmos m=1 w=8.96u l=130.00n ng=8
MP3 Z net21 net24 VDD sg13_lv_pmos m=1 w=8.96u l=130.00n ng=8
MP1 net22 TE_B VDD VDD sg13_lv_pmos m=1 w=1.12u l=130.00n ng=1
MP0 net21 A VDD VDD sg13_lv_pmos m=1 w=2.24u l=130.00n ng=2
.ENDS

************************************************************************
* Library Name: sg13cmos5l_stdcell
* Cell Name:    sg13cmos5l_einvn_2
* View Name:    schematic
************************************************************************

.SUBCKT sg13cmos5l_einvn_2 Z A TE_B VDD VSS
*.PININFO A:I TE_B:I Z:O VDD:B VSS:B
MN0 TE TE_B VSS VSS sg13_lv_nmos m=1 w=420.00n l=130.00n ng=1
MN2 net1 TE VSS VSS sg13_lv_nmos m=1 w=1.48u l=130.00n ng=2
MN1 Z A net1 VSS sg13_lv_nmos m=1 w=1.48u l=130.00n ng=2
MP0 TE TE_B VDD VDD sg13_lv_pmos m=1 w=640.00n l=130.00n ng=1
MP1 net2 TE_B VDD VDD sg13_lv_pmos m=1 w=2.24u l=130.00n ng=2
MP2 Z A net2 VDD sg13_lv_pmos m=1 w=2.24u l=130.00n ng=2
.ENDS

************************************************************************
* Library Name: sg13cmos5l_stdcell
* Cell Name:    sg13cmos5l_einvn_4
* View Name:    schematic
************************************************************************

.SUBCKT sg13cmos5l_einvn_4 Z A TE_B VDD VSS
*.PININFO A:I TE_B:I Z:O VDD:B VSS:B
MN2 net16 TE VSS VSS sg13_lv_nmos m=1 w=2.96u l=130.00n ng=4
MN0 TE TE_B VSS VSS sg13_lv_nmos m=1 w=740.00n l=130.00n ng=1
MN1 Z A net16 VSS sg13_lv_nmos m=1 w=2.96u l=130.00n ng=4
MP0 TE TE_B VDD VDD sg13_lv_pmos m=1 w=1.12u l=130.00n ng=1
MP1 net17 TE_B VDD VDD sg13_lv_pmos m=1 w=4.48u l=130.00n ng=4
MP2 Z A net17 VDD sg13_lv_pmos m=1 w=4.48u l=130.00n ng=4
.ENDS

************************************************************************
* Library Name: sg13cmos5l_stdcell
* Cell Name:    sg13cmos5l_einvn_8
* View Name:    schematic
************************************************************************

.SUBCKT sg13cmos5l_einvn_8 Z A TE_B VDD VSS
*.PININFO A:I TE_B:I Z:O VDD:B VSS:B
MN1 Z A net29 VSS sg13_lv_nmos m=1 w=5.92u l=130.00n ng=8
MN0 TE TE_B VSS VSS sg13_lv_nmos m=1 w=740.00n l=130.00n ng=1
MN2 net29 TE VSS VSS sg13_lv_nmos m=1 w=5.92u l=130.00n ng=8
MP1 net28 TE_B VDD VDD sg13_lv_pmos m=1 w=8.96u l=130.00n ng=8
MP2 Z A net28 VDD sg13_lv_pmos m=1 w=8.96u l=130.00n ng=8
MP0 TE TE_B VDD VDD sg13_lv_pmos m=1 w=1.12u l=130.00n ng=1
.ENDS

************************************************************************
* Library Name: sg13cmos5l_stdcell
* Cell Name:    sg13cmos5l_inv_1
* View Name:    schematic
************************************************************************

.SUBCKT sg13cmos5l_inv_1 Y A VDD VSS
*.PININFO A:I Y:O VDD:B VSS:B
MN0 Y A VSS VSS sg13_lv_nmos m=1 w=740.00n l=130.00n ng=1
MP0 Y A VDD VDD sg13_lv_pmos m=1 w=1.12u l=130.00n ng=1
.ENDS

************************************************************************
* Library Name: sg13cmos5l_stdcell
* Cell Name:    sg13cmos5l_inv_16
* View Name:    schematic
************************************************************************

.SUBCKT sg13cmos5l_inv_16 Y A VDD VSS
*.PININFO A:I Y:O VDD:B VSS:B
MN0 Y A VSS VSS sg13_lv_nmos m=1 w=11.84u l=130.00n ng=16
MP0 Y A VDD VDD sg13_lv_pmos m=1 w=17.92u l=130.00n ng=16
.ENDS

************************************************************************
* Library Name: sg13cmos5l_stdcell
* Cell Name:    sg13cmos5l_inv_2
* View Name:    schematic
************************************************************************

.SUBCKT sg13cmos5l_inv_2 Y A VDD VSS
*.PININFO A:I Y:O VDD:B VSS:B
MN0 Y A VSS VSS sg13_lv_nmos m=1 w=1.48u l=130.00n ng=2
MP0 Y A VDD VDD sg13_lv_pmos m=1 w=2.24u l=130.00n ng=2
.ENDS

************************************************************************
* Library Name: sg13cmos5l_stdcell
* Cell Name:    sg13cmos5l_inv_4
* View Name:    schematic
************************************************************************

.SUBCKT sg13cmos5l_inv_4 Y A VDD VSS
*.PININFO A:I Y:O VDD:B VSS:B
MP0 Y A VDD VDD sg13_lv_pmos m=1 w=4.48u l=130.00n ng=4
MN0 Y A VSS VSS sg13_lv_nmos m=1 w=2.96u l=130.00n ng=4
.ENDS

************************************************************************
* Library Name: sg13cmos5l_stdcell
* Cell Name:    sg13cmos5l_inv_8
* View Name:    schematic
************************************************************************

.SUBCKT sg13cmos5l_inv_8 Y A VDD VSS
*.PININFO A:I Y:O VDD:B VSS:B
MN0 Y A VSS VSS sg13_lv_nmos m=1 w=5.92u l=130.00n ng=8
MP0 Y A VDD VDD sg13_lv_pmos m=1 w=8.96u l=130.00n ng=8
.ENDS

************************************************************************
* Library Name: sg13cmos5l_stdcell
* Cell Name:    sg13cmos5l_lgcp_1
* View Name:    schematic
************************************************************************

.SUBCKT sg13cmos5l_lgcp_1 GCLK CLK GATE VDD VSS
*.PININFO CLK:I GATE:I GCLK:O VDD:B VSS:B
MP1 CLKBB CLKB VDD VDD sg13_lv_pmos m=1 w=840.00n l=130.00n ng=1
MP3 net1 CLKBB net4 VDD sg13_lv_pmos m=1 w=1.000u l=130.00n ng=1
MP4 int_GATE net1 VDD VDD sg13_lv_pmos m=1 w=1.12u l=130.00n ng=1
MP2 net4 GATE VDD VDD sg13_lv_pmos m=1 w=1.000u l=130.00n ng=1
MP8 net3 int_GATE VDD VDD sg13_lv_pmos m=1 w=840.00n l=130.00n ng=1
MP9 GCLK net3 VDD VDD sg13_lv_pmos m=1 w=1.12u l=130.00n ng=1
MP6 net1 CLKB net6 VDD sg13_lv_pmos m=1 w=420.00n l=130.00n ng=1
MP0 CLKB CLK VDD VDD sg13_lv_pmos m=1 w=840.00n l=130.00n ng=1
MP7 net3 CLK VDD VDD sg13_lv_pmos m=1 w=840.00n l=130.00n ng=1
MP5 net6 int_GATE VDD VDD sg13_lv_pmos m=1 w=420.00n l=130.00n ng=1
MN9 GCLK net3 VSS VSS sg13_lv_nmos m=1 w=740.00n l=130.00n ng=1
MN7 net3 int_GATE net5 VSS sg13_lv_nmos m=1 w=640.00n l=130.00n ng=1
MN4 int_GATE net1 VSS VSS sg13_lv_nmos m=1 w=740.00n l=130.00n ng=1
MN1 CLKBB CLKB VSS VSS sg13_lv_nmos m=1 w=740.00n l=130.00n ng=1
MN6 net7 int_GATE VSS VSS sg13_lv_nmos m=1 w=420.00n l=130.00n ng=1
MN3 net2 GATE VSS VSS sg13_lv_nmos m=1 w=640.00n l=130.00n ng=1
MN5 net1 CLKBB net7 VSS sg13_lv_nmos m=1 w=420.00n l=130.00n ng=1
MN0 CLKB CLK VSS VSS sg13_lv_nmos m=1 w=740.00n l=130.00n ng=1
MN8 net5 CLK VSS VSS sg13_lv_nmos m=1 w=640.00n l=130.00n ng=1
MN2 net1 CLKB net2 VSS sg13_lv_nmos m=1 w=640.00n l=130.00n ng=1
.ENDS

************************************************************************
* Library Name: sg13cmos5l_stdcell
* Cell Name:    sg13cmos5l_mux2_1
* View Name:    schematic
************************************************************************

.SUBCKT sg13cmos5l_mux2_1 X A0 A1 S VDD VSS
*.PININFO A0:I A1:I S:I X:O VDD:B VSS:B
MP1 net4 S VDD VDD sg13_lv_pmos m=1 w=1.000u l=130.00n ng=1
MP5 X net6 VDD VDD sg13_lv_pmos m=1 w=1.12u l=130.00n ng=1
MP4 net6 A1 net5 VDD sg13_lv_pmos m=1 w=1.000u l=130.00n ng=1
MP0 Sb S VDD VDD sg13_lv_pmos m=1 w=840.00n l=130.00n ng=1
MP3 net5 Sb VDD VDD sg13_lv_pmos m=1 w=1.000u l=130.00n ng=1
MP2 net6 A0 net4 VDD sg13_lv_pmos m=1 w=1.000u l=130.00n ng=1
MN4 net3 S VSS VSS sg13_lv_nmos m=1 w=740.00n l=130.00n ng=1
MN2 net1 Sb VSS VSS sg13_lv_nmos m=1 w=740.00n l=130.00n ng=1
MN5 X net6 VSS VSS sg13_lv_nmos m=1 w=740.00n l=130.00n ng=1
MN0 Sb S VSS VSS sg13_lv_nmos m=1 w=550.00n l=130.00n ng=1
MN3 net6 A1 net3 VSS sg13_lv_nmos m=1 w=740.00n l=130.00n ng=1
MN1 net6 A0 net1 VSS sg13_lv_nmos m=1 w=740.00n l=130.00n ng=1
.ENDS

************************************************************************
* Library Name: sg13cmos5l_stdcell
* Cell Name:    sg13cmos5l_mux2_2
* View Name:    schematic
************************************************************************

.SUBCKT sg13cmos5l_mux2_2 X A0 A1 S VDD VSS
*.PININFO A0:I A1:I S:I X:O VDD:B VSS:B
MP1 net4 S VDD VDD sg13_lv_pmos m=1 w=1.000u l=130.00n ng=1
MP5 X net6 VDD VDD sg13_lv_pmos m=1 w=2.24u l=130.00n ng=2
MP4 net6 A1 net5 VDD sg13_lv_pmos m=1 w=1.000u l=130.00n ng=1
MP0 Sb S VDD VDD sg13_lv_pmos m=1 w=840.00n l=130.00n ng=1
MP3 net5 Sb VDD VDD sg13_lv_pmos m=1 w=1.000u l=130.00n ng=1
MP2 net6 A0 net4 VDD sg13_lv_pmos m=1 w=1.000u l=130.00n ng=1
MN4 net3 S VSS VSS sg13_lv_nmos m=1 w=740.00n l=130.00n ng=1
MN2 net1 Sb VSS VSS sg13_lv_nmos m=1 w=740.00n l=130.00n ng=1
MN5 X net6 VSS VSS sg13_lv_nmos m=1 w=1.48u l=130.00n ng=2
MN0 Sb S VSS VSS sg13_lv_nmos m=1 w=550.00n l=130.00n ng=1
MN3 net6 A1 net3 VSS sg13_lv_nmos m=1 w=740.00n l=130.00n ng=1
MN1 net6 A0 net1 VSS sg13_lv_nmos m=1 w=740.00n l=130.00n ng=1
.ENDS

************************************************************************
* Library Name: sg13cmos5l_stdcell
* Cell Name:    sg13cmos5l_mux4_1
* View Name:    schematic
************************************************************************

.SUBCKT sg13cmos5l_mux4_1 X A0 A1 A2 A3 S0 S1 VDD VSS
*.PININFO A0:I A1:I A2:I A3:I S0:I S1:I X:O VDD:B VSS:B
MN12 X Xb VSS VSS sg13_lv_nmos m=1 w=740.00n l=130.00n ng=1
MN2 low S0b net7 VSS sg13_lv_nmos m=1 w=640.00n l=130.00n ng=1
MN3 net7 A0 VSS VSS sg13_lv_nmos m=1 w=640.00n l=130.00n ng=1
MN6 low S1b Xb VSS sg13_lv_nmos m=1 w=640.00n l=130.00n ng=1
MN11 high S1 Xb VSS sg13_lv_nmos m=1 w=640.00n l=130.00n ng=1
MN10 net4 A3 VSS VSS sg13_lv_nmos m=1 w=640.00n l=130.00n ng=1
MN9 high S0 net4 VSS sg13_lv_nmos m=1 w=640.00n l=130.00n ng=1
MN8 net6 A2 VSS VSS sg13_lv_nmos m=1 w=640.00n l=130.00n ng=1
MN7 high S0b net6 VSS sg13_lv_nmos m=1 w=640.00n l=130.00n ng=1
MN5 net2 A1 VSS VSS sg13_lv_nmos m=1 w=640.00n l=130.00n ng=1
MN4 low S0 net2 VSS sg13_lv_nmos m=1 w=640.00n l=130.00n ng=1
MN1 S1b S1 VSS VSS sg13_lv_nmos m=1 w=640.00n l=130.00n ng=1
MN0 S0b S0 VSS VSS sg13_lv_nmos m=1 w=640.00n l=130.00n ng=1
MP6 low S1 Xb VDD sg13_lv_pmos m=1 w=1.000u l=130.00n ng=1
MP11 high S1b Xb VDD sg13_lv_pmos m=1 w=1.000u l=130.00n ng=1
MP12 X Xb VDD VDD sg13_lv_pmos m=1 w=1.12u l=130.00n ng=1
MP10 high S0b net3 VDD sg13_lv_pmos m=1 w=1.000u l=130.00n ng=1
MP9 net3 A3 VDD VDD sg13_lv_pmos m=1 w=1.000u l=130.00n ng=1
MP8 high S0 net5 VDD sg13_lv_pmos m=1 w=1.000u l=130.00n ng=1
MP7 net5 A2 VDD VDD sg13_lv_pmos m=1 w=1.000u l=130.00n ng=1
MP2 net8 A0 VDD VDD sg13_lv_pmos m=1 w=1.000u l=130.00n ng=1
MP3 low S0 net8 VDD sg13_lv_pmos m=1 w=1.000u l=130.00n ng=1
MP1 S1b S1 VDD VDD sg13_lv_pmos m=1 w=1.000u l=130.00n ng=1
MP0 S0b S0 VDD VDD sg13_lv_pmos m=1 w=1.000u l=130.00n ng=1
MP5 low S0b net1 VDD sg13_lv_pmos m=1 w=1.000u l=130.00n ng=1
MP4 net1 A1 VDD VDD sg13_lv_pmos m=1 w=1.000u l=130.00n ng=1
.ENDS

************************************************************************
* Library Name: sg13cmos5l_stdcell
* Cell Name:    sg13cmos5l_nand2_1
* View Name:    schematic
************************************************************************

.SUBCKT sg13cmos5l_nand2_1 Y A B VDD VSS
*.PININFO A:I B:I Y:O VDD:B VSS:B
MP1 Y B VDD VDD sg13_lv_pmos m=1 w=1.12u l=130.00n ng=1
MP0 Y A VDD VDD sg13_lv_pmos m=1 w=1.12u l=130.00n ng=1
MN1 net1 B VSS VSS sg13_lv_nmos m=1 w=740.00n l=130.00n ng=1
MN0 Y A net1 VSS sg13_lv_nmos m=1 w=740.00n l=130.00n ng=1
.ENDS

************************************************************************
* Library Name: sg13cmos5l_stdcell
* Cell Name:    sg13cmos5l_nand2_2
* View Name:    schematic
************************************************************************

.SUBCKT sg13cmos5l_nand2_2 Y A B VDD VSS
*.PININFO A:I B:I Y:O VDD:B VSS:B
MP1 Y B VDD VDD sg13_lv_pmos m=1 w=2.24u l=130.00n ng=2
MP0 Y A VDD VDD sg13_lv_pmos m=1 w=2.24u l=130.00n ng=2
MN1 net1 B VSS VSS sg13_lv_nmos m=1 w=1.44u l=130.00n ng=2
MN0 Y A net1 VSS sg13_lv_nmos m=1 w=1.44u l=130.00n ng=2
.ENDS

************************************************************************
* Library Name: sg13cmos5l_stdcell
* Cell Name:    sg13cmos5l_nand2b_1
* View Name:    schematic
************************************************************************

.SUBCKT sg13cmos5l_nand2b_1 Y A_N B VDD VSS
*.PININFO A_N:I B:I Y:O VDD:B VSS:B
MP2 Y net2 VDD VDD sg13_lv_pmos m=1 w=1.12u l=130.00n ng=1
MP1 net2 A_N VDD VDD sg13_lv_pmos m=1 w=840.00n l=130.00n ng=1
MP0 Y B VDD VDD sg13_lv_pmos m=1 w=1.12u l=130.00n ng=1
MN1 Y net2 net1 VSS sg13_lv_nmos m=1 w=740.00n l=130.00n ng=1
MN0 net2 A_N VSS VSS sg13_lv_nmos m=1 w=550.00n l=130.00n ng=1
MN2 net1 B VSS VSS sg13_lv_nmos m=1 w=740.00n l=130.00n ng=1
.ENDS

************************************************************************
* Library Name: sg13cmos5l_stdcell
* Cell Name:    sg13cmos5l_nand2b_2
* View Name:    schematic
************************************************************************

.SUBCKT sg13cmos5l_nand2b_2 Y A_N B VDD VSS
*.PININFO A_N:I B:I Y:O VDD:B VSS:B
MP2 Y A VDD VDD sg13_lv_pmos m=1 w=2.24u l=130.00n ng=2
MP0 A A_N VDD VDD sg13_lv_pmos m=1 w=840.00n l=130.00n ng=1
MP1 Y B VDD VDD sg13_lv_pmos m=1 w=2.24u l=130.00n ng=2
MN1 Y B net1 VSS sg13_lv_nmos m=1 w=1.44u l=130.00n ng=2
MN0 A A_N VSS VSS sg13_lv_nmos m=1 w=550.00n l=130.00n ng=1
MN2 net1 A VSS VSS sg13_lv_nmos m=1 w=1.44u l=130.00n ng=2
.ENDS

************************************************************************
* Library Name: sg13cmos5l_stdcell
* Cell Name:    sg13cmos5l_nand3_1
* View Name:    schematic
************************************************************************

.SUBCKT sg13cmos5l_nand3_1 Y A B C VDD VSS
*.PININFO A:I B:I C:I Y:O VDD:B VSS:B
MP0 Y A VDD VDD sg13_lv_pmos m=1 w=1.12u l=130.00n ng=1
MP1 Y B VDD VDD sg13_lv_pmos m=1 w=1.12u l=130.00n ng=1
MP2 Y C VDD VDD sg13_lv_pmos m=1 w=1.12u l=130.00n ng=1
MN1 net2 B net3 VSS sg13_lv_nmos m=1 w=740.00n l=130.00n ng=1
MN2 net3 C VSS VSS sg13_lv_nmos m=1 w=740.00n l=130.00n ng=1
MN0 Y A net2 VSS sg13_lv_nmos m=1 w=740.00n l=130.00n ng=1
.ENDS

************************************************************************
* Library Name: sg13cmos5l_stdcell
* Cell Name:    sg13cmos5l_nand3b_1
* View Name:    schematic
************************************************************************

.SUBCKT sg13cmos5l_nand3b_1 Y A_N B C VDD VSS
*.PININFO A_N:I B:I C:I Y:O VDD:B VSS:B
MP0 net1 A_N VDD VDD sg13_lv_pmos m=1 w=840.00n l=130.00n ng=1
MP1 Y net1 VDD VDD sg13_lv_pmos m=1 w=1.12u l=130.00n ng=1
MP2 Y B VDD VDD sg13_lv_pmos m=1 w=1.12u l=130.00n ng=1
MP3 Y C VDD VDD sg13_lv_pmos m=1 w=1.12u l=130.00n ng=1
MN2 net2 B net3 VSS sg13_lv_nmos m=1 w=740.00n l=130.00n ng=1
MN3 net3 C VSS VSS sg13_lv_nmos m=1 w=740.00n l=130.00n ng=1
MN0 net1 A_N VSS VSS sg13_lv_nmos m=1 w=550.00n l=130.00n ng=1
MN1 Y net1 net2 VSS sg13_lv_nmos m=1 w=740.00n l=130.00n ng=1
.ENDS

************************************************************************
* Library Name: sg13cmos5l_stdcell
* Cell Name:    sg13cmos5l_nand4_1
* View Name:    schematic
************************************************************************

.SUBCKT sg13cmos5l_nand4_1 Y A B C D VDD VSS
*.PININFO A:I B:I C:I D:I Y:O VDD:B VSS:B
MP3 Y D VDD VDD sg13_lv_pmos m=1 w=1.12u l=130.00n ng=1
MP0 Y A VDD VDD sg13_lv_pmos m=1 w=1.12u l=130.00n ng=1
MP1 Y B VDD VDD sg13_lv_pmos m=1 w=1.12u l=130.00n ng=1
MP2 Y C VDD VDD sg13_lv_pmos m=1 w=1.12u l=130.00n ng=1
MN1 net2 B net3 VSS sg13_lv_nmos m=1 w=740.00n l=130.00n ng=1
MN2 net3 C net5 VSS sg13_lv_nmos m=1 w=740.00n l=130.00n ng=1
MN0 Y A net2 VSS sg13_lv_nmos m=1 w=740.00n l=130.00n ng=1
MN3 net5 D VSS VSS sg13_lv_nmos m=1 w=740.00n l=130.00n ng=1
.ENDS

************************************************************************
* Library Name: sg13cmos5l_stdcell
* Cell Name:    sg13cmos5l_nor2_1
* View Name:    schematic
************************************************************************

.SUBCKT sg13cmos5l_nor2_1 Y A B VDD VSS
*.PININFO A:I B:I Y:O VDD:B VSS:B
MN0 Y A VSS VSS sg13_lv_nmos m=1 w=740.00n l=130.00n ng=1
MN1 Y B VSS VSS sg13_lv_nmos m=1 w=740.00n l=130.00n ng=1
MP0 net1 A VDD VDD sg13_lv_pmos m=1 w=1.12u l=130.00n ng=1
MP1 Y B net1 VDD sg13_lv_pmos m=1 w=1.12u l=130.00n ng=1
.ENDS

************************************************************************
* Library Name: sg13cmos5l_stdcell
* Cell Name:    sg13cmos5l_nor2_2
* View Name:    schematic
************************************************************************

.SUBCKT sg13cmos5l_nor2_2 Y A B VDD VSS
*.PININFO A:I B:I Y:O VDD:B VSS:B
MN0 Y A VSS VSS sg13_lv_nmos m=1 w=1.48u l=130.00n ng=2
MN1 Y B VSS VSS sg13_lv_nmos m=1 w=1.48u l=130.00n ng=2
MP0 net1 A VDD VDD sg13_lv_pmos m=1 w=2.24u l=130.00n ng=2
MP1 Y B net1 VDD sg13_lv_pmos m=1 w=2.24u l=130.00n ng=2
.ENDS

************************************************************************
* Library Name: sg13cmos5l_stdcell
* Cell Name:    sg13cmos5l_nor2b_1
* View Name:    schematic
************************************************************************

.SUBCKT sg13cmos5l_nor2b_1 Y A B_N VDD VSS
*.PININFO A:I B_N:I Y:O VDD:B VSS:B
MN0 B B_N VSS VSS sg13_lv_nmos m=1 w=550.00n l=130.00n ng=1
MN1 Y A VSS VSS sg13_lv_nmos m=1 w=740.00n l=130.00n ng=1
MN2 Y B VSS VSS sg13_lv_nmos m=1 w=740.00n l=130.00n ng=1
MP0 B B_N VDD VDD sg13_lv_pmos m=1 w=840.00n l=130.00n ng=1
MP1 net1 B VDD VDD sg13_lv_pmos m=1 w=1.12u l=130.00n ng=1
MP2 Y A net1 VDD sg13_lv_pmos m=1 w=1.12u l=130.00n ng=1
.ENDS

************************************************************************
* Library Name: sg13cmos5l_stdcell
* Cell Name:    sg13cmos5l_nor2b_2
* View Name:    schematic
************************************************************************

.SUBCKT sg13cmos5l_nor2b_2 Y A B_N VDD VSS
*.PININFO A:I B_N:I Y:O VDD:B VSS:B
MN0 B B_N VSS VSS sg13_lv_nmos m=1 w=640.00n l=130.00n ng=1
MN1 Y A VSS VSS sg13_lv_nmos m=1 w=1.44u l=130.00n ng=2
MN2 Y B VSS VSS sg13_lv_nmos m=1 w=1.44u l=130.00n ng=2
MP0 B B_N VDD VDD sg13_lv_pmos m=1 w=1.000u l=130.00n ng=1
MP1 net1 B VDD VDD sg13_lv_pmos m=1 w=2.24u l=130.00n ng=2
MP2 Y A net1 VDD sg13_lv_pmos m=1 w=2.24u l=130.00n ng=2
.ENDS

************************************************************************
* Library Name: sg13cmos5l_stdcell
* Cell Name:    sg13cmos5l_nor3_1
* View Name:    schematic
************************************************************************

.SUBCKT sg13cmos5l_nor3_1 Y A B C VDD VSS
*.PININFO A:I B:I C:I Y:O VDD:B VSS:B
MP2 Y C net2 VDD sg13_lv_pmos m=1 w=1.12u l=130.00n ng=1
MP1 net2 B net3 VDD sg13_lv_pmos m=1 w=1.12u l=130.00n ng=1
MP0 net3 A VDD VDD sg13_lv_pmos m=1 w=1.12u l=130.00n ng=1
MN0 Y A VSS VSS sg13_lv_nmos m=1 w=770.00n l=130.00n ng=1
MN1 Y B VSS VSS sg13_lv_nmos m=1 w=770.00n l=130.00n ng=1
MN2 Y C VSS VSS sg13_lv_nmos m=1 w=770.00n l=130.00n ng=1
.ENDS

************************************************************************
* Library Name: sg13cmos5l_stdcell
* Cell Name:    sg13cmos5l_nor3_2
* View Name:    schematic
************************************************************************

.SUBCKT sg13cmos5l_nor3_2 Y A B C VDD VSS
*.PININFO A:I B:I C:I Y:O VDD:B VSS:B
MP2 Y C net2 VDD sg13_lv_pmos m=1 w=2.24u l=130.00n ng=2
MP1 net2 B net3 VDD sg13_lv_pmos m=1 w=2.24u l=130.00n ng=2
MP0 net3 A VDD VDD sg13_lv_pmos m=1 w=2.24u l=130.00n ng=2
MN0 Y A VSS VSS sg13_lv_nmos m=1 w=1.48u l=130.00n ng=2
MN1 Y B VSS VSS sg13_lv_nmos m=1 w=1.48u l=130.00n ng=2
MN2 Y C VSS VSS sg13_lv_nmos m=1 w=1.48u l=130.00n ng=2
.ENDS

************************************************************************
* Library Name: sg13cmos5l_stdcell
* Cell Name:    sg13cmos5l_nor4_1
* View Name:    schematic
************************************************************************

.SUBCKT sg13cmos5l_nor4_1 Y A B C D VDD VSS
*.PININFO A:I B:I C:I D:I Y:O VDD:B VSS:B
MP0 net3 A VDD VDD sg13_lv_pmos m=1 w=1.12u l=130.00n ng=1
MP1 net2 B net3 VDD sg13_lv_pmos m=1 w=1.12u l=130.00n ng=1
MP2 net1 C net2 VDD sg13_lv_pmos m=1 w=1.12u l=130.00n ng=1
MP3 Y D net1 VDD sg13_lv_pmos m=1 w=1.12u l=130.00n ng=1
MN0 Y A VSS VSS sg13_lv_nmos m=1 w=740.00n l=130.00n ng=1
MN3 Y D VSS VSS sg13_lv_nmos m=1 w=740.00n l=130.00n ng=1
MN1 Y B VSS VSS sg13_lv_nmos m=1 w=740.00n l=130.00n ng=1
MN2 Y C VSS VSS sg13_lv_nmos m=1 w=740.00n l=130.00n ng=1
.ENDS

************************************************************************
* Library Name: sg13cmos5l_stdcell
* Cell Name:    sg13cmos5l_nor4_2
* View Name:    schematic
************************************************************************

.SUBCKT sg13cmos5l_nor4_2 Y A B C D VDD VSS
*.PININFO A:I B:I C:I D:I Y:O VDD:B VSS:B
MP0 net3 A VDD VDD sg13_lv_pmos m=1 w=2.24u l=130.00n ng=2
MP1 net2 B net3 VDD sg13_lv_pmos m=1 w=2.24u l=130.00n ng=2
MP2 net1 C net2 VDD sg13_lv_pmos m=1 w=2.24u l=130.00n ng=2
MP3 Y D net1 VDD sg13_lv_pmos m=1 w=2.24u l=130.00n ng=2
MN0 Y A VSS VSS sg13_lv_nmos m=1 w=1.48u l=130.00n ng=2
MN3 Y D VSS VSS sg13_lv_nmos m=1 w=1.48u l=130.00n ng=2
MN1 Y B VSS VSS sg13_lv_nmos m=1 w=1.48u l=130.00n ng=2
MN2 Y C VSS VSS sg13_lv_nmos m=1 w=1.48u l=130.00n ng=2
.ENDS

************************************************************************
* Library Name: sg13cmos5l_stdcell
* Cell Name:    sg13cmos5l_o21ai_1
* View Name:    schematic
************************************************************************

.SUBCKT sg13cmos5l_o21ai_1 Y A1 A2 B1 VDD VSS
*.PININFO A1:I A2:I B1:I Y:O VDD:B VSS:B
MP0 net14 A1 VDD VDD sg13_lv_pmos m=1 w=1.12u l=150.00n ng=1
MP1 Y A2 net14 VDD sg13_lv_pmos m=1 w=1.12u l=150.00n ng=1
MP2 Y B1 VDD VDD sg13_lv_pmos m=1 w=1.12u l=150.00n ng=1
MN0 net1 A2 VSS VSS sg13_lv_nmos m=1 w=740.00n l=150.00n ng=1
MN2 net1 A1 VSS VSS sg13_lv_nmos m=1 w=740.00n l=150.00n ng=1
MN1 Y B1 net1 VSS sg13_lv_nmos m=1 w=740.00n l=150.00n ng=1
.ENDS

************************************************************************
* Library Name: sg13cmos5l_stdcell
* Cell Name:    sg13cmos5l_or2_1
* View Name:    schematic
************************************************************************

.SUBCKT sg13cmos5l_or2_1 X A B VDD VSS
*.PININFO A:I B:I X:O VDD:B VSS:B
MP1 net2 B net3 VDD sg13_lv_pmos m=1 w=840.00n l=130.00n ng=1
MP0 net3 A VDD VDD sg13_lv_pmos m=1 w=840.00n l=130.00n ng=1
MP2 X net2 VDD VDD sg13_lv_pmos m=1 w=1.12u l=130.00n ng=1
MN1 net2 A VSS VSS sg13_lv_nmos m=1 w=550.00n l=130.00n ng=1
MN0 net2 B VSS VSS sg13_lv_nmos m=1 w=550.00n l=130.00n ng=1
MN2 X net2 VSS VSS sg13_lv_nmos m=1 w=740.00n l=130.00n ng=1
.ENDS

************************************************************************
* Library Name: sg13cmos5l_stdcell
* Cell Name:    sg13cmos5l_or2_2
* View Name:    schematic
************************************************************************

.SUBCKT sg13cmos5l_or2_2 X A B VDD VSS
*.PININFO A:I B:I X:O VDD:B VSS:B
MP1 net2 B net3 VDD sg13_lv_pmos m=1 w=840.00n l=130.00n ng=1
MP0 net3 A VDD VDD sg13_lv_pmos m=1 w=840.00n l=130.00n ng=1
MP2 X net2 VDD VDD sg13_lv_pmos m=1 w=2.24u l=130.00n ng=2
MN1 net2 A VSS VSS sg13_lv_nmos m=1 w=550.00n l=130.00n ng=1
MN0 net2 B VSS VSS sg13_lv_nmos m=1 w=550.00n l=130.00n ng=1
MN2 X net2 VSS VSS sg13_lv_nmos m=1 w=1.48u l=130.00n ng=2
.ENDS

************************************************************************
* Library Name: sg13cmos5l_stdcell
* Cell Name:    sg13cmos5l_or3_1
* View Name:    schematic
************************************************************************

.SUBCKT sg13cmos5l_or3_1 X A B C VDD VSS
*.PININFO A:I B:I C:I X:O VDD:B VSS:B
MN2 net1 C VSS VSS sg13_lv_nmos m=1 w=550.00n l=130.00n ng=1
MN3 X net1 VSS VSS sg13_lv_nmos m=1 w=740.00n l=130.00n ng=1
MN1 net1 B VSS VSS sg13_lv_nmos m=1 w=550.00n l=130.00n ng=1
MN0 net1 A VSS VSS sg13_lv_nmos m=1 w=550.00n l=130.00n ng=1
MP3 X net1 VDD VDD sg13_lv_pmos m=1 w=1.12u l=130.00n ng=1
MP1 net9 B net12 VDD sg13_lv_pmos m=1 w=1.000u l=130.00n ng=1
MP0 net12 A VDD VDD sg13_lv_pmos m=1 w=1.000u l=130.00n ng=1
MP2 net1 C net9 VDD sg13_lv_pmos m=1 w=1.000u l=130.00n ng=1
.ENDS

************************************************************************
* Library Name: sg13cmos5l_stdcell
* Cell Name:    sg13cmos5l_or3_2
* View Name:    schematic
************************************************************************

.SUBCKT sg13cmos5l_or3_2 X A B C VDD VSS
*.PININFO A:I B:I C:I X:O VDD:B VSS:B
MN2 net1 C VSS VSS sg13_lv_nmos m=1 w=550.00n l=130.00n ng=1
MN3 X net1 VSS VSS sg13_lv_nmos m=1 w=1.48u l=130.00n ng=2
MN1 net1 B VSS VSS sg13_lv_nmos m=1 w=550.00n l=130.00n ng=1
MN0 net1 A VSS VSS sg13_lv_nmos m=1 w=550.00n l=130.00n ng=1
MP3 X net1 VDD VDD sg13_lv_pmos m=1 w=2.24u l=130.00n ng=2
MP1 net9 B net12 VDD sg13_lv_pmos m=1 w=1.000u l=130.00n ng=1
MP0 net12 A VDD VDD sg13_lv_pmos m=1 w=1.000u l=130.00n ng=1
MP2 net1 C net9 VDD sg13_lv_pmos m=1 w=1.000u l=130.00n ng=1
.ENDS

************************************************************************
* Library Name: sg13cmos5l_stdcell
* Cell Name:    sg13cmos5l_or4_1
* View Name:    schematic
************************************************************************

.SUBCKT sg13cmos5l_or4_1 X A B C D VDD VSS
*.PININFO A:I B:I C:I D:I X:O VDD:B VSS:B
MN4 X net1 VSS VSS sg13_lv_nmos m=1 w=740.00n l=130.00n ng=1
MN3 net1 D VSS VSS sg13_lv_nmos m=1 w=550.00n l=130.00n ng=1
MN2 net1 C VSS VSS sg13_lv_nmos m=1 w=550.00n l=130.00n ng=1
MN1 net1 B VSS VSS sg13_lv_nmos m=1 w=550.00n l=130.00n ng=1
MN0 net1 A VSS VSS sg13_lv_nmos m=1 w=550.00n l=130.00n ng=1
MP0 net4 A VDD VDD sg13_lv_pmos m=1 w=1.000u l=130.00n ng=1
MP1 net3 B net4 VDD sg13_lv_pmos m=1 w=1.000u l=130.00n ng=1
MP2 net2 C net3 VDD sg13_lv_pmos m=1 w=1.000u l=130.00n ng=1
MP3 net1 D net2 VDD sg13_lv_pmos m=1 w=1.000u l=130.00n ng=1
MP4 X net1 VDD VDD sg13_lv_pmos m=1 w=1.12u l=130.00n ng=1
.ENDS

************************************************************************
* Library Name: sg13cmos5l_stdcell
* Cell Name:    sg13cmos5l_or4_2
* View Name:    schematic
************************************************************************

.SUBCKT sg13cmos5l_or4_2 X A B C D VDD VSS
*.PININFO A:I B:I C:I D:I X:O VDD:B VSS:B
MN4 X net1 VSS VSS sg13_lv_nmos m=1 w=1.48u l=130.00n ng=2
MN3 net1 D VSS VSS sg13_lv_nmos m=1 w=550.00n l=130.00n ng=1
MN2 net1 C VSS VSS sg13_lv_nmos m=1 w=550.00n l=130.00n ng=1
MN1 net1 B VSS VSS sg13_lv_nmos m=1 w=550.00n l=130.00n ng=1
MN0 net1 A VSS VSS sg13_lv_nmos m=1 w=550.00n l=130.00n ng=1
MP0 net4 A VDD VDD sg13_lv_pmos m=1 w=1.000u l=130.00n ng=1
MP1 net3 B net4 VDD sg13_lv_pmos m=1 w=1.000u l=130.00n ng=1
MP2 net2 C net3 VDD sg13_lv_pmos m=1 w=1.000u l=130.00n ng=1
MP3 net1 D net2 VDD sg13_lv_pmos m=1 w=1.000u l=130.00n ng=1
MP4 X net1 VDD VDD sg13_lv_pmos m=1 w=2.24u l=130.00n ng=2
.ENDS

************************************************************************
* Library Name: sg13cmos5l_stdcell
* Cell Name:    sg13cmos5l_sdfbbp_1
* View Name:    schematic
************************************************************************

.SUBCKT sg13cmos5l_sdfbbp_1 Q Q_N CLK D RESET_B SCD SCE SET_B VDD VSS
*.PININFO CLK:I D:I RESET_B:I SCD:I SCE:I SET_B:I Q:O Q_N:O VDD:B VSS:B
MP1 resetbb RESET_B VDD VDD sg13_lv_pmos m=1 w=640.00n l=130.00n ng=1
MP19 pre_q DbbLatch2 net8 VDD sg13_lv_pmos m=1 w=1.000u l=130.00n ng=1
MP20 pre_q SET_B VDD VDD sg13_lv_pmos m=1 w=1.000u l=130.00n ng=1
MP3 CLKbb CLKb VDD VDD sg13_lv_pmos m=1 w=1.12u l=130.00n ng=1
MP0 SCEb SCE VDD VDD sg13_lv_pmos m=1 w=640.00n l=130.00n ng=1
MP7 Db D net3 VDD sg13_lv_pmos m=1 w=640.00n l=130.00n ng=1
MP13 DbbTG CLKb net10 VDD sg13_lv_pmos m=1 w=420.00n l=130.00n ng=1
MP12 net10 DbLatchM VDD VDD sg13_lv_pmos m=1 w=420.00n l=130.00n ng=1
MP6 net3 SCE VDD VDD sg13_lv_pmos m=1 w=640.00n l=130.00n ng=1
MP21 Q_N pre_q VDD VDD sg13_lv_pmos m=1 w=1.12u l=130.00n ng=1
MP14 net1 DbLatchM VDD VDD sg13_lv_pmos m=1 w=840.00n l=130.00n ng=1
MP18 net8 resetbb VDD VDD sg13_lv_pmos m=1 w=1.000u l=130.00n ng=1
MP11 DbLatchM SET_B VDD VDD sg13_lv_pmos m=1 w=840.00n l=130.00n ng=1
MP4 net2 SCD VDD VDD sg13_lv_pmos m=1 w=640.00n l=130.00n ng=1
MP2 CLKb CLK VDD VDD sg13_lv_pmos m=1 w=1.12u l=130.00n ng=1
MP10 DbLatchM DbbTG net7 VDD sg13_lv_pmos m=1 w=840.00n l=130.00n ng=1
MP8 Db CLKbb DbbTG VDD sg13_lv_pmos m=1 w=640.00n l=130.00n ng=1
MP5 Db SCEb net2 VDD sg13_lv_pmos m=1 w=640.00n l=130.00n ng=1
MP22 pre_qb pre_q VDD VDD sg13_lv_pmos m=1 w=840.00n l=130.00n ng=1
MP9 net7 resetbb VDD VDD sg13_lv_pmos m=1 w=840.00n l=130.00n ng=1
MP16 net6 pre_q VDD VDD sg13_lv_pmos m=1 w=420.00n l=130.00n ng=1
MP17 DbbLatch2 CLKbb net6 VDD sg13_lv_pmos m=1 w=420.00n l=130.00n ng=1
MP15 DbbLatch2 CLKb net1 VDD sg13_lv_pmos m=1 w=840.00n l=130.00n ng=1
MP23 Q pre_qb VDD VDD sg13_lv_pmos m=1 w=1.12u l=130.00n ng=1
MN4 Db SCE net5 VSS sg13_lv_nmos m=1 w=420.00n l=130.00n ng=1
MN5 net5 SCD VSS VSS sg13_lv_nmos m=1 w=420.00n l=130.00n ng=1
MN18 pre_q DbbLatch2 net11 VSS sg13_lv_nmos m=1 w=740.00n l=130.00n ng=1
MN8 Db CLKb DbbTG VSS sg13_lv_nmos m=1 w=420.00n l=130.00n ng=1
MN7 net4 SCEb VSS VSS sg13_lv_nmos m=1 w=420.00n l=130.00n ng=1
MN3 CLKbb CLKb VSS VSS sg13_lv_nmos m=1 w=740.00n l=130.00n ng=1
MN1 resetbb RESET_B VSS VSS sg13_lv_nmos m=1 w=420.00n l=130.00n ng=1
MN17 net14 pre_q VSS VSS sg13_lv_nmos m=1 w=420.00n l=130.00n ng=1
MN9 DbLatchM DbbTG net12 VSS sg13_lv_nmos m=1 w=550.00n l=130.00n ng=1
MN0 SCEb SCE VSS VSS sg13_lv_nmos m=1 w=420.00n l=130.00n ng=1
MN10 net12 SET_B VSS VSS sg13_lv_nmos m=1 w=550.00n l=130.00n ng=1
MN13 net15 DbLatchM VSS VSS sg13_lv_nmos m=1 w=420.00n l=130.00n ng=1
MN19 net11 SET_B VSS VSS sg13_lv_nmos m=1 w=740.00n l=130.00n ng=1
MN12 DbbTG CLKbb net15 VSS sg13_lv_nmos m=1 w=420.00n l=130.00n ng=1
MN6 Db D net4 VSS sg13_lv_nmos m=1 w=420.00n l=130.00n ng=1
MN22 pre_qb pre_q VSS VSS sg13_lv_nmos m=1 w=550.00n l=130.00n ng=1
MN16 DbbLatch2 CLKb net14 VSS sg13_lv_nmos m=1 w=420.00n l=130.00n ng=1
MN23 Q pre_qb VSS VSS sg13_lv_nmos m=1 w=740.00n l=130.00n ng=1
MN15 net13 DbLatchM VSS VSS sg13_lv_nmos m=1 w=550.00n l=130.00n ng=1
MN2 CLKb CLK VSS VSS sg13_lv_nmos m=1 w=740.00n l=130.00n ng=1
MN14 DbbLatch2 CLKbb net13 VSS sg13_lv_nmos m=1 w=550.00n l=130.00n ng=1
MN11 DbLatchM resetbb net12 VSS sg13_lv_nmos m=1 w=550.00n l=130.00n ng=1
MN21 Q_N pre_q VSS VSS sg13_lv_nmos m=1 w=740.00n l=130.00n ng=1
MN20 pre_q resetbb net11 VSS sg13_lv_nmos m=1 w=740.00n l=130.00n ng=1
.ENDS

************************************************************************
* Library Name: sg13cmos5l_stdcell
* Cell Name:    sg13cmos5l_sighold
* View Name:    schematic
************************************************************************

.SUBCKT sg13cmos5l_sighold SH VDD VSS
*.PININFO SH:B VDD:B VSS:B
MN1 net1 SH VSS VSS sg13_lv_nmos m=1 w=300.0n l=130.00n ng=1
MN0 SH net1 VSS VSS sg13_lv_nmos m=1 w=300.0n l=700.0n ng=1
MP1 net1 SH VDD VDD sg13_lv_pmos m=1 w=450.00n l=130.00n ng=1
MP0 SH net1 VDD VDD sg13_lv_pmos m=1 w=300.0n l=700.0n ng=1
.ENDS

************************************************************************
* Library Name: sg13cmos5l_stdcell
* Cell Name:    sg13cmos5l_slgcp_1
* View Name:    schematic
************************************************************************

.SUBCKT sg13cmos5l_slgcp_1 GCLK CLK GATE SCE VDD VSS
*.PININFO CLK:I GATE:I SCE:I GCLK:O VDD:B VSS:B
MP10 GCLK net5 VDD VDD sg13_lv_pmos m=1 w=1.12u l=130.00n ng=1
MP4 net1 CLKbb net6 VDD sg13_lv_pmos m=1 w=840.00n l=130.00n ng=1
MP1 CLKbb CLKb VDD VDD sg13_lv_pmos m=1 w=840.00n l=130.00n ng=1
MP8 net5 int_GATE VDD VDD sg13_lv_pmos m=1 w=840.00n l=130.00n ng=1
MP2 net3 SCE VDD VDD sg13_lv_pmos m=1 w=840.00n l=130.00n ng=1
MP7 net6 CLKb net4 VDD sg13_lv_pmos m=1 w=420.00n l=130.00n ng=1
MP5 int_GATE net6 VDD VDD sg13_lv_pmos m=1 w=1.12u l=130.00n ng=1
MP0 CLKb CLK VDD VDD sg13_lv_pmos m=1 w=840.00n l=130.00n ng=1
MP9 net5 CLK VDD VDD sg13_lv_pmos m=1 w=840.00n l=130.00n ng=1
MP6 net4 int_GATE VDD VDD sg13_lv_pmos m=1 w=420.00n l=130.00n ng=1
MP3 net1 GATE net3 VDD sg13_lv_pmos m=1 w=840.00n l=130.00n ng=1
MN5 int_GATE net6 VSS VSS sg13_lv_nmos m=1 w=740.00n l=130.00n ng=1
MN9 net2 CLK VSS VSS sg13_lv_nmos m=1 w=640.00n l=130.00n ng=1
MN2 net1 SCE VSS VSS sg13_lv_nmos m=1 w=550.00n l=130.00n ng=1
MN4 net6 CLKb net1 VSS sg13_lv_nmos m=1 w=550.00n l=130.00n ng=1
MN7 net7 int_GATE VSS VSS sg13_lv_nmos m=1 w=420.00n l=130.00n ng=1
MN8 net5 int_GATE net2 VSS sg13_lv_nmos m=1 w=640.00n l=130.00n ng=1
MN10 GCLK net5 VSS VSS sg13_lv_nmos m=1 w=740.00n l=130.00n ng=1
MN1 CLKbb CLKb VSS VSS sg13_lv_nmos m=1 w=740.00n l=130.00n ng=1
MN3 net1 GATE VSS VSS sg13_lv_nmos m=1 w=550.00n l=130.00n ng=1
MN0 CLKb CLK VSS VSS sg13_lv_nmos m=1 w=740.00n l=130.00n ng=1
MN6 net6 CLKbb net7 VSS sg13_lv_nmos m=1 w=420.00n l=130.00n ng=1
.ENDS

************************************************************************
* Library Name: sg13cmos5l_stdcell
* Cell Name:    sg13cmos5l_tiehi
* View Name:    schematic
************************************************************************

.SUBCKT sg13cmos5l_tiehi L_HI VDD VSS
*.PININFO L_HI:O VDD:B VSS:B
MN1 net3 net2 VSS VSS sg13_lv_nmos m=1 w=795.00n l=130.00n ng=1
MN0 net1 net1 VSS VSS sg13_lv_nmos m=1 w=300n l=130.00n ng=1
MP1 L_HI net3 VDD VDD sg13_lv_pmos m=1 w=1.155u l=130.00n ng=1
MP0 net2 net1 VDD VDD sg13_lv_pmos m=1 w=660.0n l=130.00n ng=1
.ENDS

************************************************************************
* Library Name: sg13cmos5l_stdcell
* Cell Name:    sg13cmos5l_tielo
* View Name:    schematic
************************************************************************

.SUBCKT sg13cmos5l_tielo L_LO VDD VSS
*.PININFO L_LO:O VDD:B VSS:B
MN0 net3 net2 VSS VSS sg13_lv_nmos m=1 w=385.00n l=130.00n ng=1
MN1 L_LO net1 VSS VSS sg13_lv_nmos m=1 w=880.0n l=130.00n ng=1
MP0 net2 net2 VDD VDD sg13_lv_pmos m=1 w=300n l=130.00n ng=1
MP1 net1 net3 VDD VDD sg13_lv_pmos m=1 w=1.045u l=130.00n ng=1
.ENDS

************************************************************************
* Library Name: sg13cmos5l_stdcell
* Cell Name:    sg13cmos5l_xnor2_1
* View Name:    schematic
************************************************************************

.SUBCKT sg13cmos5l_xnor2_1 Y A B VDD VSS
*.PININFO A:I B:I Y:O VDD:B VSS:B
MP4 Y net1 VDD VDD sg13_lv_pmos m=1 w=1.12u l=130.00n ng=1
MP3 Y B net4 VDD sg13_lv_pmos m=1 w=1.12u l=130.00n ng=1
MP2 net4 A VDD VDD sg13_lv_pmos m=1 w=1.12u l=130.00n ng=1
MP1 net1 B VDD VDD sg13_lv_pmos m=1 w=840.00n l=130.00n ng=1
MP0 net1 A VDD VDD sg13_lv_pmos m=1 w=840.00n l=130.00n ng=1
MN3 Y net1 net3 VSS sg13_lv_nmos m=1 w=740.00n l=130.00n ng=1
MN1 net2 A VSS VSS sg13_lv_nmos m=1 w=640.00n l=130.00n ng=1
MN0 net1 B net2 VSS sg13_lv_nmos m=1 w=640.00n l=130.00n ng=1
MN4 net3 B VSS VSS sg13_lv_nmos m=1 w=740.00n l=130.00n ng=1
MN2 net3 A VSS VSS sg13_lv_nmos m=1 w=740.00n l=130.00n ng=1
.ENDS

************************************************************************
* Library Name: sg13cmos5l_stdcell
* Cell Name:    sg13cmos5l_xor2_1
* View Name:    schematic
************************************************************************

.SUBCKT sg13cmos5l_xor2_1 X A B VDD VSS
*.PININFO A:I B:I X:O VDD:B VSS:B
MN0 net1 A VSS VSS sg13_lv_nmos m=1 w=550.00n l=130.00n ng=1
MN3 X B net3 VSS sg13_lv_nmos m=1 w=740.00n l=130.00n ng=1
MN2 X net1 VSS VSS sg13_lv_nmos m=1 w=740.00n l=130.00n ng=1
MN4 net3 A VSS VSS sg13_lv_nmos m=1 w=740.00n l=130.00n ng=1
MN1 net1 B VSS VSS sg13_lv_nmos m=1 w=550.00n l=130.00n ng=1
MP0 net6 A VDD VDD sg13_lv_pmos m=1 w=1.000u l=130.00n ng=1
MP1 net1 B net6 VDD sg13_lv_pmos m=1 w=1.000u l=130.00n ng=1
MP2 net5 A VDD VDD sg13_lv_pmos m=1 w=1.12u l=130.00n ng=1
MP4 net5 B VDD VDD sg13_lv_pmos m=1 w=1.12u l=130.00n ng=1
MP3 X net1 net5 VDD sg13_lv_pmos m=1 w=1.12u l=130.00n ng=1
.ENDS

************************************************************************
* Library Name: sg13cmos5l_stdcell
* Cell Name:    sg13cmos5l_a22oi_1
* View Name:    schematic
************************************************************************

.SUBCKT sg13cmos5l_a22oi_1 Y A1 A2 B1 B2 VDD VSS
*.PININFO A1:I A2:I B1:I B2:I Y:O VDD:B VSS:B
MN1 net1 B1 VSS VSS sg13_lv_nmos m=1 w=740.00n l=130.00n ng=1
MN0 Y B2 net1 VSS sg13_lv_nmos m=1 w=740.00n l=130.00n ng=1
MN3 net2 A2 VSS VSS sg13_lv_nmos m=1 w=740.00n l=130.00n ng=1
MN2 Y A1 net2 VSS sg13_lv_nmos m=1 w=740.00n l=130.00n ng=1
MP1 Y B1 net3 VDD sg13_lv_pmos m=1 w=1.12u l=130.00n ng=1
MP3 Y B2 net3 VDD sg13_lv_pmos m=1 w=1.12u l=130.00n ng=1
MP2 net3 A2 VDD VDD sg13_lv_pmos m=1 w=1.12u l=130.00n ng=1
MP0 net3 A1 VDD VDD sg13_lv_pmos m=1 w=1.12u l=130.00n ng=1
.ENDS

************************************************************************
* Library Name: sg13cmos5l_stdcell
* Cell Name:    sg13cmos5l_sdfrbpq_1
* View Name:    schematic
************************************************************************

.SUBCKT sg13cmos5l_sdfrbpq_1 Q CLK D RESET_B SCD SCE VDD VSS
*.PININFO CLK:I D:I RESET_B:I SCD:I SCE:I Q:O VDD:B VSS:B
MN3 Db SCD net63 VSS sg13_lv_nmos m=1 w=740.00n l=130.00n ng=1
MN1 Db D net65 VSS sg13_lv_nmos m=1 w=740.00n l=130.00n ng=1
MN0 SCEb SCE VSS VSS sg13_lv_nmos m=1 w=550.00n l=130.00n ng=1
MN4 net63 SCE VSS VSS sg13_lv_nmos m=1 w=740.00n l=130.00n ng=1
MN2 net65 SCEb VSS VSS sg13_lv_nmos m=1 w=740.00n l=130.00n ng=1
MN17 net12 net2 VSS VSS sg13_lv_nmos m=1 w=420.00n l=130.00n ng=1
MN16 net5 clkneg net12 VSS sg13_lv_nmos m=1 w=420.00n l=130.00n ng=1
MN18 net2 net5 net11 VSS sg13_lv_nmos m=1 w=420.00n l=130.00n ng=1
MN19 net11 RESET_B VSS VSS sg13_lv_nmos m=1 w=420.00n l=130.00n ng=1
MN20 Q net2 VSS VSS sg13_lv_nmos m=1 w=740.00n l=130.00n ng=1
MN6 Dbbb Dbb net10 VSS sg13_lv_nmos m=1 w=420.00n l=130.00n ng=1
MN7 net10 RESET_B VSS VSS sg13_lv_nmos m=1 w=420.00n l=130.00n ng=1
MN10 Dbbb clkneg net6 VSS sg13_lv_nmos m=1 w=420.00n l=130.00n ng=1
MN11 net6 clkpos net9 VSS sg13_lv_nmos m=1 w=420.00n l=130.00n ng=1
MN12 net9 net4 net8 VSS sg13_lv_nmos m=1 w=420.00n l=130.00n ng=1
MN13 net8 RESET_B VSS VSS sg13_lv_nmos m=1 w=420.00n l=130.00n ng=1
MN14 net4 net6 VSS VSS sg13_lv_nmos m=1 w=740.00n l=130.00n ng=1
MN8 clkneg CLK VSS VSS sg13_lv_nmos m=1 w=740.00n l=130.00n ng=1
MN15 net4 clkpos net5 VSS sg13_lv_nmos m=1 w=740.00n l=130.00n ng=1
MN9 clkpos clkneg VSS VSS sg13_lv_nmos m=1 w=740.00n l=130.00n ng=1
MN5 Dbb Db VSS VSS sg13_lv_nmos m=1 w=740.00n l=130.00n ng=1
MP1 net64 SCE VDD VDD sg13_lv_pmos m=1 w=1.000u l=130.00n ng=1
MP3 net62 SCEb VDD VDD sg13_lv_pmos m=1 w=1.000u l=130.00n ng=1
MP0 SCEb SCE VDD VDD sg13_lv_pmos m=1 w=840.00n l=130.00n ng=1
MP4 Db SCD net62 VDD sg13_lv_pmos m=1 w=1.000u l=130.00n ng=1
MP2 Db D net64 VDD sg13_lv_pmos m=1 w=1.000u l=130.00n ng=1
MP17 net5 clkpos net3 VDD sg13_lv_pmos m=1 w=420.00n l=130.00n ng=1
MP18 net2 net5 VDD VDD sg13_lv_pmos m=1 w=420.00n l=130.00n ng=1
MP19 net2 RESET_B VDD VDD sg13_lv_pmos m=1 w=420.00n l=130.00n ng=1
MP20 Q net2 VDD VDD sg13_lv_pmos m=1 w=1.12u l=130.00n ng=1
MP10 Dbbb clkpos net6 VDD sg13_lv_pmos m=1 w=420.00n l=130.00n ng=1
MP6 Dbbb RESET_B VDD VDD sg13_lv_pmos m=1 w=420.00n l=130.00n ng=1
MP7 Dbbb Dbb VDD VDD sg13_lv_pmos m=1 w=420.00n l=130.00n ng=1
MP11 net7 net4 VDD VDD sg13_lv_pmos m=1 w=420.00n l=130.00n ng=1
MP12 net6 clkneg net7 VDD sg13_lv_pmos m=1 w=420.00n l=130.00n ng=1
MP13 net6 RESET_B VDD VDD sg13_lv_pmos m=1 w=420.00n l=130.00n ng=1
MP8 clkneg CLK VDD VDD sg13_lv_pmos m=1 w=1.12u l=130.00n ng=1
MP9 clkpos clkneg VDD VDD sg13_lv_pmos m=1 w=1.12u l=130.00n ng=1
MP14 net4 net6 VDD VDD sg13_lv_pmos m=1 w=1.000u l=130.00n ng=1
MP15 net4 clkneg net5 VDD sg13_lv_pmos m=1 w=1.000u l=130.00n ng=1
MP5 Dbb Db VDD VDD sg13_lv_pmos m=1 w=1.12u l=130.00n ng=1
MP16 net3 net2 VDD VDD sg13_lv_pmos m=1 w=420.00n l=130.00n ng=1
.ENDS

************************************************************************
* Library Name: sg13cmos5l_stdcell
* Cell Name:    sg13cmos5l_sdfrbpq_2
* View Name:    schematic
************************************************************************

.SUBCKT sg13cmos5l_sdfrbpq_2 Q CLK D RESET_B SCD SCE VDD VSS
*.PININFO CLK:I D:I RESET_B:I SCD:I SCE:I Q:O VDD:B VSS:B
MN3 Db SCD net63 VSS sg13_lv_nmos m=1 w=740.00n l=130.00n ng=1
MN1 Db D net65 VSS sg13_lv_nmos m=1 w=740.00n l=130.00n ng=1
MN0 SCEb SCE VSS VSS sg13_lv_nmos m=1 w=550.00n l=130.00n ng=1
MN4 net63 SCE VSS VSS sg13_lv_nmos m=1 w=740.00n l=130.00n ng=1
MN2 net65 SCEb VSS VSS sg13_lv_nmos m=1 w=740.00n l=130.00n ng=1
MN5 Dbb Db VSS VSS sg13_lv_nmos m=1 w=740.00n l=130.00n ng=1
MN17 net12 net2 VSS VSS sg13_lv_nmos m=1 w=420.00n l=130.00n ng=1
MN16 net5 clkneg net12 VSS sg13_lv_nmos m=1 w=420.00n l=130.00n ng=1
MN18 net2 net5 net11 VSS sg13_lv_nmos m=1 w=420.00n l=130.00n ng=1
MN19 net11 RESET_B VSS VSS sg13_lv_nmos m=1 w=420.00n l=130.00n ng=1
MN20 Q net2 VSS VSS sg13_lv_nmos m=1 w=1.48u l=130.00n ng=2
MN6 Dbbb Dbb net10 VSS sg13_lv_nmos m=1 w=420.00n l=130.00n ng=1
MN7 net10 RESET_B VSS VSS sg13_lv_nmos m=1 w=420.00n l=130.00n ng=1
MN10 Dbbb clkneg net6 VSS sg13_lv_nmos m=1 w=420.00n l=130.00n ng=1
MN11 net6 clkpos net9 VSS sg13_lv_nmos m=1 w=420.00n l=130.00n ng=1
MN12 net9 net4 net8 VSS sg13_lv_nmos m=1 w=420.00n l=130.00n ng=1
MN13 net8 RESET_B VSS VSS sg13_lv_nmos m=1 w=420.00n l=130.00n ng=1
MN14 net4 net6 VSS VSS sg13_lv_nmos m=1 w=740.00n l=130.00n ng=1
MN8 clkneg CLK VSS VSS sg13_lv_nmos m=1 w=740.00n l=130.00n ng=1
MN15 net4 clkpos net5 VSS sg13_lv_nmos m=1 w=740.00n l=130.00n ng=1
MN9 clkpos clkneg VSS VSS sg13_lv_nmos m=1 w=740.00n l=130.00n ng=1
MP1 net64 SCE VDD VDD sg13_lv_pmos m=1 w=1.000u l=130.00n ng=1
MP3 net62 SCEb VDD VDD sg13_lv_pmos m=1 w=1.000u l=130.00n ng=1
MP0 SCEb SCE VDD VDD sg13_lv_pmos m=1 w=840.00n l=130.00n ng=1
MP4 Db SCD net62 VDD sg13_lv_pmos m=1 w=1.000u l=130.00n ng=1
MP2 Db D net64 VDD sg13_lv_pmos m=1 w=1.000u l=130.00n ng=1
MP5 Dbb Db VDD VDD sg13_lv_pmos m=1 w=1.12u l=130.00n ng=1
MP17 net5 clkpos net3 VDD sg13_lv_pmos m=1 w=420.00n l=130.00n ng=1
MP18 net2 net5 VDD VDD sg13_lv_pmos m=1 w=420.00n l=130.00n ng=1
MP19 net2 RESET_B VDD VDD sg13_lv_pmos m=1 w=420.00n l=130.00n ng=1
MP20 Q net2 VDD VDD sg13_lv_pmos m=1 w=2.24u l=130.00n ng=2
MP10 Dbbb clkpos net6 VDD sg13_lv_pmos m=1 w=420.00n l=130.00n ng=1
MP6 Dbbb RESET_B VDD VDD sg13_lv_pmos m=1 w=420.00n l=130.00n ng=1
MP7 Dbbb Dbb VDD VDD sg13_lv_pmos m=1 w=420.00n l=130.00n ng=1
MP11 net7 net4 VDD VDD sg13_lv_pmos m=1 w=420.00n l=130.00n ng=1
MP12 net6 clkneg net7 VDD sg13_lv_pmos m=1 w=420.00n l=130.00n ng=1
MP13 net6 RESET_B VDD VDD sg13_lv_pmos m=1 w=420.00n l=130.00n ng=1
MP8 clkneg CLK VDD VDD sg13_lv_pmos m=1 w=1.12u l=130.00n ng=1
MP9 clkpos clkneg VDD VDD sg13_lv_pmos m=1 w=1.12u l=130.00n ng=1
MP14 net4 net6 VDD VDD sg13_lv_pmos m=1 w=1.000u l=130.00n ng=1
MP15 net4 clkneg net5 VDD sg13_lv_pmos m=1 w=1.000u l=130.00n ng=1
MP16 net3 net2 VDD VDD sg13_lv_pmos m=1 w=420.00n l=130.00n ng=1
.ENDS

************************************************************************
* Library Name: sg13cmos5l_stdcell
* Cell Name:    sg13cmos5l_sdfrbp_2
* View Name:    schematic
************************************************************************

.SUBCKT sg13cmos5l_sdfrbp_2 Q Q_N CLK D RESET_B SCD SCE VDD VSS
*.PININFO CLK:I D:I RESET_B:I SCD:I SCE:I Q:O Q_N:O VDD:B VSS:B
MN3 Db SCD net63 VSS sg13_lv_nmos m=1 w=740.00n l=130.00n ng=1
MN1 Db D net65 VSS sg13_lv_nmos m=1 w=740.00n l=130.00n ng=1
MN0 SCEb SCE VSS VSS sg13_lv_nmos m=1 w=550.00n l=130.00n ng=1
MN4 net63 SCE VSS VSS sg13_lv_nmos m=1 w=740.00n l=130.00n ng=1
MN2 net65 SCEb VSS VSS sg13_lv_nmos m=1 w=740.00n l=130.00n ng=1
MN5 Dbb Db VSS VSS sg13_lv_nmos m=1 w=740.00n l=130.00n ng=1
MN17 net12 net2 VSS VSS sg13_lv_nmos m=1 w=420.00n l=130.00n ng=1
MN16 net5 clkneg net12 VSS sg13_lv_nmos m=1 w=420.00n l=130.00n ng=1
MN18 net2 net5 net11 VSS sg13_lv_nmos m=1 w=420.00n l=130.00n ng=1
MN19 net11 RESET_B VSS VSS sg13_lv_nmos m=1 w=420.00n l=130.00n ng=1
MN20 Q_N net5 VSS VSS sg13_lv_nmos m=1 w=1.48u l=130.00n ng=2
MN6 Dbbb Dbb net10 VSS sg13_lv_nmos m=1 w=420.00n l=130.00n ng=1
MN7 net10 RESET_B VSS VSS sg13_lv_nmos m=1 w=420.00n l=130.00n ng=1
MN10 Dbbb clkneg net6 VSS sg13_lv_nmos m=1 w=420.00n l=130.00n ng=1
MN11 net6 clkpos net9 VSS sg13_lv_nmos m=1 w=420.00n l=130.00n ng=1
MN12 net9 net4 net8 VSS sg13_lv_nmos m=1 w=420.00n l=130.00n ng=1
MN13 net8 RESET_B VSS VSS sg13_lv_nmos m=1 w=420.00n l=130.00n ng=1
MN14 net4 net6 VSS VSS sg13_lv_nmos m=1 w=740.00n l=130.00n ng=1
MN8 clkneg CLK VSS VSS sg13_lv_nmos m=1 w=740.00n l=130.00n ng=1
MN15 net4 clkpos net5 VSS sg13_lv_nmos m=1 w=740.00n l=130.00n ng=1
MN9 clkpos clkneg VSS VSS sg13_lv_nmos m=1 w=740.00n l=130.00n ng=1
MN22 Q net1 VSS VSS sg13_lv_nmos m=1 w=1.48u l=130.00n ng=2
MN21 net1 net5 VSS VSS sg13_lv_nmos m=1 w=640.00n l=130.00n ng=1
MP1 net64 SCE VDD VDD sg13_lv_pmos m=1 w=1.000u l=130.00n ng=1
MP3 net62 SCEb VDD VDD sg13_lv_pmos m=1 w=1.000u l=130.00n ng=1
MP0 SCEb SCE VDD VDD sg13_lv_pmos m=1 w=840.00n l=130.00n ng=1
MP4 Db SCD net62 VDD sg13_lv_pmos m=1 w=1.000u l=130.00n ng=1
MP2 Db D net64 VDD sg13_lv_pmos m=1 w=1.000u l=130.00n ng=1
MP5 Dbb Db VDD VDD sg13_lv_pmos m=1 w=1.12u l=130.00n ng=1
MP17 net5 clkpos net3 VDD sg13_lv_pmos m=1 w=420.00n l=130.00n ng=1
MP18 net2 net5 VDD VDD sg13_lv_pmos m=1 w=420.00n l=130.00n ng=1
MP19 net2 RESET_B VDD VDD sg13_lv_pmos m=1 w=420.00n l=130.00n ng=1
MP20 Q_N net5 VDD VDD sg13_lv_pmos m=1 w=2.24u l=130.00n ng=2
MP10 Dbbb clkpos net6 VDD sg13_lv_pmos m=1 w=420.00n l=130.00n ng=1
MP6 Dbbb RESET_B VDD VDD sg13_lv_pmos m=1 w=420.00n l=130.00n ng=1
MP7 Dbbb Dbb VDD VDD sg13_lv_pmos m=1 w=420.00n l=130.00n ng=1
MP11 net7 net4 VDD VDD sg13_lv_pmos m=1 w=420.00n l=130.00n ng=1
MP12 net6 clkneg net7 VDD sg13_lv_pmos m=1 w=420.00n l=130.00n ng=1
MP13 net6 RESET_B VDD VDD sg13_lv_pmos m=1 w=420.00n l=130.00n ng=1
MP8 clkneg CLK VDD VDD sg13_lv_pmos m=1 w=1.12u l=130.00n ng=1
MP9 clkpos clkneg VDD VDD sg13_lv_pmos m=1 w=1.12u l=130.00n ng=1
MP14 net4 net6 VDD VDD sg13_lv_pmos m=1 w=1.000u l=130.00n ng=1
MP15 net4 clkneg net5 VDD sg13_lv_pmos m=1 w=1.000u l=130.00n ng=1
MP22 Q net1 VDD VDD sg13_lv_pmos m=1 w=2.24u l=130.00n ng=2
MP16 net3 net2 VDD VDD sg13_lv_pmos m=1 w=420.00n l=130.00n ng=1
MP21 net1 net5 VDD VDD sg13_lv_pmos m=1 w=1.000u l=130.00n ng=1
.ENDS

************************************************************************
* Library Name: sg13cmos5l_stdcell
* Cell Name:    sg13cmos5l_sdfrbp_1
* View Name:    schematic
************************************************************************

.SUBCKT sg13cmos5l_sdfrbp_1 Q Q_N CLK D RESET_B SCD SCE VDD VSS
*.PININFO CLK:I D:I RESET_B:I SCD:I SCE:I Q:O Q_N:O VDD:B VSS:B
MN3 Db SCD net63 VSS sg13_lv_nmos m=1 w=740.00n l=130.00n ng=1
MN1 Db D net65 VSS sg13_lv_nmos m=1 w=740.00n l=130.00n ng=1
MN0 SCEb SCE VSS VSS sg13_lv_nmos m=1 w=550.00n l=130.00n ng=1
MN4 net63 SCE VSS VSS sg13_lv_nmos m=1 w=740.00n l=130.00n ng=1
MN2 net65 SCEb VSS VSS sg13_lv_nmos m=1 w=740.00n l=130.00n ng=1
MN5 net13 Db VSS VSS sg13_lv_nmos m=1 w=740.00n l=130.00n ng=1
MN17 net12 net2 VSS VSS sg13_lv_nmos m=1 w=420.00n l=130.00n ng=1
MN16 net5 clkneg net12 VSS sg13_lv_nmos m=1 w=420.00n l=130.00n ng=1
MN18 net2 net5 net11 VSS sg13_lv_nmos m=1 w=420.00n l=130.00n ng=1
MN19 net11 RESET_B VSS VSS sg13_lv_nmos m=1 w=420.00n l=130.00n ng=1
MN20 Q_N net5 VSS VSS sg13_lv_nmos m=1 w=740.00n l=130.00n ng=1
MN6 Dbb net13 net10 VSS sg13_lv_nmos m=1 w=420.00n l=130.00n ng=1
MN7 net10 RESET_B VSS VSS sg13_lv_nmos m=1 w=420.00n l=130.00n ng=1
MN10 Dbb clkneg net6 VSS sg13_lv_nmos m=1 w=420.00n l=130.00n ng=1
MN11 net6 clkpos net9 VSS sg13_lv_nmos m=1 w=420.00n l=130.00n ng=1
MN12 net9 net4 net8 VSS sg13_lv_nmos m=1 w=420.00n l=130.00n ng=1
MN13 net8 RESET_B VSS VSS sg13_lv_nmos m=1 w=420.00n l=130.00n ng=1
MN14 net4 net6 VSS VSS sg13_lv_nmos m=1 w=740.00n l=130.00n ng=1
MN8 clkneg CLK VSS VSS sg13_lv_nmos m=1 w=740.00n l=130.00n ng=1
MN15 net4 clkpos net5 VSS sg13_lv_nmos m=1 w=740.00n l=130.00n ng=1
MN9 clkpos clkneg VSS VSS sg13_lv_nmos m=1 w=740.00n l=130.00n ng=1
MN22 Q net1 VSS VSS sg13_lv_nmos m=1 w=740.00n l=130.00n ng=1
MN21 net1 net5 VSS VSS sg13_lv_nmos m=1 w=640.00n l=130.00n ng=1
MP1 net64 SCE VDD VDD sg13_lv_pmos m=1 w=1.000u l=130.00n ng=1
MP3 net62 SCEb VDD VDD sg13_lv_pmos m=1 w=1.000u l=130.00n ng=1
MP0 SCEb SCE VDD VDD sg13_lv_pmos m=1 w=840.00n l=130.00n ng=1
MP4 Db SCD net62 VDD sg13_lv_pmos m=1 w=1.000u l=130.00n ng=1
MP2 Db D net64 VDD sg13_lv_pmos m=1 w=1.000u l=130.00n ng=1
MP5 net13 Db VDD VDD sg13_lv_pmos m=1 w=1.12u l=130.00n ng=1
MP17 net5 clkpos net3 VDD sg13_lv_pmos m=1 w=420.00n l=130.00n ng=1
MP18 net2 net5 VDD VDD sg13_lv_pmos m=1 w=420.00n l=130.00n ng=1
MP19 net2 RESET_B VDD VDD sg13_lv_pmos m=1 w=420.00n l=130.00n ng=1
MP20 Q_N net5 VDD VDD sg13_lv_pmos m=1 w=1.12u l=130.00n ng=1
MP10 Dbb clkpos net6 VDD sg13_lv_pmos m=1 w=420.00n l=130.00n ng=1
MP6 Dbb RESET_B VDD VDD sg13_lv_pmos m=1 w=420.00n l=130.00n ng=1
MP7 Dbb net13 VDD VDD sg13_lv_pmos m=1 w=420.00n l=130.00n ng=1
MP11 net7 net4 VDD VDD sg13_lv_pmos m=1 w=420.00n l=130.00n ng=1
MP12 net6 clkneg net7 VDD sg13_lv_pmos m=1 w=420.00n l=130.00n ng=1
MP13 net6 RESET_B VDD VDD sg13_lv_pmos m=1 w=420.00n l=130.00n ng=1
MP8 clkneg CLK VDD VDD sg13_lv_pmos m=1 w=1.12u l=130.00n ng=1
MP9 clkpos clkneg VDD VDD sg13_lv_pmos m=1 w=1.12u l=130.00n ng=1
MP14 net4 net6 VDD VDD sg13_lv_pmos m=1 w=1.000u l=130.00n ng=1
MP15 net4 clkneg net5 VDD sg13_lv_pmos m=1 w=1.000u l=130.00n ng=1
MP22 Q net1 VDD VDD sg13_lv_pmos m=1 w=1.12u l=130.00n ng=1
MP16 net3 net2 VDD VDD sg13_lv_pmos m=1 w=420.00n l=130.00n ng=1
MP21 net1 net5 VDD VDD sg13_lv_pmos m=1 w=1.000u l=130.00n ng=1
.ENDS

************************************************************************
* Library Name: sg13cmos5l_stdcell
* Cell Name:    sg13cmos5l_dfrbpq_2
* View Name:    schematic
************************************************************************

.SUBCKT sg13cmos5l_dfrbpq_2 Q CLK D RESET_B VDD VSS
*.PININFO CLK:I D:I RESET_B:I Q:O VDD:B VSS:B
MN11 net12 net2 VSS VSS sg13_lv_nmos m=1 w=420.00n l=130.00n ng=1
MN10 net5 clkneg net12 VSS sg13_lv_nmos m=1 w=420.00n l=130.00n ng=1
MN12 net2 net5 net11 VSS sg13_lv_nmos m=1 w=420.00n l=130.00n ng=1
MN13 net11 RESET_B VSS VSS sg13_lv_nmos m=1 w=420.00n l=130.00n ng=1
MN0 Db D net10 VSS sg13_lv_nmos m=1 w=420.00n l=130.00n ng=1
MN1 net10 RESET_B VSS VSS sg13_lv_nmos m=1 w=420.00n l=130.00n ng=1
MN4 Db clkneg net6 VSS sg13_lv_nmos m=1 w=420.00n l=130.00n ng=1
MN5 net6 clkpos net9 VSS sg13_lv_nmos m=1 w=420.00n l=130.00n ng=1
MN6 net9 net4 net8 VSS sg13_lv_nmos m=1 w=420.00n l=130.00n ng=1
MN7 net8 RESET_B VSS VSS sg13_lv_nmos m=1 w=420.00n l=130.00n ng=1
MN8 net4 net6 VSS VSS sg13_lv_nmos m=1 w=740.00n l=130.00n ng=1
MN2 clkneg CLK VSS VSS sg13_lv_nmos m=1 w=740.00n l=130.00n ng=1
MN9 net4 clkpos net5 VSS sg13_lv_nmos m=1 w=740.00n l=130.00n ng=1
MN3 clkpos clkneg VSS VSS sg13_lv_nmos m=1 w=740.00n l=130.00n ng=1
MN15 Q net1 VSS VSS sg13_lv_nmos m=1 w=1.48u l=130.00n ng=2
MN14 net1 net5 VSS VSS sg13_lv_nmos m=1 w=640.00n l=130.00n ng=1
MP11 net5 clkpos net3 VDD sg13_lv_pmos m=1 w=420.00n l=130.00n ng=1
MP12 net2 net5 VDD VDD sg13_lv_pmos m=1 w=420.00n l=130.00n ng=1
MP13 net2 RESET_B VDD VDD sg13_lv_pmos m=1 w=420.00n l=130.00n ng=1
MP4 Db clkpos net6 VDD sg13_lv_pmos m=1 w=420.00n l=130.00n ng=1
MP0 Db RESET_B VDD VDD sg13_lv_pmos m=1 w=420.00n l=130.00n ng=1
MP1 Db D VDD VDD sg13_lv_pmos m=1 w=420.00n l=130.00n ng=1
MP5 net7 net4 VDD VDD sg13_lv_pmos m=1 w=420.00n l=130.00n ng=1
MP6 net6 clkneg net7 VDD sg13_lv_pmos m=1 w=420.00n l=130.00n ng=1
MP7 net6 RESET_B VDD VDD sg13_lv_pmos m=1 w=420.00n l=130.00n ng=1
MP2 clkneg CLK VDD VDD sg13_lv_pmos m=1 w=1.12u l=130.00n ng=1
MP3 clkpos clkneg VDD VDD sg13_lv_pmos m=1 w=1.12u l=130.00n ng=1
MP8 net4 net6 VDD VDD sg13_lv_pmos m=1 w=1.000u l=130.00n ng=1
MP9 net4 clkneg net5 VDD sg13_lv_pmos m=1 w=1.000u l=130.00n ng=1
MP15 Q net1 VDD VDD sg13_lv_pmos m=1 w=2.24u l=130.00n ng=2
MP10 net3 net2 VDD VDD sg13_lv_pmos m=1 w=420.00n l=130.00n ng=1
MP14 net1 net5 VDD VDD sg13_lv_pmos m=1 w=1.000u l=130.00n ng=1
.ENDS

************************************************************************
* Library Name: sg13cmos5l_stdcell
* Cell Name:    sg13cmos5l_dfrbpq_1
* View Name:    schematic
************************************************************************

.SUBCKT sg13cmos5l_dfrbpq_1 Q CLK D RESET_B VDD VSS
*.PININFO CLK:I D:I RESET_B:I Q:O VDD:B VSS:B
MN11 net12 net2 VSS VSS sg13_lv_nmos m=1 w=420.00n l=130.00n ng=1
MN10 net5 clkneg net12 VSS sg13_lv_nmos m=1 w=420.00n l=130.00n ng=1
MN12 net2 net5 net11 VSS sg13_lv_nmos m=1 w=420.00n l=130.00n ng=1
MN13 net11 RESET_B VSS VSS sg13_lv_nmos m=1 w=420.00n l=130.00n ng=1
MN0 Db D net10 VSS sg13_lv_nmos m=1 w=420.00n l=130.00n ng=1
MN1 net10 RESET_B VSS VSS sg13_lv_nmos m=1 w=420.00n l=130.00n ng=1
MN4 Db clkneg net6 VSS sg13_lv_nmos m=1 w=420.00n l=130.00n ng=1
MN5 net6 clkpos net9 VSS sg13_lv_nmos m=1 w=420.00n l=130.00n ng=1
MN6 net9 net4 net8 VSS sg13_lv_nmos m=1 w=420.00n l=130.00n ng=1
MN7 net8 RESET_B VSS VSS sg13_lv_nmos m=1 w=420.00n l=130.00n ng=1
MN8 net4 net6 VSS VSS sg13_lv_nmos m=1 w=740.00n l=130.00n ng=1
MN2 clkneg CLK VSS VSS sg13_lv_nmos m=1 w=740.00n l=130.00n ng=1
MN9 net4 clkpos net5 VSS sg13_lv_nmos m=1 w=740.00n l=130.00n ng=1
MN3 clkpos clkneg VSS VSS sg13_lv_nmos m=1 w=740.00n l=130.00n ng=1
MN15 Q net1 VSS VSS sg13_lv_nmos m=1 w=740.00n l=130.00n ng=1
MN14 net1 net5 VSS VSS sg13_lv_nmos m=1 w=740.00n l=130.00n ng=1
MP11 net5 clkpos net3 VDD sg13_lv_pmos m=1 w=420.00n l=130.00n ng=1
MP12 net2 net5 VDD VDD sg13_lv_pmos m=1 w=420.00n l=130.00n ng=1
MP13 net2 RESET_B VDD VDD sg13_lv_pmos m=1 w=420.00n l=130.00n ng=1
MP4 Db clkpos net6 VDD sg13_lv_pmos m=1 w=420.00n l=130.00n ng=1
MP0 Db RESET_B VDD VDD sg13_lv_pmos m=1 w=420.00n l=130.00n ng=1
MP1 Db D VDD VDD sg13_lv_pmos m=1 w=420.00n l=130.00n ng=1
MP5 net7 net4 VDD VDD sg13_lv_pmos m=1 w=420.00n l=130.00n ng=1
MP6 net6 clkneg net7 VDD sg13_lv_pmos m=1 w=420.00n l=130.00n ng=1
MP7 net6 RESET_B VDD VDD sg13_lv_pmos m=1 w=420.00n l=130.00n ng=1
MP2 clkneg CLK VDD VDD sg13_lv_pmos m=1 w=1.12u l=130.00n ng=1
MP3 clkpos clkneg VDD VDD sg13_lv_pmos m=1 w=1.12u l=130.00n ng=1
MP8 net4 net6 VDD VDD sg13_lv_pmos m=1 w=1.000u l=130.00n ng=1
MP9 net4 clkneg net5 VDD sg13_lv_pmos m=1 w=1.000u l=130.00n ng=1
MP15 Q net1 VDD VDD sg13_lv_pmos m=1 w=1.12u l=130.00n ng=1
MP10 net3 net2 VDD VDD sg13_lv_pmos m=1 w=420.00n l=130.00n ng=1
MP14 net1 net5 VDD VDD sg13_lv_pmos m=1 w=1.12u l=130.00n ng=1
.ENDS

************************************************************************
* Library Name: sg13cmos5l_stdcell
* Cell Name:    sg13cmos5l_fill_1
* View Name:    schematic
************************************************************************

.SUBCKT sg13cmos5l_fill_1 VDD VSS
*.PININFO VDD:B VSS:B
.ENDS

************************************************************************
* Library Name: sg13cmos5l_stdcell
* Cell Name:    sg13cmos5l_fill_2
* View Name:    schematic
************************************************************************

.SUBCKT sg13cmos5l_fill_2 VDD VSS
*.PININFO VDD:B VSS:B
.ENDS

************************************************************************
* Library Name: sg13cmos5l_stdcell
* Cell Name:    sg13cmos5l_fill_4
* View Name:    schematic
************************************************************************

.SUBCKT sg13cmos5l_fill_4 VDD VSS
*.PININFO VDD:B VSS:B
.ENDS

************************************************************************
* Library Name: sg13cmos5l_stdcell
* Cell Name:    sg13cmos5l_fill_8
* View Name:    schematic
************************************************************************

.SUBCKT sg13cmos5l_fill_8 VDD VSS
*.PININFO VDD:B VSS:B
.ENDS

* CDL Netlist generated by OpenROAD

*.BUSDELIMITER [

.SUBCKT sar_fsm_wrapper_pnr bn0 bn1 bn2 bn3 bn4 bn5 bn6 bn7 bn8
+ bn9 bp0 bp1 bp2 bp3 bp4 bp5 bp6 bp7 bp8 bp9 busy clk code0
+ code1 code2 code3 code4 code5 code6 code7 code8 code9 comp
+ comp_clk rst_n sample start valid VDD VSS
X_212_ _210_ _001_ VDD VSS sg13cmos5l_inv_1
X_213_ _050_ net119 VDD VSS sg13cmos5l_inv_1
X_214_ _051_ net163 VDD VSS sg13cmos5l_inv_1
X_215_ _052_ net155 VDD VSS sg13cmos5l_inv_1
X_216_ _053_ net58 VDD VSS sg13cmos5l_inv_1
X_217_ _054_ u_sar.bit_idx\[2\] VDD VSS sg13cmos5l_inv_1
X_218_ _055_ net105 VDD VSS sg13cmos5l_inv_1
X_219_ _056_ net154 VDD VSS sg13cmos5l_inv_1
X_220_ _057_ net138 VDD VSS sg13cmos5l_inv_1
X_221_ _058_ net150 VDD VSS sg13cmos5l_inv_1
X_222_ _059_ net152 VDD VSS sg13cmos5l_inv_1
X_223_ _060_ net132 VDD VSS sg13cmos5l_inv_1
X_224_ _061_ net144 VDD VSS sg13cmos5l_inv_1
X_225_ _062_ net109 VDD VSS sg13cmos5l_inv_1
X_226_ _063_ net146 VDD VSS sg13cmos5l_inv_1
X_227_ _064_ net134 VDD VSS sg13cmos5l_inv_1
X_228_ _065_ net148 VDD VSS sg13cmos5l_inv_1
X_229_ _066_ net131 VDD VSS sg13cmos5l_inv_1
X_230_ _067_ net142 VDD VSS sg13cmos5l_inv_1
X_231_ _068_ net123 VDD VSS sg13cmos5l_inv_1
X_232_ _069_ net127 VDD VSS sg13cmos5l_inv_1
X_233_ _070_ net125 VDD VSS sg13cmos5l_inv_1
X_234_ _071_ net121 VDD VSS sg13cmos5l_inv_1
X_235_ _072_ net140 VDD VSS sg13cmos5l_inv_1
X_236_ _073_ net129 VDD VSS sg13cmos5l_inv_1
X_237_ _074_ net136 VDD VSS sg13cmos5l_inv_1
X_238_ _075_ net115 VDD VSS sg13cmos5l_inv_1
X_239_ _076_ net77 VDD VSS sg13cmos5l_inv_1
X_240_ _077_ net70 VDD VSS sg13cmos5l_inv_1
X_241_ _078_ u_sar.state\[1\] u_sar.state\[0\] VDD VSS sg13cmos5l_nor2b_1
X_242_ _079_ net158 net105 net166 VDD VSS sg13cmos5l_nand3b_1
X_243_ _049_ _079_ VDD VSS sg13cmos5l_inv_1
X_244_ _080_ net105 net158 net166 VDD VSS sg13cmos5l_nand3b_1
X_245_ _211_\[5\] _080_ VDD VSS sg13cmos5l_inv_1
X_246_ _081_ _079_ _080_ VDD VSS sg13cmos5l_and2_1
X_247_ _082_ _079_ _080_ VDD VSS sg13cmos5l_nand2_1
X_248_ _083_ u_sar.state\[0\] u_sar.state\[1\] VDD VSS sg13cmos5l_nor2_1
X_249_ _084_ u_sar.state\[2\] _083_ VDD VSS sg13cmos5l_and2_1
X_250_ _085_ net105 _083_ VDD VSS sg13cmos5l_nand2_1
X_251_ _086_ net58 net60 VDD VSS sg13cmos5l_nor2b_1
X_252_ _087_ net57 net59 VDD VSS sg13cmos5l_nand2b_1
X_253_ _088_ _210_ u_sar.bit_idx\[2\] _087_ VDD VSS sg13cmos5l_nor3_1
X_254_ _089_ net56 net51 VDD VSS sg13cmos5l_nand2_1
X_255_ _090_ u_sar.state\[0\] u_sar.state\[1\] u_sar.state\[2\]
+ VDD VSS sg13cmos5l_nor3_1
X_256_ _091_ _077_ _090_ VDD VSS sg13cmos5l_and2_1
X_257_ _092_ _077_ _090_ VDD VSS sg13cmos5l_nand2_1
X_258_ _093_ net56 net52 _091_ VDD VSS sg13cmos5l_a21oi_1
X_259_ _094_ net56 net52 _090_ _077_ _082_ VDD VSS sg13cmos5l_a221oi_1
X_260_ _095_ _055_ _078_ VDD VSS sg13cmos5l_and2_1
X_261_ _096_ u_sar.state\[0\] net105 VDD VSS sg13cmos5l_nor2_1
X_262_ _097_ net158 _096_ VDD VSS sg13cmos5l_nand2_1
X_263_ _098_ u_sar.count\[4\] u_sar.count\[5\] u_sar.count\[6\]
+ u_sar.count\[7\] VDD VSS sg13cmos5l_or4_1
X_264_ _099_ u_sar.count\[0\] u_sar.count\[1\] VDD VSS sg13cmos5l_nand2b_1
X_265_ _100_ u_sar.count\[2\] net111 _098_ _099_ VDD VSS sg13cmos5l_nor4_1
X_266_ _101_ _097_ net112 VDD VSS sg13cmos5l_nor2_1
X_267_ _102_ net117 _095_ net113 VDD VSS sg13cmos5l_nor3_1
X_268_ _002_ net117 _094_ _102_ VDD VSS sg13cmos5l_a21oi_1
X_269_ _103_ net117 net119 VDD VSS sg13cmos5l_xor2_1
X_270_ _104_ _095_ net113 _103_ VDD VSS sg13cmos5l_o21ai_1
X_271_ _003_ _050_ _094_ _104_ VDD VSS sg13cmos5l_o21ai_1
X_272_ _105_ net117 net119 net160 VDD VSS sg13cmos5l_a21oi_1
X_273_ _106_ _094_ net160 VDD VSS sg13cmos5l_nand2b_1
X_274_ _107_ _055_ _078_ _096_ u_sar.state\[1\] VDD VSS sg13cmos5l_a22oi_1
X_275_ _108_ _095_ _097_ VDD VSS sg13cmos5l_nand2b_1
X_276_ _109_ net117 net119 net160 VDD VSS sg13cmos5l_nand3_1
X_277_ _110_ _108_ _109_ VDD VSS sg13cmos5l_nand2_1
X_278_ _004_ _106_ _110_ _105_ VDD VSS sg13cmos5l_a21oi_1
X_279_ _111_ _094_ net111 VDD VSS sg13cmos5l_nor2b_1
X_280_ _112_ net111 _109_ VDD VSS sg13cmos5l_or2_1
X_281_ _113_ net111 _109_ VDD VSS sg13cmos5l_nand2_1
X_282_ _114_ _098_ _112_ _095_ VDD VSS sg13cmos5l_o21ai_1
X_283_ _115_ _112_ _113_ _114_ _097_ VDD VSS sg13cmos5l_a22oi_1
X_284_ _005_ _111_ net159 VDD VSS sg13cmos5l_or2_1
X_285_ _116_ net117 net119 net160 net111 VDD VSS sg13cmos5l_and4_1
X_286_ _117_ net165 _116_ VDD VSS sg13cmos5l_nor2_1
X_287_ _118_ _094_ net165 VDD VSS sg13cmos5l_nand2b_1
X_288_ _119_ net165 _116_ VDD VSS sg13cmos5l_nand2_1
X_289_ _120_ _108_ _119_ VDD VSS sg13cmos5l_nand2_1
X_290_ _006_ _118_ _120_ _117_ VDD VSS sg13cmos5l_a21oi_1
X_291_ _121_ _094_ net163 VDD VSS sg13cmos5l_nand2b_1
X_292_ _122_ u_sar.count\[4\] net163 _116_ VDD VSS sg13cmos5l_nand3_1
X_293_ _123_ _108_ _122_ VDD VSS sg13cmos5l_nand2_1
X_294_ _007_ _051_ _119_ _121_ _123_ VDD VSS sg13cmos5l_a22oi_1
X_295_ _124_ u_sar.count\[4\] u_sar.count\[5\] net155 _116_
+ VDD VSS sg13cmos5l_nand4_1
X_296_ _125_ _107_ _124_ VDD VSS sg13cmos5l_nand2b_1
X_297_ _126_ _094_ _125_ VDD VSS sg13cmos5l_nand2_1
X_298_ _127_ _107_ _122_ _052_ VDD VSS sg13cmos5l_o21ai_1
X_299_ _008_ _126_ net156 VDD VSS sg13cmos5l_and2_1
X_300_ _128_ net161 _107_ _124_ VDD VSS sg13cmos5l_nor3_1
X_301_ _009_ net161 _126_ _128_ VDD VSS sg13cmos5l_a21o_1
X_302_ _129_ _081_ _092_ _107_ VDD VSS sg13cmos5l_nand3_1
X_303_ _130_ net46 _089_ VDD VSS sg13cmos5l_nand2b_1
X_304_ _010_ net56 _130_ net59 VDD VSS sg13cmos5l_mux2_1
X_305_ _131_ net59 net57 VDD VSS sg13cmos5l_nand2b_1
X_306_ _132_ _087_ _131_ net55 VDD VSS sg13cmos5l_a21oi_1
X_307_ _011_ _132_ net57 _130_ VDD VSS sg13cmos5l_mux2_1
X_308_ _133_ net167 net46 VDD VSS sg13cmos5l_nand2_1
X_309_ _134_ _054_ _086_ VDD VSS sg13cmos5l_xnor2_1
X_310_ _135_ net56 _134_ VDD VSS sg13cmos5l_nand2_1
X_311_ _012_ _130_ _135_ _133_ VDD VSS sg13cmos5l_o21ai_1
X_312_ _136_ _054_ _086_ net169 VDD VSS sg13cmos5l_a21oi_1
X_313_ _137_ net54 net51 VDD VSS sg13cmos5l_nor2_1
X_314_ _138_ net53 net51 _136_ VDD VSS sg13cmos5l_nor3_1
X_315_ _013_ net169 _130_ _138_ VDD VSS sg13cmos5l_a21o_1
X_316_ _139_ _097_ _100_ _092_ VDD VSS sg13cmos5l_o21ai_1
X_317_ _140_ _092_ _114_ VDD VSS sg13cmos5l_and2_1
X_318_ _141_ net56 net52 net106 VDD VSS sg13cmos5l_a21oi_1
X_319_ _014_ _139_ net107 _114_ VDD VSS sg13cmos5l_o21ai_1
X_320_ _142_ net55 net52 _107_ VDD VSS sg13cmos5l_o21ai_1
X_321_ _015_ _140_ _142_ net113 VDD VSS sg13cmos5l_a21o_1
X_322_ _016_ _080_ _089_ VDD VSS sg13cmos5l_nand2_1
X_323_ _143_ net46 _137_ net25 VDD VSS sg13cmos5l_o21ai_1
X_324_ _017_ _076_ _089_ _143_ VDD VSS sg13cmos5l_o21ai_1
X_325_ _144_ net51 _136_ VDD VSS sg13cmos5l_nor2_1
X_326_ _145_ _210_ net59 net57 u_sar.bit_idx\[2\] VDD VSS
+ sg13cmos5l_nor4_1
X_327_ _146_ net54 _145_ VDD VSS sg13cmos5l_nor2_1
X_328_ _147_ net47 _146_ net94 VDD VSS sg13cmos5l_o21ai_1
X_329_ _148_ _076_ net51 VDD VSS sg13cmos5l_nor2_1
X_330_ _149_ net60 _053_ net77 VDD VSS sg13cmos5l_nand3b_1
X_331_ _150_ _134_ _149_ VDD VSS sg13cmos5l_nor2_1
X_332_ _151_ _138_ _150_ VDD VSS sg13cmos5l_nand2_1
X_333_ _018_ net95 _151_ VDD VSS sg13cmos5l_nand2_1
X_334_ _152_ _001_ net59 net57 _054_ VDD VSS sg13cmos5l_and4_1
X_335_ _153_ net54 _152_ VDD VSS sg13cmos5l_nor2_1
X_336_ _154_ net47 _153_ net87 VDD VSS sg13cmos5l_o21ai_1
X_337_ _155_ net60 net58 net77 VDD VSS sg13cmos5l_nand3_1
X_338_ _156_ net53 net51 _134_ _136_ VDD VSS sg13cmos5l_or4_1
X_339_ _019_ _155_ _156_ net88 VDD VSS sg13cmos5l_o21ai_1
X_340_ _157_ _210_ net59 _053_ u_sar.bit_idx\[2\] VDD VSS
+ sg13cmos5l_nor4_1
X_341_ _158_ net54 _157_ VDD VSS sg13cmos5l_nor2_1
X_342_ _159_ net47 _158_ net79 VDD VSS sg13cmos5l_o21ai_1
X_343_ _160_ net60 net58 net77 VDD VSS sg13cmos5l_nand3b_1
X_344_ _020_ _156_ _160_ net80 VDD VSS sg13cmos5l_o21ai_1
X_345_ _161_ _210_ _054_ _087_ VDD VSS sg13cmos5l_nor3_1
X_346_ _162_ net54 _161_ VDD VSS sg13cmos5l_nor2_1
X_347_ _163_ net47 _162_ net103 VDD VSS sg13cmos5l_o21ai_1
X_348_ _164_ net60 _053_ _148_ VDD VSS sg13cmos5l_nand3_1
X_349_ _021_ _156_ _164_ _163_ VDD VSS sg13cmos5l_o21ai_1
X_350_ _165_ _210_ net59 net57 _054_ VDD VSS sg13cmos5l_nor4_1
X_351_ _166_ net53 _165_ VDD VSS sg13cmos5l_nor2_1
X_352_ _167_ net46 _166_ net90 VDD VSS sg13cmos5l_o21ai_1
X_353_ _168_ net56 _134_ _144_ VDD VSS sg13cmos5l_nand3_1
X_354_ _022_ _149_ _168_ _167_ VDD VSS sg13cmos5l_o21ai_1
X_355_ _169_ _001_ net59 net57 u_sar.bit_idx\[2\] VDD VSS
+ sg13cmos5l_and4_1
X_356_ _170_ net53 _169_ VDD VSS sg13cmos5l_nor2_1
X_357_ _171_ net46 _170_ net84 VDD VSS sg13cmos5l_o21ai_1
X_358_ _023_ _155_ _168_ net85 VDD VSS sg13cmos5l_o21ai_1
X_359_ _172_ _210_ net60 _053_ _054_ VDD VSS sg13cmos5l_nor4_1
X_360_ _173_ net53 _172_ VDD VSS sg13cmos5l_nor2_1
X_361_ _174_ net46 _173_ net82 VDD VSS sg13cmos5l_o21ai_1
X_362_ _024_ _160_ _168_ _174_ VDD VSS sg13cmos5l_o21ai_1
X_363_ _175_ _001_ u_sar.bit_idx\[2\] _087_ VDD VSS sg13cmos5l_nor3_1
X_364_ _176_ net53 _175_ VDD VSS sg13cmos5l_nor2_1
X_365_ _177_ net46 _176_ net97 VDD VSS sg13cmos5l_o21ai_1
X_366_ _025_ _135_ _164_ net98 VDD VSS sg13cmos5l_o21ai_1
X_367_ _178_ _001_ net60 net57 u_sar.bit_idx\[2\] VDD VSS
+ sg13cmos5l_nor4_1
X_368_ _179_ net53 _178_ VDD VSS sg13cmos5l_nor2_1
X_369_ _180_ net46 _179_ net100 VDD VSS sg13cmos5l_o21ai_1
X_370_ _181_ net51 _136_ _150_ VDD VSS sg13cmos5l_o21ai_1
X_371_ _026_ net53 _181_ net101 VDD VSS sg13cmos5l_o21ai_1
X_372_ _182_ _081_ _097_ VDD VSS sg13cmos5l_and2_1
X_373_ _183_ _081_ _097_ VDD VSS sg13cmos5l_nand2_1
X_374_ _184_ net1 net54 net51 VDD VSS sg13cmos5l_or3_1
X_375_ _185_ net52 net56 net1 VDD VSS sg13cmos5l_nand3b_1
X_376_ _186_ net52 net48 net43 VDD VSS sg13cmos5l_nand3_1
X_377_ _187_ _084_ _091_ _183_ VDD VSS sg13cmos5l_nor3_1
X_378_ _027_ _056_ _186_ net39 VDD VSS sg13cmos5l_a21oi_1
X_379_ _188_ net50 _145_ net45 net42 VDD VSS sg13cmos5l_nand4_1
X_380_ _028_ _057_ _188_ net39 VDD VSS sg13cmos5l_a21oi_1
X_381_ _189_ net50 _152_ net45 net42 VDD VSS sg13cmos5l_nand4_1
X_382_ _029_ _058_ _189_ net39 VDD VSS sg13cmos5l_a21oi_1
X_383_ _190_ net50 _157_ net45 net42 VDD VSS sg13cmos5l_nand4_1
X_384_ _030_ _059_ _190_ net39 VDD VSS sg13cmos5l_a21oi_1
X_385_ _191_ net50 _161_ net45 net42 VDD VSS sg13cmos5l_nand4_1
X_386_ _031_ _060_ _191_ net40 VDD VSS sg13cmos5l_a21oi_1
X_387_ _192_ net50 _165_ net45 net42 VDD VSS sg13cmos5l_nand4_1
X_388_ _032_ _061_ _192_ net40 VDD VSS sg13cmos5l_a21oi_1
X_389_ _193_ net50 _169_ net45 _184_ VDD VSS sg13cmos5l_nand4_1
X_390_ _033_ _062_ _193_ net40 VDD VSS sg13cmos5l_a21oi_1
X_391_ _194_ net50 _172_ net45 net42 VDD VSS sg13cmos5l_nand4_1
X_392_ _034_ _063_ _194_ net39 VDD VSS sg13cmos5l_a21oi_1
X_393_ _195_ net49 _175_ net44 net42 VDD VSS sg13cmos5l_nand4_1
X_394_ _035_ _064_ _195_ net39 VDD VSS sg13cmos5l_a21oi_1
X_395_ _196_ net49 _178_ net44 net42 VDD VSS sg13cmos5l_nand4_1
X_396_ _036_ _065_ _196_ net39 VDD VSS sg13cmos5l_a21oi_1
X_397_ _037_ _066_ _186_ net39 VDD VSS sg13cmos5l_a21oi_1
X_398_ _197_ net48 _145_ net43 net41 VDD VSS sg13cmos5l_nand4_1
X_399_ _038_ _067_ _197_ net38 VDD VSS sg13cmos5l_a21oi_1
X_400_ _198_ net48 _152_ net43 net41 VDD VSS sg13cmos5l_nand4_1
X_401_ _039_ _068_ _198_ net38 VDD VSS sg13cmos5l_a21oi_1
X_402_ _199_ net48 _157_ net43 net41 VDD VSS sg13cmos5l_nand4_1
X_403_ _040_ _069_ _199_ net40 VDD VSS sg13cmos5l_a21oi_1
X_404_ _200_ net48 _161_ net43 net41 VDD VSS sg13cmos5l_nand4_1
X_405_ _041_ _070_ _200_ net38 VDD VSS sg13cmos5l_a21oi_1
X_406_ _201_ net48 _165_ net43 net41 VDD VSS sg13cmos5l_nand4_1
X_407_ _042_ _071_ _201_ net38 VDD VSS sg13cmos5l_a21oi_1
X_408_ _202_ net48 _169_ net43 net41 VDD VSS sg13cmos5l_nand4_1
X_409_ _043_ _072_ _202_ net38 VDD VSS sg13cmos5l_a21oi_1
X_410_ _203_ net48 _172_ net43 net41 VDD VSS sg13cmos5l_nand4_1
X_411_ _044_ _073_ _203_ net38 VDD VSS sg13cmos5l_a21oi_1
X_412_ _204_ net49 _175_ net44 net41 VDD VSS sg13cmos5l_nand4_1
X_413_ _045_ _074_ _204_ net38 VDD VSS sg13cmos5l_a21oi_1
X_414_ _205_ net49 _178_ net44 _185_ VDD VSS sg13cmos5l_nand4_1
X_415_ _046_ _075_ _205_ net38 VDD VSS sg13cmos5l_a21oi_1
X_416_ _206_ net70 _090_ VDD VSS sg13cmos5l_nand2_1
X_417_ _207_ _080_ net55 _107_ VDD VSS sg13cmos5l_nand3_1
X_418_ _208_ net24 _207_ VDD VSS sg13cmos5l_nand2_1
X_419_ _047_ net71 _208_ VDD VSS sg13cmos5l_nand2_1
X_420_ _209_ _084_ _183_ net73 VDD VSS sg13cmos5l_o21ai_1
X_421_ _048_ _114_ net71 net74 VDD VSS sg13cmos5l_nand3_1
X_422_ u_sar.count\[0\] clknet_3_0__leaf_clk net118 net61
+ VDD VSS sg13cmos5l_dfrbpq_1
X_423_ u_sar.count\[1\] clknet_3_0__leaf_clk net120 net62
+ VDD VSS sg13cmos5l_dfrbpq_1
X_424_ u_sar.count\[2\] clknet_3_0__leaf_clk _004_ net61 VDD
+ VSS sg13cmos5l_dfrbpq_1
X_425_ u_sar.count\[3\] clknet_3_0__leaf_clk _005_ net62 VDD
+ VSS sg13cmos5l_dfrbpq_1
X_426_ u_sar.count\[4\] clknet_3_0__leaf_clk _006_ net61 VDD
+ VSS sg13cmos5l_dfrbpq_1
X_427_ u_sar.count\[5\] clknet_3_0__leaf_clk net164 net61
+ VDD VSS sg13cmos5l_dfrbpq_1
X_428_ u_sar.count\[6\] clknet_3_1__leaf_clk net157 net61
+ VDD VSS sg13cmos5l_dfrbpq_1
X_429_ u_sar.count\[7\] clknet_3_1__leaf_clk net162 net61
+ VDD VSS sg13cmos5l_dfrbpq_1
X_430_ _000_ clknet_3_1__leaf_clk _010_ net61 VDD VSS sg13cmos5l_dfrbpq_1
X_431_ u_sar.bit_idx\[1\] clknet_3_1__leaf_clk _011_ net61
+ VDD VSS sg13cmos5l_dfrbpq_1
X_432_ u_sar.bit_idx\[2\] clknet_3_4__leaf_clk net168 net65
+ VDD VSS sg13cmos5l_dfrbpq_1
X_433_ _001_ clknet_3_4__leaf_clk _013_ net65 VDD VSS sg13cmos5l_dfrbpq_1
X_434_ u_sar.state\[0\] clknet_3_0__leaf_clk net108 net63
+ VDD VSS sg13cmos5l_dfrbpq_1
X_435_ u_sar.state\[1\] clknet_3_1__leaf_clk net114 net64
+ VDD VSS sg13cmos5l_dfrbpq_1
X_436_ u_sar.state\[2\] clknet_3_1__leaf_clk _016_ net67 VDD
+ VSS sg13cmos5l_dfrbpq_1
X_437_ net25 clknet_3_4__leaf_clk net78 net67 VDD VSS sg13cmos5l_dfrbpq_1
X_438_ net26 clknet_3_5__leaf_clk net96 net66 VDD VSS sg13cmos5l_dfrbpq_1
X_439_ net27 clknet_3_5__leaf_clk net89 net65 VDD VSS sg13cmos5l_dfrbpq_1
X_440_ net28 clknet_3_5__leaf_clk net81 net65 VDD VSS sg13cmos5l_dfrbpq_1
X_441_ net29 clknet_3_5__leaf_clk net104 net65 VDD VSS sg13cmos5l_dfrbpq_1
X_442_ net30 clknet_3_5__leaf_clk net91 net65 VDD VSS sg13cmos5l_dfrbpq_1
X_443_ net31 clknet_3_5__leaf_clk net86 net65 VDD VSS sg13cmos5l_dfrbpq_1
X_444_ net32 clknet_3_4__leaf_clk net83 net68 VDD VSS sg13cmos5l_dfrbpq_1
X_445_ net33 clknet_3_4__leaf_clk net99 net65 VDD VSS sg13cmos5l_dfrbpq_1
X_446_ net34 clknet_3_4__leaf_clk net102 net68 VDD VSS sg13cmos5l_dfrbpq_1
X_447_ net4 clknet_3_7__leaf_clk _027_ net66 VDD VSS sg13cmos5l_dfrbpq_1
X_448_ net5 clknet_3_7__leaf_clk net139 net66 VDD VSS sg13cmos5l_dfrbpq_1
X_449_ net6 clknet_3_7__leaf_clk net151 net66 VDD VSS sg13cmos5l_dfrbpq_1
X_450_ net7 clknet_3_7__leaf_clk net153 net66 VDD VSS sg13cmos5l_dfrbpq_1
X_451_ net8 clknet_3_7__leaf_clk net133 net66 VDD VSS sg13cmos5l_dfrbpq_1
X_452_ net9 clknet_3_6__leaf_clk net145 net66 VDD VSS sg13cmos5l_dfrbpq_1
X_453_ net10 clknet_3_6__leaf_clk net110 net67 VDD VSS sg13cmos5l_dfrbpq_1
X_454_ net11 clknet_3_6__leaf_clk net147 net67 VDD VSS sg13cmos5l_dfrbpq_1
X_455_ net12 clknet_3_6__leaf_clk net135 net67 VDD VSS sg13cmos5l_dfrbpq_1
X_456_ net13 clknet_3_6__leaf_clk net149 net67 VDD VSS sg13cmos5l_dfrbpq_1
X_457_ net14 clknet_3_6__leaf_clk _037_ net67 VDD VSS sg13cmos5l_dfrbpq_1
X_458_ net15 clknet_3_3__leaf_clk net143 net63 VDD VSS sg13cmos5l_dfrbpq_1
X_459_ net16 clknet_3_3__leaf_clk net124 net63 VDD VSS sg13cmos5l_dfrbpq_1
X_460_ net17 clknet_3_3__leaf_clk net128 net63 VDD VSS sg13cmos5l_dfrbpq_1
X_461_ net18 clknet_3_2__leaf_clk net126 net63 VDD VSS sg13cmos5l_dfrbpq_1
X_462_ net19 clknet_3_3__leaf_clk net122 net62 VDD VSS sg13cmos5l_dfrbpq_1
X_463_ net20 clknet_3_2__leaf_clk net141 net62 VDD VSS sg13cmos5l_dfrbpq_1
X_464_ net21 clknet_3_2__leaf_clk net130 net62 VDD VSS sg13cmos5l_dfrbpq_1
X_465_ net22 clknet_3_2__leaf_clk net137 net62 VDD VSS sg13cmos5l_dfrbpq_1
X_466_ net23 clknet_3_2__leaf_clk net116 net62 VDD VSS sg13cmos5l_dfrbpq_1
X_467_ net24 clknet_3_3__leaf_clk net72 net63 VDD VSS sg13cmos5l_dfrbpq_1
X_468_ net37 clknet_3_7__leaf_clk _049_ net66 VDD VSS sg13cmos5l_dfrbpq_1
X_469_ net36 clknet_3_3__leaf_clk net75 net63 VDD VSS sg13cmos5l_dfrbpq_1
X_470_ net35 clknet_3_2__leaf_clk _211_\[5\] net62 VDD VSS
+ sg13cmos5l_dfrbpq_1
Xclkbuf_0_clk clknet_0_clk clk VDD VSS sg13cmos5l_buf_8
Xinput1 net1 net76 VDD VSS sg13cmos5l_buf_1
Xinput2 net2 net92 VDD VSS sg13cmos5l_buf_1
Xinput3 net3 net69 VDD VSS sg13cmos5l_buf_1
Xoutput4 bn0 net154 VDD VSS sg13cmos5l_buf_1
Xoutput5 bn1 net138 VDD VSS sg13cmos5l_buf_1
Xoutput6 bn2 net150 VDD VSS sg13cmos5l_buf_1
Xoutput7 bn3 net152 VDD VSS sg13cmos5l_buf_1
Xoutput8 bn4 net132 VDD VSS sg13cmos5l_buf_1
Xoutput9 bn5 net144 VDD VSS sg13cmos5l_buf_1
Xoutput10 bn6 net109 VDD VSS sg13cmos5l_buf_1
Xoutput11 bn7 net146 VDD VSS sg13cmos5l_buf_1
Xoutput12 bn8 net134 VDD VSS sg13cmos5l_buf_1
Xoutput13 bn9 net148 VDD VSS sg13cmos5l_buf_1
Xoutput14 bp0 net131 VDD VSS sg13cmos5l_buf_1
Xoutput15 bp1 net142 VDD VSS sg13cmos5l_buf_1
Xoutput16 bp2 net123 VDD VSS sg13cmos5l_buf_1
Xoutput17 bp3 net127 VDD VSS sg13cmos5l_buf_1
Xoutput18 bp4 net125 VDD VSS sg13cmos5l_buf_1
Xoutput19 bp5 net121 VDD VSS sg13cmos5l_buf_1
Xoutput20 bp6 net140 VDD VSS sg13cmos5l_buf_1
Xoutput21 bp7 net129 VDD VSS sg13cmos5l_buf_1
Xoutput22 bp8 net136 VDD VSS sg13cmos5l_buf_1
Xoutput23 bp9 net115 VDD VSS sg13cmos5l_buf_1
Xoutput24 busy net173 VDD VSS sg13cmos5l_buf_1
Xoutput25 code0 net172 VDD VSS sg13cmos5l_buf_1
Xoutput26 code1 net94 VDD VSS sg13cmos5l_buf_1
Xoutput27 code2 net87 VDD VSS sg13cmos5l_buf_1
Xoutput28 code3 net79 VDD VSS sg13cmos5l_buf_1
Xoutput29 code4 net103 VDD VSS sg13cmos5l_buf_1
Xoutput30 code5 net90 VDD VSS sg13cmos5l_buf_1
Xoutput31 code6 net84 VDD VSS sg13cmos5l_buf_1
Xoutput32 code7 net82 VDD VSS sg13cmos5l_buf_1
Xoutput33 code8 net97 VDD VSS sg13cmos5l_buf_1
Xoutput34 code9 net100 VDD VSS sg13cmos5l_buf_1
Xoutput35 comp_clk net170 VDD VSS sg13cmos5l_buf_1
Xoutput36 sample net73 VDD VSS sg13cmos5l_buf_1
Xoutput37 valid net171 VDD VSS sg13cmos5l_buf_1
Xfanout38 net38 net40 VDD VSS sg13cmos5l_buf_1
Xfanout39 net39 net40 VDD VSS sg13cmos5l_buf_1
Xfanout40 net40 _187_ VDD VSS sg13cmos5l_buf_1
Xfanout41 net41 _185_ VDD VSS sg13cmos5l_buf_1
Xfanout42 net42 _184_ VDD VSS sg13cmos5l_buf_1
Xfanout43 net43 net44 VDD VSS sg13cmos5l_buf_1
Xfanout44 net44 net45 VDD VSS sg13cmos5l_buf_1
Xfanout45 net45 _182_ VDD VSS sg13cmos5l_buf_1
Xfanout46 net46 _129_ VDD VSS sg13cmos5l_buf_1
Xfanout47 net47 _129_ VDD VSS sg13cmos5l_buf_1
Xfanout48 net48 net49 VDD VSS sg13cmos5l_buf_1
Xfanout49 net49 net50 VDD VSS sg13cmos5l_buf_1
Xfanout50 net50 _093_ VDD VSS sg13cmos5l_buf_1
Xfanout51 net51 net52 VDD VSS sg13cmos5l_buf_1
Xfanout52 net52 _088_ VDD VSS sg13cmos5l_buf_1
Xfanout53 net53 net55 VDD VSS sg13cmos5l_buf_1
Xfanout54 net54 net55 VDD VSS sg13cmos5l_buf_1
Xfanout55 net55 _085_ VDD VSS sg13cmos5l_buf_1
Xfanout56 net56 _084_ VDD VSS sg13cmos5l_buf_1
Xfanout57 net57 net174 VDD VSS sg13cmos5l_buf_1
Xfanout58 net58 u_sar.bit_idx\[1\] VDD VSS sg13cmos5l_buf_1
Xfanout59 net59 net60 VDD VSS sg13cmos5l_buf_1
Xfanout60 net60 _000_ VDD VSS sg13cmos5l_buf_1
Xfanout61 net61 net64 VDD VSS sg13cmos5l_buf_1
Xfanout62 net62 net64 VDD VSS sg13cmos5l_buf_1
Xfanout63 net63 net64 VDD VSS sg13cmos5l_buf_1
Xfanout64 net64 net93 VDD VSS sg13cmos5l_buf_1
Xfanout65 net65 net68 VDD VSS sg13cmos5l_buf_1
Xfanout66 net66 net67 VDD VSS sg13cmos5l_buf_1
Xfanout67 net67 net68 VDD VSS sg13cmos5l_buf_1
Xfanout68 net68 net93 VDD VSS sg13cmos5l_buf_1
Xclkbuf_3_0__f_clk clknet_3_0__leaf_clk clknet_0_clk VDD VSS
+ sg13cmos5l_buf_8
Xclkbuf_3_1__f_clk clknet_3_1__leaf_clk clknet_0_clk VDD VSS
+ sg13cmos5l_buf_8
Xclkbuf_3_2__f_clk clknet_3_2__leaf_clk clknet_0_clk VDD VSS
+ sg13cmos5l_buf_8
Xclkbuf_3_3__f_clk clknet_3_3__leaf_clk clknet_0_clk VDD VSS
+ sg13cmos5l_buf_8
Xclkbuf_3_4__f_clk clknet_3_4__leaf_clk clknet_0_clk VDD VSS
+ sg13cmos5l_buf_8
Xclkbuf_3_5__f_clk clknet_3_5__leaf_clk clknet_0_clk VDD VSS
+ sg13cmos5l_buf_8
Xclkbuf_3_6__f_clk clknet_3_6__leaf_clk clknet_0_clk VDD VSS
+ sg13cmos5l_buf_8
Xclkbuf_3_7__f_clk clknet_3_7__leaf_clk clknet_0_clk VDD VSS
+ sg13cmos5l_buf_8
Xclkload0 _unconnected_0 clknet_3_1__leaf_clk VDD VSS sg13cmos5l_inv_1
Xclkload1 _unconnected_1 clknet_3_2__leaf_clk VDD VSS sg13cmos5l_inv_1
Xclkload2 _unconnected_2 clknet_3_3__leaf_clk VDD VSS sg13cmos5l_inv_1
Xclkload3 _unconnected_3 clknet_3_4__leaf_clk VDD VSS sg13cmos5l_inv_1
Xclkload4 _unconnected_4 clknet_3_5__leaf_clk VDD VSS sg13cmos5l_inv_1
Xclkload5 _unconnected_5 clknet_3_6__leaf_clk VDD VSS sg13cmos5l_inv_1
Xclkload6 _unconnected_6 clknet_3_7__leaf_clk VDD VSS sg13cmos5l_inv_1
Xhold69 net69 start VDD VSS sg13cmos5l_dlygate4sd3_1
Xhold70 net70 net3 VDD VSS sg13cmos5l_dlygate4sd3_1
Xhold71 net71 _206_ VDD VSS sg13cmos5l_dlygate4sd3_1
Xhold72 net72 _047_ VDD VSS sg13cmos5l_dlygate4sd3_1
Xhold73 net73 net36 VDD VSS sg13cmos5l_dlygate4sd3_1
Xhold74 net74 _209_ VDD VSS sg13cmos5l_dlygate4sd3_1
Xhold75 net75 _048_ VDD VSS sg13cmos5l_dlygate4sd3_1
Xhold76 net76 comp VDD VSS sg13cmos5l_dlygate4sd3_1
Xhold77 net77 net1 VDD VSS sg13cmos5l_dlygate4sd3_1
Xhold78 net78 _017_ VDD VSS sg13cmos5l_dlygate4sd3_1
Xhold79 net79 net28 VDD VSS sg13cmos5l_dlygate4sd3_1
Xhold80 net80 _159_ VDD VSS sg13cmos5l_dlygate4sd3_1
Xhold81 net81 _020_ VDD VSS sg13cmos5l_dlygate4sd3_1
Xhold82 net82 net32 VDD VSS sg13cmos5l_dlygate4sd3_1
Xhold83 net83 _024_ VDD VSS sg13cmos5l_dlygate4sd3_1
Xhold84 net84 net31 VDD VSS sg13cmos5l_dlygate4sd3_1
Xhold85 net85 _171_ VDD VSS sg13cmos5l_dlygate4sd3_1
Xhold86 net86 _023_ VDD VSS sg13cmos5l_dlygate4sd3_1
Xhold87 net87 net27 VDD VSS sg13cmos5l_dlygate4sd3_1
Xhold88 net88 _154_ VDD VSS sg13cmos5l_dlygate4sd3_1
Xhold89 net89 _019_ VDD VSS sg13cmos5l_dlygate4sd3_1
Xhold90 net90 net30 VDD VSS sg13cmos5l_dlygate4sd3_1
Xhold91 net91 _022_ VDD VSS sg13cmos5l_dlygate4sd3_1
Xhold92 net92 rst_n VDD VSS sg13cmos5l_dlygate4sd3_1
Xhold93 net93 net2 VDD VSS sg13cmos5l_dlygate4sd3_1
Xhold94 net94 net26 VDD VSS sg13cmos5l_dlygate4sd3_1
Xhold95 net95 _147_ VDD VSS sg13cmos5l_dlygate4sd3_1
Xhold96 net96 _018_ VDD VSS sg13cmos5l_dlygate4sd3_1
Xhold97 net97 net33 VDD VSS sg13cmos5l_dlygate4sd3_1
Xhold98 net98 _177_ VDD VSS sg13cmos5l_dlygate4sd3_1
Xhold99 net99 _025_ VDD VSS sg13cmos5l_dlygate4sd3_1
Xhold100 net100 net34 VDD VSS sg13cmos5l_dlygate4sd3_1
Xhold101 net101 _180_ VDD VSS sg13cmos5l_dlygate4sd3_1
Xhold102 net102 _026_ VDD VSS sg13cmos5l_dlygate4sd3_1
Xhold103 net103 net29 VDD VSS sg13cmos5l_dlygate4sd3_1
Xhold104 net104 _021_ VDD VSS sg13cmos5l_dlygate4sd3_1
Xhold105 net105 u_sar.state\[2\] VDD VSS sg13cmos5l_dlygate4sd3_1
Xhold106 net106 _096_ VDD VSS sg13cmos5l_dlygate4sd3_1
Xhold107 net107 _141_ VDD VSS sg13cmos5l_dlygate4sd3_1
Xhold108 net108 _014_ VDD VSS sg13cmos5l_dlygate4sd3_1
Xhold109 net109 net10 VDD VSS sg13cmos5l_dlygate4sd3_1
Xhold110 net110 _033_ VDD VSS sg13cmos5l_dlygate4sd3_1
Xhold111 net111 u_sar.count\[3\] VDD VSS sg13cmos5l_dlygate4sd3_1
Xhold112 net112 _100_ VDD VSS sg13cmos5l_dlygate4sd3_1
Xhold113 net113 _101_ VDD VSS sg13cmos5l_dlygate4sd3_1
Xhold114 net114 _015_ VDD VSS sg13cmos5l_dlygate4sd3_1
Xhold115 net115 net23 VDD VSS sg13cmos5l_dlygate4sd3_1
Xhold116 net116 _046_ VDD VSS sg13cmos5l_dlygate4sd3_1
Xhold117 net117 u_sar.count\[0\] VDD VSS sg13cmos5l_dlygate4sd3_1
Xhold118 net118 _002_ VDD VSS sg13cmos5l_dlygate4sd3_1
Xhold119 net119 u_sar.count\[1\] VDD VSS sg13cmos5l_dlygate4sd3_1
Xhold120 net120 _003_ VDD VSS sg13cmos5l_dlygate4sd3_1
Xhold121 net121 net19 VDD VSS sg13cmos5l_dlygate4sd3_1
Xhold122 net122 _042_ VDD VSS sg13cmos5l_dlygate4sd3_1
Xhold123 net123 net16 VDD VSS sg13cmos5l_dlygate4sd3_1
Xhold124 net124 _039_ VDD VSS sg13cmos5l_dlygate4sd3_1
Xhold125 net125 net18 VDD VSS sg13cmos5l_dlygate4sd3_1
Xhold126 net126 _041_ VDD VSS sg13cmos5l_dlygate4sd3_1
Xhold127 net127 net17 VDD VSS sg13cmos5l_dlygate4sd3_1
Xhold128 net128 _040_ VDD VSS sg13cmos5l_dlygate4sd3_1
Xhold129 net129 net21 VDD VSS sg13cmos5l_dlygate4sd3_1
Xhold130 net130 _044_ VDD VSS sg13cmos5l_dlygate4sd3_1
Xhold131 net131 net14 VDD VSS sg13cmos5l_dlygate4sd3_1
Xhold132 net132 net8 VDD VSS sg13cmos5l_dlygate4sd3_1
Xhold133 net133 _031_ VDD VSS sg13cmos5l_dlygate4sd3_1
Xhold134 net134 net12 VDD VSS sg13cmos5l_dlygate4sd3_1
Xhold135 net135 _035_ VDD VSS sg13cmos5l_dlygate4sd3_1
Xhold136 net136 net22 VDD VSS sg13cmos5l_dlygate4sd3_1
Xhold137 net137 _045_ VDD VSS sg13cmos5l_dlygate4sd3_1
Xhold138 net138 net5 VDD VSS sg13cmos5l_dlygate4sd3_1
Xhold139 net139 _028_ VDD VSS sg13cmos5l_dlygate4sd3_1
Xhold140 net140 net20 VDD VSS sg13cmos5l_dlygate4sd3_1
Xhold141 net141 _043_ VDD VSS sg13cmos5l_dlygate4sd3_1
Xhold142 net142 net15 VDD VSS sg13cmos5l_dlygate4sd3_1
Xhold143 net143 _038_ VDD VSS sg13cmos5l_dlygate4sd3_1
Xhold144 net144 net9 VDD VSS sg13cmos5l_dlygate4sd3_1
Xhold145 net145 _032_ VDD VSS sg13cmos5l_dlygate4sd3_1
Xhold146 net146 net11 VDD VSS sg13cmos5l_dlygate4sd3_1
Xhold147 net147 _034_ VDD VSS sg13cmos5l_dlygate4sd3_1
Xhold148 net148 net13 VDD VSS sg13cmos5l_dlygate4sd3_1
Xhold149 net149 _036_ VDD VSS sg13cmos5l_dlygate4sd3_1
Xhold150 net150 net6 VDD VSS sg13cmos5l_dlygate4sd3_1
Xhold151 net151 _029_ VDD VSS sg13cmos5l_dlygate4sd3_1
Xhold152 net152 net7 VDD VSS sg13cmos5l_dlygate4sd3_1
Xhold153 net153 _030_ VDD VSS sg13cmos5l_dlygate4sd3_1
Xhold154 net154 net4 VDD VSS sg13cmos5l_dlygate4sd3_1
Xhold155 net155 u_sar.count\[6\] VDD VSS sg13cmos5l_dlygate4sd3_1
Xhold156 net156 _127_ VDD VSS sg13cmos5l_dlygate4sd3_1
Xhold157 net157 _008_ VDD VSS sg13cmos5l_dlygate4sd3_1
Xhold158 net158 u_sar.state\[1\] VDD VSS sg13cmos5l_dlygate4sd3_1
Xhold159 net159 _115_ VDD VSS sg13cmos5l_dlygate4sd3_1
Xhold160 net160 u_sar.count\[2\] VDD VSS sg13cmos5l_dlygate4sd3_1
Xhold161 net161 u_sar.count\[7\] VDD VSS sg13cmos5l_dlygate4sd3_1
Xhold162 net162 _009_ VDD VSS sg13cmos5l_dlygate4sd3_1
Xhold163 net163 u_sar.count\[5\] VDD VSS sg13cmos5l_dlygate4sd3_1
Xhold164 net164 _007_ VDD VSS sg13cmos5l_dlygate4sd3_1
Xhold165 net165 u_sar.count\[4\] VDD VSS sg13cmos5l_dlygate4sd3_1
Xhold166 net166 u_sar.state\[0\] VDD VSS sg13cmos5l_dlygate4sd3_1
Xhold167 net167 u_sar.bit_idx\[2\] VDD VSS sg13cmos5l_dlygate4sd3_1
Xhold168 net168 _012_ VDD VSS sg13cmos5l_dlygate4sd3_1
Xhold169 net169 _001_ VDD VSS sg13cmos5l_dlygate4sd3_1
Xhold170 net170 net35 VDD VSS sg13cmos5l_dlygate4sd3_1
Xhold171 net171 net37 VDD VSS sg13cmos5l_dlygate4sd3_1
Xhold172 net172 net25 VDD VSS sg13cmos5l_dlygate4sd3_1
Xhold173 net173 net24 VDD VSS sg13cmos5l_dlygate4sd3_1
Xhold174 net174 u_sar.bit_idx\[1\] VDD VSS sg13cmos5l_dlygate4sd3_1
XFILLER_0_0 VDD VSS sg13cmos5l_decap_8
XFILLER_0_7 VDD VSS sg13cmos5l_decap_8
XFILLER_0_14 VDD VSS sg13cmos5l_decap_8
XFILLER_0_21 VDD VSS sg13cmos5l_decap_8
XFILLER_0_28 VDD VSS sg13cmos5l_decap_8
XFILLER_0_35 VDD VSS sg13cmos5l_decap_8
XFILLER_0_42 VDD VSS sg13cmos5l_decap_8
XFILLER_0_49 VDD VSS sg13cmos5l_decap_8
XFILLER_0_56 VDD VSS sg13cmos5l_decap_4
XFILLER_0_60 VDD VSS sg13cmos5l_fill_1
XFILLER_0_95 VDD VSS sg13cmos5l_fill_2
XFILLER_0_102 VDD VSS sg13cmos5l_fill_2
XFILLER_0_113 VDD VSS sg13cmos5l_fill_1
XFILLER_1_0 VDD VSS sg13cmos5l_decap_8
XFILLER_1_7 VDD VSS sg13cmos5l_decap_8
XFILLER_1_14 VDD VSS sg13cmos5l_decap_8
XFILLER_1_21 VDD VSS sg13cmos5l_decap_8
XFILLER_1_28 VDD VSS sg13cmos5l_decap_8
XFILLER_1_35 VDD VSS sg13cmos5l_decap_8
XFILLER_1_42 VDD VSS sg13cmos5l_decap_8
XFILLER_1_49 VDD VSS sg13cmos5l_decap_4
XFILLER_1_53 VDD VSS sg13cmos5l_fill_2
XFILLER_1_114 VDD VSS sg13cmos5l_fill_2
XFILLER_1_121 VDD VSS sg13cmos5l_fill_1
XFILLER_2_0 VDD VSS sg13cmos5l_decap_8
XFILLER_2_7 VDD VSS sg13cmos5l_decap_8
XFILLER_2_14 VDD VSS sg13cmos5l_decap_8
XFILLER_2_21 VDD VSS sg13cmos5l_decap_8
XFILLER_2_28 VDD VSS sg13cmos5l_decap_8
XFILLER_2_35 VDD VSS sg13cmos5l_decap_8
XFILLER_2_42 VDD VSS sg13cmos5l_fill_2
XFILLER_2_44 VDD VSS sg13cmos5l_fill_1
XFILLER_2_99 VDD VSS sg13cmos5l_fill_2
XFILLER_3_0 VDD VSS sg13cmos5l_decap_8
XFILLER_3_7 VDD VSS sg13cmos5l_decap_8
XFILLER_3_14 VDD VSS sg13cmos5l_decap_8
XFILLER_3_21 VDD VSS sg13cmos5l_decap_8
XFILLER_3_28 VDD VSS sg13cmos5l_decap_8
XFILLER_3_35 VDD VSS sg13cmos5l_fill_2
XFILLER_3_37 VDD VSS sg13cmos5l_fill_1
XFILLER_3_116 VDD VSS sg13cmos5l_fill_1
XFILLER_4_0 VDD VSS sg13cmos5l_decap_8
XFILLER_4_7 VDD VSS sg13cmos5l_decap_8
XFILLER_4_14 VDD VSS sg13cmos5l_decap_8
XFILLER_4_21 VDD VSS sg13cmos5l_decap_8
XFILLER_4_28 VDD VSS sg13cmos5l_decap_4
XFILLER_4_32 VDD VSS sg13cmos5l_fill_2
XFILLER_4_73 VDD VSS sg13cmos5l_fill_1
XFILLER_4_109 VDD VSS sg13cmos5l_fill_2
XFILLER_5_0 VDD VSS sg13cmos5l_decap_8
XFILLER_5_7 VDD VSS sg13cmos5l_decap_8
XFILLER_5_14 VDD VSS sg13cmos5l_decap_8
XFILLER_5_21 VDD VSS sg13cmos5l_decap_8
XFILLER_5_28 VDD VSS sg13cmos5l_fill_1
XFILLER_5_62 VDD VSS sg13cmos5l_fill_2
XFILLER_5_113 VDD VSS sg13cmos5l_fill_2
XFILLER_6_0 VDD VSS sg13cmos5l_decap_8
XFILLER_6_7 VDD VSS sg13cmos5l_decap_8
XFILLER_6_14 VDD VSS sg13cmos5l_decap_8
XFILLER_6_21 VDD VSS sg13cmos5l_fill_2
XFILLER_6_80 VDD VSS sg13cmos5l_fill_2
XFILLER_6_111 VDD VSS sg13cmos5l_fill_1
XFILLER_6_175 VDD VSS sg13cmos5l_fill_2
XFILLER_7_4 VDD VSS sg13cmos5l_decap_8
XFILLER_7_11 VDD VSS sg13cmos5l_decap_8
XFILLER_7_18 VDD VSS sg13cmos5l_decap_8
XFILLER_7_25 VDD VSS sg13cmos5l_decap_4
XFILLER_7_29 VDD VSS sg13cmos5l_fill_2
XFILLER_7_103 VDD VSS sg13cmos5l_fill_2
XFILLER_7_123 VDD VSS sg13cmos5l_fill_1
XFILLER_7_145 VDD VSS sg13cmos5l_fill_2
XFILLER_8_9 VDD VSS sg13cmos5l_decap_8
XFILLER_8_16 VDD VSS sg13cmos5l_decap_8
XFILLER_8_23 VDD VSS sg13cmos5l_fill_2
XFILLER_8_25 VDD VSS sg13cmos5l_fill_1
XFILLER_8_68 VDD VSS sg13cmos5l_fill_2
XFILLER_8_133 VDD VSS sg13cmos5l_fill_2
XFILLER_8_162 VDD VSS sg13cmos5l_fill_2
XFILLER_9_0 VDD VSS sg13cmos5l_decap_8
XFILLER_9_7 VDD VSS sg13cmos5l_decap_8
XFILLER_9_14 VDD VSS sg13cmos5l_decap_8
XFILLER_9_33 VDD VSS sg13cmos5l_fill_2
XFILLER_9_60 VDD VSS sg13cmos5l_fill_1
XFILLER_9_118 VDD VSS sg13cmos5l_fill_1
XFILLER_9_145 VDD VSS sg13cmos5l_fill_2
XFILLER_10_0 VDD VSS sg13cmos5l_decap_8
XFILLER_10_7 VDD VSS sg13cmos5l_decap_8
XFILLER_10_14 VDD VSS sg13cmos5l_decap_8
XFILLER_10_21 VDD VSS sg13cmos5l_decap_4
XFILLER_10_25 VDD VSS sg13cmos5l_fill_2
XFILLER_10_66 VDD VSS sg13cmos5l_fill_1
XFILLER_10_128 VDD VSS sg13cmos5l_fill_1
XFILLER_10_134 VDD VSS sg13cmos5l_fill_2
XFILLER_11_0 VDD VSS sg13cmos5l_decap_8
XFILLER_11_7 VDD VSS sg13cmos5l_decap_8
XFILLER_11_14 VDD VSS sg13cmos5l_decap_8
XFILLER_11_21 VDD VSS sg13cmos5l_decap_4
XFILLER_11_25 VDD VSS sg13cmos5l_fill_1
XFILLER_11_56 VDD VSS sg13cmos5l_fill_2
XFILLER_11_121 VDD VSS sg13cmos5l_fill_2
XFILLER_12_0 VDD VSS sg13cmos5l_decap_8
XFILLER_12_7 VDD VSS sg13cmos5l_decap_8
XFILLER_12_14 VDD VSS sg13cmos5l_decap_4
XFILLER_12_18 VDD VSS sg13cmos5l_fill_1
XFILLER_12_97 VDD VSS sg13cmos5l_fill_2
XFILLER_12_114 VDD VSS sg13cmos5l_fill_1
XFILLER_13_0 VDD VSS sg13cmos5l_decap_8
XFILLER_13_7 VDD VSS sg13cmos5l_decap_4
XFILLER_13_11 VDD VSS sg13cmos5l_fill_2
XFILLER_13_94 VDD VSS sg13cmos5l_fill_1
XFILLER_13_100 VDD VSS sg13cmos5l_fill_1
XFILLER_13_128 VDD VSS sg13cmos5l_fill_1
XFILLER_13_141 VDD VSS sg13cmos5l_fill_1
XFILLER_13_148 VDD VSS sg13cmos5l_fill_2
XFILLER_14_0 VDD VSS sg13cmos5l_decap_8
XFILLER_14_7 VDD VSS sg13cmos5l_decap_8
XFILLER_14_14 VDD VSS sg13cmos5l_decap_8
XFILLER_14_21 VDD VSS sg13cmos5l_fill_2
XFILLER_14_58 VDD VSS sg13cmos5l_fill_2
XFILLER_14_135 VDD VSS sg13cmos5l_fill_2
XFILLER_15_4 VDD VSS sg13cmos5l_decap_8
XFILLER_15_11 VDD VSS sg13cmos5l_fill_2
XFILLER_15_56 VDD VSS sg13cmos5l_fill_2
XFILLER_15_65 VDD VSS sg13cmos5l_fill_1
XFILLER_15_93 VDD VSS sg13cmos5l_fill_2
XFILLER_16_9 VDD VSS sg13cmos5l_fill_2
XFILLER_16_11 VDD VSS sg13cmos5l_fill_1
XFILLER_16_80 VDD VSS sg13cmos5l_fill_1
XFILLER_16_185 VDD VSS sg13cmos5l_fill_1
XFILLER_17_0 VDD VSS sg13cmos5l_decap_4
XFILLER_17_87 VDD VSS sg13cmos5l_fill_2
XFILLER_17_108 VDD VSS sg13cmos5l_fill_2
XFILLER_17_125 VDD VSS sg13cmos5l_fill_1
XFILLER_18_89 VDD VSS sg13cmos5l_fill_1
XFILLER_19_66 VDD VSS sg13cmos5l_fill_1
XFILLER_19_135 VDD VSS sg13cmos5l_fill_2
XFILLER_20_0 VDD VSS sg13cmos5l_fill_2
XFILLER_20_2 VDD VSS sg13cmos5l_fill_1
XFILLER_20_118 VDD VSS sg13cmos5l_fill_2
XFILLER_21_185 VDD VSS sg13cmos5l_fill_1
XFILLER_22_59 VDD VSS sg13cmos5l_fill_1
XFILLER_22_105 VDD VSS sg13cmos5l_fill_1
XFILLER_22_158 VDD VSS sg13cmos5l_fill_1
.ENDS sar_fsm_wrapper_pnr

.subckt sar_fsm_wrapper clk rst_n start comp sample comp_clk busy valid bp9 bp8 bp7 bp6 bp5 bp4 bp3 bp2 bp1 bp0 bn9 bn8 bn7 bn6 bn5 bn4 bn3 bn2 bn1 bn0 code9 code8 code7 code6 code5 code4 code3 code2 code1 code0 VDD VSS
XPNR bn0 bn1 bn2 bn3 bn4 bn5 bn6 bn7 bn8 bn9 bp0 bp1 bp2 bp3 bp4 bp5 bp6 bp7 bp8 bp9 busy clk code0 code1 code2 code3 code4 code5 code6 code7 code8 code9 comp comp_clk rst_n sample start valid VDD VSS sar_fsm_wrapper_pnr
.ends sar_fsm_wrapper
.end

* ---- slot_16 (Chipalooza slot 16) --------------------------------------------------------------
* ports: sg13cmos5l_ocd_chipalooza/verilog/gl/slot16_wrapper_lvs.v (order preserved)
* ADC reference: circuit_files/sar_adc_test/layout/rev13_final_frozen/sar_10_bit_lvs_reference_m512_LVSexport.spice sha256 49b5ea70083086860b22966ffdb78a7cc0897c3b102dca175f84b47048d88b12
.subckt slot_16 vss_1v2 s16_an[0] s16_an[1] s16_an_0_esd s16_an_1_esd vbias dig_in[23] dig_in[22] dig_in[21] dig_in[20] dig_in[19] dig_in[18] dig_in[17] dig_in[16] dig_in[15] dig_in[14] dig_in[13] dig_in[12] dig_in[11] dig_in[10] dig_in[9] dig_in[8] dig_in[7] dig_in[6] dig_in[5] dig_in[4] dig_in[3] dig_in[2] dig_in[1] dig_in[0] dig_out[11] dig_out[10] dig_out[9] dig_out[8] dig_out[7] dig_out[6] dig_out[5] dig_out[4] dig_out[3] dig_out[2] dig_out[1] dig_out[0] ibias0 ibias1 analog_bus3 analog_bus2 analog_bus1 analog_bus0 vdd_1v2 vss_3v3 vdd_3v3 enable clk reset
XADC dig_in[1] dig_out[10] dig_in[0] dig_out[11] analog_bus1 analog_bus0 s16_an[1] s16_an[0] clk dig_out[0] dig_out[9] dig_out[1] dig_out[5] dig_out[6] dig_out[2] dig_out[7] dig_out[3] dig_out[8] dig_out[4] vss_3v3 vdd_3v3 adc_voutn_nc vdd_1v2 sar_10_bit
.ends slot_16
