** sch_path: /home/arjun/eda/projects/SAR_ADC/circuit_files/sar_adc_test/xschem/strong_arm_comp.sch
.subckt strong_arm_comp Voutn Vinn Voutp Vinp vdd vss CLK
*.PININFO Vinn:I Voutp:O vdd:B Vinp:I CLK:I vss:B Voutn:O
MM1 P CLK vdd vdd sg13_hv_pmos w=2u l=0.4u ng=1 m=4
MM2 net1 CLK vss vss sg13_hv_nmos w=2u l=0.45u ng=1 m=8
MM3 X CLK vdd vdd sg13_hv_pmos w=2u l=0.4u ng=1 m=4
MM4 P Vinn net1 vss sg13_hv_nmos w=2u l=0.45u ng=1 m=6
MM5 Q Vinp net1 vss sg13_hv_nmos w=2u l=0.45u ng=1 m=6
MM6 X Y P vss sg13_hv_nmos w=2u l=0.45u ng=1 m=2
MM7 Y X Q vss sg13_hv_nmos w=2u l=0.45u ng=1 m=2
MM8 X Y vdd vdd sg13_hv_pmos w=2u l=0.4u ng=1 m=4
MM9 Y CLK vdd vdd sg13_hv_pmos w=2u l=0.4u ng=1 m=4
MM10 Q CLK vdd vdd sg13_hv_pmos w=2u l=0.4u ng=1 m=4
MM11 Y X vdd vdd sg13_hv_pmos w=2u l=0.4u ng=1 m=4
MM12 net2 X vss vss sg13_hv_nmos w=2u l=0.45u ng=1
MM13 Voutp net2 vss vss sg13_hv_nmos w=2u l=0.45u ng=1 m=2
MM14 Voutn net3 vss vss sg13_hv_nmos w=2u l=0.45u ng=1 m=2
MM15 net3 Y vss vss sg13_hv_nmos w=2u l=0.45u ng=1
MM16 net2 X vdd vdd sg13_hv_pmos w=2u l=0.4u ng=1 m=2
MM17 Voutp Voutn vdd vdd sg13_hv_pmos w=2u l=0.4u ng=1 m=4
MM18 net3 Y vdd vdd sg13_hv_pmos w=2u l=0.4u ng=1 m=2
MM19 Voutn Voutp vdd vdd sg13_hv_pmos w=2u l=0.4u ng=1 m=4
.ends
