* Generated LVS reference; original schematic netlist is unchanged.
** sch_path: /home/arjun/eda/projects/SAR_ADC/circuit_files/sar_adc_test/xschem/cdac_caps_10b_diff.sch
.subckt cdac_array_10b_diff vcp bp3 bp0 bp5 bp2 bpd bp1 bp7 bp6 bp8 bp4 bp9 vcn bn0 bn1 bn8 bn7 bn6 bn5 bn4 bn3 bn9 bn2 bnd
*.PININFO vcp:B vcn:B bpd:B bp0:B bp1:B bp2:B bp3:B bp4:B bp5:B bp6:B bp7:B bp8:B bp9:B bnd:B bn1:B bn2:B bn3:B bn4:B bn5:B bn6:B
*+ bn7:B bn8:B bn9:B bn0:B
C_LVS_XC1_1 vcp bpd cap_cmomi w=2.67e-6 l=2.52e-6 m=1
C_LVS_XC2_1 vcp bp0 cap_cmomi w=2.67e-6 l=2.52e-6 m=1
C_LVS_XC3_1 vcp bp1 cap_cmomi w=2.67e-6 l=2.52e-6 m=1
C_LVS_XC3_2 vcp bp1 cap_cmomi w=2.67e-6 l=2.52e-6 m=1
C_LVS_XC4_1 vcp bp2 cap_cmomi w=2.67e-6 l=2.52e-6 m=1
C_LVS_XC4_2 vcp bp2 cap_cmomi w=2.67e-6 l=2.52e-6 m=1
C_LVS_XC4_3 vcp bp2 cap_cmomi w=2.67e-6 l=2.52e-6 m=1
C_LVS_XC4_4 vcp bp2 cap_cmomi w=2.67e-6 l=2.52e-6 m=1
C_LVS_XC5_1 vcp bp3 cap_cmomi w=2.67e-6 l=2.52e-6 m=1
C_LVS_XC5_2 vcp bp3 cap_cmomi w=2.67e-6 l=2.52e-6 m=1
C_LVS_XC5_3 vcp bp3 cap_cmomi w=2.67e-6 l=2.52e-6 m=1
C_LVS_XC5_4 vcp bp3 cap_cmomi w=2.67e-6 l=2.52e-6 m=1
C_LVS_XC5_5 vcp bp3 cap_cmomi w=2.67e-6 l=2.52e-6 m=1
C_LVS_XC5_6 vcp bp3 cap_cmomi w=2.67e-6 l=2.52e-6 m=1
C_LVS_XC5_7 vcp bp3 cap_cmomi w=2.67e-6 l=2.52e-6 m=1
C_LVS_XC5_8 vcp bp3 cap_cmomi w=2.67e-6 l=2.52e-6 m=1
C_LVS_XC6_1 vcp bp4 cap_cmomi w=2.67e-6 l=2.52e-6 m=1
C_LVS_XC6_2 vcp bp4 cap_cmomi w=2.67e-6 l=2.52e-6 m=1
C_LVS_XC6_3 vcp bp4 cap_cmomi w=2.67e-6 l=2.52e-6 m=1
C_LVS_XC6_4 vcp bp4 cap_cmomi w=2.67e-6 l=2.52e-6 m=1
C_LVS_XC6_5 vcp bp4 cap_cmomi w=2.67e-6 l=2.52e-6 m=1
C_LVS_XC6_6 vcp bp4 cap_cmomi w=2.67e-6 l=2.52e-6 m=1
C_LVS_XC6_7 vcp bp4 cap_cmomi w=2.67e-6 l=2.52e-6 m=1
C_LVS_XC6_8 vcp bp4 cap_cmomi w=2.67e-6 l=2.52e-6 m=1
C_LVS_XC6_9 vcp bp4 cap_cmomi w=2.67e-6 l=2.52e-6 m=1
C_LVS_XC6_10 vcp bp4 cap_cmomi w=2.67e-6 l=2.52e-6 m=1
C_LVS_XC6_11 vcp bp4 cap_cmomi w=2.67e-6 l=2.52e-6 m=1
C_LVS_XC6_12 vcp bp4 cap_cmomi w=2.67e-6 l=2.52e-6 m=1
C_LVS_XC6_13 vcp bp4 cap_cmomi w=2.67e-6 l=2.52e-6 m=1
C_LVS_XC6_14 vcp bp4 cap_cmomi w=2.67e-6 l=2.52e-6 m=1
C_LVS_XC6_15 vcp bp4 cap_cmomi w=2.67e-6 l=2.52e-6 m=1
C_LVS_XC6_16 vcp bp4 cap_cmomi w=2.67e-6 l=2.52e-6 m=1
C_LVS_XC7_1 vcp bp5 cap_cmomi w=2.67e-6 l=2.52e-6 m=1
C_LVS_XC7_2 vcp bp5 cap_cmomi w=2.67e-6 l=2.52e-6 m=1
C_LVS_XC7_3 vcp bp5 cap_cmomi w=2.67e-6 l=2.52e-6 m=1
C_LVS_XC7_4 vcp bp5 cap_cmomi w=2.67e-6 l=2.52e-6 m=1
C_LVS_XC7_5 vcp bp5 cap_cmomi w=2.67e-6 l=2.52e-6 m=1
C_LVS_XC7_6 vcp bp5 cap_cmomi w=2.67e-6 l=2.52e-6 m=1
C_LVS_XC7_7 vcp bp5 cap_cmomi w=2.67e-6 l=2.52e-6 m=1
C_LVS_XC7_8 vcp bp5 cap_cmomi w=2.67e-6 l=2.52e-6 m=1
C_LVS_XC7_9 vcp bp5 cap_cmomi w=2.67e-6 l=2.52e-6 m=1
C_LVS_XC7_10 vcp bp5 cap_cmomi w=2.67e-6 l=2.52e-6 m=1
C_LVS_XC7_11 vcp bp5 cap_cmomi w=2.67e-6 l=2.52e-6 m=1
C_LVS_XC7_12 vcp bp5 cap_cmomi w=2.67e-6 l=2.52e-6 m=1
C_LVS_XC7_13 vcp bp5 cap_cmomi w=2.67e-6 l=2.52e-6 m=1
C_LVS_XC7_14 vcp bp5 cap_cmomi w=2.67e-6 l=2.52e-6 m=1
C_LVS_XC7_15 vcp bp5 cap_cmomi w=2.67e-6 l=2.52e-6 m=1
C_LVS_XC7_16 vcp bp5 cap_cmomi w=2.67e-6 l=2.52e-6 m=1
C_LVS_XC7_17 vcp bp5 cap_cmomi w=2.67e-6 l=2.52e-6 m=1
C_LVS_XC7_18 vcp bp5 cap_cmomi w=2.67e-6 l=2.52e-6 m=1
C_LVS_XC7_19 vcp bp5 cap_cmomi w=2.67e-6 l=2.52e-6 m=1
C_LVS_XC7_20 vcp bp5 cap_cmomi w=2.67e-6 l=2.52e-6 m=1
C_LVS_XC7_21 vcp bp5 cap_cmomi w=2.67e-6 l=2.52e-6 m=1
C_LVS_XC7_22 vcp bp5 cap_cmomi w=2.67e-6 l=2.52e-6 m=1
C_LVS_XC7_23 vcp bp5 cap_cmomi w=2.67e-6 l=2.52e-6 m=1
C_LVS_XC7_24 vcp bp5 cap_cmomi w=2.67e-6 l=2.52e-6 m=1
C_LVS_XC7_25 vcp bp5 cap_cmomi w=2.67e-6 l=2.52e-6 m=1
C_LVS_XC7_26 vcp bp5 cap_cmomi w=2.67e-6 l=2.52e-6 m=1
C_LVS_XC7_27 vcp bp5 cap_cmomi w=2.67e-6 l=2.52e-6 m=1
C_LVS_XC7_28 vcp bp5 cap_cmomi w=2.67e-6 l=2.52e-6 m=1
C_LVS_XC7_29 vcp bp5 cap_cmomi w=2.67e-6 l=2.52e-6 m=1
C_LVS_XC7_30 vcp bp5 cap_cmomi w=2.67e-6 l=2.52e-6 m=1
C_LVS_XC7_31 vcp bp5 cap_cmomi w=2.67e-6 l=2.52e-6 m=1
C_LVS_XC7_32 vcp bp5 cap_cmomi w=2.67e-6 l=2.52e-6 m=1
C_LVS_XC8_1 vcp bp6 cap_cmomi w=2.67e-6 l=2.52e-6 m=1
C_LVS_XC8_2 vcp bp6 cap_cmomi w=2.67e-6 l=2.52e-6 m=1
C_LVS_XC8_3 vcp bp6 cap_cmomi w=2.67e-6 l=2.52e-6 m=1
C_LVS_XC8_4 vcp bp6 cap_cmomi w=2.67e-6 l=2.52e-6 m=1
C_LVS_XC8_5 vcp bp6 cap_cmomi w=2.67e-6 l=2.52e-6 m=1
C_LVS_XC8_6 vcp bp6 cap_cmomi w=2.67e-6 l=2.52e-6 m=1
C_LVS_XC8_7 vcp bp6 cap_cmomi w=2.67e-6 l=2.52e-6 m=1
C_LVS_XC8_8 vcp bp6 cap_cmomi w=2.67e-6 l=2.52e-6 m=1
C_LVS_XC8_9 vcp bp6 cap_cmomi w=2.67e-6 l=2.52e-6 m=1
C_LVS_XC8_10 vcp bp6 cap_cmomi w=2.67e-6 l=2.52e-6 m=1
C_LVS_XC8_11 vcp bp6 cap_cmomi w=2.67e-6 l=2.52e-6 m=1
C_LVS_XC8_12 vcp bp6 cap_cmomi w=2.67e-6 l=2.52e-6 m=1
C_LVS_XC8_13 vcp bp6 cap_cmomi w=2.67e-6 l=2.52e-6 m=1
C_LVS_XC8_14 vcp bp6 cap_cmomi w=2.67e-6 l=2.52e-6 m=1
C_LVS_XC8_15 vcp bp6 cap_cmomi w=2.67e-6 l=2.52e-6 m=1
C_LVS_XC8_16 vcp bp6 cap_cmomi w=2.67e-6 l=2.52e-6 m=1
C_LVS_XC8_17 vcp bp6 cap_cmomi w=2.67e-6 l=2.52e-6 m=1
C_LVS_XC8_18 vcp bp6 cap_cmomi w=2.67e-6 l=2.52e-6 m=1
C_LVS_XC8_19 vcp bp6 cap_cmomi w=2.67e-6 l=2.52e-6 m=1
C_LVS_XC8_20 vcp bp6 cap_cmomi w=2.67e-6 l=2.52e-6 m=1
C_LVS_XC8_21 vcp bp6 cap_cmomi w=2.67e-6 l=2.52e-6 m=1
C_LVS_XC8_22 vcp bp6 cap_cmomi w=2.67e-6 l=2.52e-6 m=1
C_LVS_XC8_23 vcp bp6 cap_cmomi w=2.67e-6 l=2.52e-6 m=1
C_LVS_XC8_24 vcp bp6 cap_cmomi w=2.67e-6 l=2.52e-6 m=1
C_LVS_XC8_25 vcp bp6 cap_cmomi w=2.67e-6 l=2.52e-6 m=1
C_LVS_XC8_26 vcp bp6 cap_cmomi w=2.67e-6 l=2.52e-6 m=1
C_LVS_XC8_27 vcp bp6 cap_cmomi w=2.67e-6 l=2.52e-6 m=1
C_LVS_XC8_28 vcp bp6 cap_cmomi w=2.67e-6 l=2.52e-6 m=1
C_LVS_XC8_29 vcp bp6 cap_cmomi w=2.67e-6 l=2.52e-6 m=1
C_LVS_XC8_30 vcp bp6 cap_cmomi w=2.67e-6 l=2.52e-6 m=1
C_LVS_XC8_31 vcp bp6 cap_cmomi w=2.67e-6 l=2.52e-6 m=1
C_LVS_XC8_32 vcp bp6 cap_cmomi w=2.67e-6 l=2.52e-6 m=1
C_LVS_XC8_33 vcp bp6 cap_cmomi w=2.67e-6 l=2.52e-6 m=1
C_LVS_XC8_34 vcp bp6 cap_cmomi w=2.67e-6 l=2.52e-6 m=1
C_LVS_XC8_35 vcp bp6 cap_cmomi w=2.67e-6 l=2.52e-6 m=1
C_LVS_XC8_36 vcp bp6 cap_cmomi w=2.67e-6 l=2.52e-6 m=1
C_LVS_XC8_37 vcp bp6 cap_cmomi w=2.67e-6 l=2.52e-6 m=1
C_LVS_XC8_38 vcp bp6 cap_cmomi w=2.67e-6 l=2.52e-6 m=1
C_LVS_XC8_39 vcp bp6 cap_cmomi w=2.67e-6 l=2.52e-6 m=1
C_LVS_XC8_40 vcp bp6 cap_cmomi w=2.67e-6 l=2.52e-6 m=1
C_LVS_XC8_41 vcp bp6 cap_cmomi w=2.67e-6 l=2.52e-6 m=1
C_LVS_XC8_42 vcp bp6 cap_cmomi w=2.67e-6 l=2.52e-6 m=1
C_LVS_XC8_43 vcp bp6 cap_cmomi w=2.67e-6 l=2.52e-6 m=1
C_LVS_XC8_44 vcp bp6 cap_cmomi w=2.67e-6 l=2.52e-6 m=1
C_LVS_XC8_45 vcp bp6 cap_cmomi w=2.67e-6 l=2.52e-6 m=1
C_LVS_XC8_46 vcp bp6 cap_cmomi w=2.67e-6 l=2.52e-6 m=1
C_LVS_XC8_47 vcp bp6 cap_cmomi w=2.67e-6 l=2.52e-6 m=1
C_LVS_XC8_48 vcp bp6 cap_cmomi w=2.67e-6 l=2.52e-6 m=1
C_LVS_XC8_49 vcp bp6 cap_cmomi w=2.67e-6 l=2.52e-6 m=1
C_LVS_XC8_50 vcp bp6 cap_cmomi w=2.67e-6 l=2.52e-6 m=1
C_LVS_XC8_51 vcp bp6 cap_cmomi w=2.67e-6 l=2.52e-6 m=1
C_LVS_XC8_52 vcp bp6 cap_cmomi w=2.67e-6 l=2.52e-6 m=1
C_LVS_XC8_53 vcp bp6 cap_cmomi w=2.67e-6 l=2.52e-6 m=1
C_LVS_XC8_54 vcp bp6 cap_cmomi w=2.67e-6 l=2.52e-6 m=1
C_LVS_XC8_55 vcp bp6 cap_cmomi w=2.67e-6 l=2.52e-6 m=1
C_LVS_XC8_56 vcp bp6 cap_cmomi w=2.67e-6 l=2.52e-6 m=1
C_LVS_XC8_57 vcp bp6 cap_cmomi w=2.67e-6 l=2.52e-6 m=1
C_LVS_XC8_58 vcp bp6 cap_cmomi w=2.67e-6 l=2.52e-6 m=1
C_LVS_XC8_59 vcp bp6 cap_cmomi w=2.67e-6 l=2.52e-6 m=1
C_LVS_XC8_60 vcp bp6 cap_cmomi w=2.67e-6 l=2.52e-6 m=1
C_LVS_XC8_61 vcp bp6 cap_cmomi w=2.67e-6 l=2.52e-6 m=1
C_LVS_XC8_62 vcp bp6 cap_cmomi w=2.67e-6 l=2.52e-6 m=1
C_LVS_XC8_63 vcp bp6 cap_cmomi w=2.67e-6 l=2.52e-6 m=1
C_LVS_XC8_64 vcp bp6 cap_cmomi w=2.67e-6 l=2.52e-6 m=1
C_LVS_XC9_1 vcp bp7 cap_cmomi w=2.67e-6 l=2.52e-6 m=1
C_LVS_XC9_2 vcp bp7 cap_cmomi w=2.67e-6 l=2.52e-6 m=1
C_LVS_XC9_3 vcp bp7 cap_cmomi w=2.67e-6 l=2.52e-6 m=1
C_LVS_XC9_4 vcp bp7 cap_cmomi w=2.67e-6 l=2.52e-6 m=1
C_LVS_XC9_5 vcp bp7 cap_cmomi w=2.67e-6 l=2.52e-6 m=1
C_LVS_XC9_6 vcp bp7 cap_cmomi w=2.67e-6 l=2.52e-6 m=1
C_LVS_XC9_7 vcp bp7 cap_cmomi w=2.67e-6 l=2.52e-6 m=1
C_LVS_XC9_8 vcp bp7 cap_cmomi w=2.67e-6 l=2.52e-6 m=1
C_LVS_XC9_9 vcp bp7 cap_cmomi w=2.67e-6 l=2.52e-6 m=1
C_LVS_XC9_10 vcp bp7 cap_cmomi w=2.67e-6 l=2.52e-6 m=1
C_LVS_XC9_11 vcp bp7 cap_cmomi w=2.67e-6 l=2.52e-6 m=1
C_LVS_XC9_12 vcp bp7 cap_cmomi w=2.67e-6 l=2.52e-6 m=1
C_LVS_XC9_13 vcp bp7 cap_cmomi w=2.67e-6 l=2.52e-6 m=1
C_LVS_XC9_14 vcp bp7 cap_cmomi w=2.67e-6 l=2.52e-6 m=1
C_LVS_XC9_15 vcp bp7 cap_cmomi w=2.67e-6 l=2.52e-6 m=1
C_LVS_XC9_16 vcp bp7 cap_cmomi w=2.67e-6 l=2.52e-6 m=1
C_LVS_XC9_17 vcp bp7 cap_cmomi w=2.67e-6 l=2.52e-6 m=1
C_LVS_XC9_18 vcp bp7 cap_cmomi w=2.67e-6 l=2.52e-6 m=1
C_LVS_XC9_19 vcp bp7 cap_cmomi w=2.67e-6 l=2.52e-6 m=1
C_LVS_XC9_20 vcp bp7 cap_cmomi w=2.67e-6 l=2.52e-6 m=1
C_LVS_XC9_21 vcp bp7 cap_cmomi w=2.67e-6 l=2.52e-6 m=1
C_LVS_XC9_22 vcp bp7 cap_cmomi w=2.67e-6 l=2.52e-6 m=1
C_LVS_XC9_23 vcp bp7 cap_cmomi w=2.67e-6 l=2.52e-6 m=1
C_LVS_XC9_24 vcp bp7 cap_cmomi w=2.67e-6 l=2.52e-6 m=1
C_LVS_XC9_25 vcp bp7 cap_cmomi w=2.67e-6 l=2.52e-6 m=1
C_LVS_XC9_26 vcp bp7 cap_cmomi w=2.67e-6 l=2.52e-6 m=1
C_LVS_XC9_27 vcp bp7 cap_cmomi w=2.67e-6 l=2.52e-6 m=1
C_LVS_XC9_28 vcp bp7 cap_cmomi w=2.67e-6 l=2.52e-6 m=1
C_LVS_XC9_29 vcp bp7 cap_cmomi w=2.67e-6 l=2.52e-6 m=1
C_LVS_XC9_30 vcp bp7 cap_cmomi w=2.67e-6 l=2.52e-6 m=1
C_LVS_XC9_31 vcp bp7 cap_cmomi w=2.67e-6 l=2.52e-6 m=1
C_LVS_XC9_32 vcp bp7 cap_cmomi w=2.67e-6 l=2.52e-6 m=1
C_LVS_XC9_33 vcp bp7 cap_cmomi w=2.67e-6 l=2.52e-6 m=1
C_LVS_XC9_34 vcp bp7 cap_cmomi w=2.67e-6 l=2.52e-6 m=1
C_LVS_XC9_35 vcp bp7 cap_cmomi w=2.67e-6 l=2.52e-6 m=1
C_LVS_XC9_36 vcp bp7 cap_cmomi w=2.67e-6 l=2.52e-6 m=1
C_LVS_XC9_37 vcp bp7 cap_cmomi w=2.67e-6 l=2.52e-6 m=1
C_LVS_XC9_38 vcp bp7 cap_cmomi w=2.67e-6 l=2.52e-6 m=1
C_LVS_XC9_39 vcp bp7 cap_cmomi w=2.67e-6 l=2.52e-6 m=1
C_LVS_XC9_40 vcp bp7 cap_cmomi w=2.67e-6 l=2.52e-6 m=1
C_LVS_XC9_41 vcp bp7 cap_cmomi w=2.67e-6 l=2.52e-6 m=1
C_LVS_XC9_42 vcp bp7 cap_cmomi w=2.67e-6 l=2.52e-6 m=1
C_LVS_XC9_43 vcp bp7 cap_cmomi w=2.67e-6 l=2.52e-6 m=1
C_LVS_XC9_44 vcp bp7 cap_cmomi w=2.67e-6 l=2.52e-6 m=1
C_LVS_XC9_45 vcp bp7 cap_cmomi w=2.67e-6 l=2.52e-6 m=1
C_LVS_XC9_46 vcp bp7 cap_cmomi w=2.67e-6 l=2.52e-6 m=1
C_LVS_XC9_47 vcp bp7 cap_cmomi w=2.67e-6 l=2.52e-6 m=1
C_LVS_XC9_48 vcp bp7 cap_cmomi w=2.67e-6 l=2.52e-6 m=1
C_LVS_XC9_49 vcp bp7 cap_cmomi w=2.67e-6 l=2.52e-6 m=1
C_LVS_XC9_50 vcp bp7 cap_cmomi w=2.67e-6 l=2.52e-6 m=1
C_LVS_XC9_51 vcp bp7 cap_cmomi w=2.67e-6 l=2.52e-6 m=1
C_LVS_XC9_52 vcp bp7 cap_cmomi w=2.67e-6 l=2.52e-6 m=1
C_LVS_XC9_53 vcp bp7 cap_cmomi w=2.67e-6 l=2.52e-6 m=1
C_LVS_XC9_54 vcp bp7 cap_cmomi w=2.67e-6 l=2.52e-6 m=1
C_LVS_XC9_55 vcp bp7 cap_cmomi w=2.67e-6 l=2.52e-6 m=1
C_LVS_XC9_56 vcp bp7 cap_cmomi w=2.67e-6 l=2.52e-6 m=1
C_LVS_XC9_57 vcp bp7 cap_cmomi w=2.67e-6 l=2.52e-6 m=1
C_LVS_XC9_58 vcp bp7 cap_cmomi w=2.67e-6 l=2.52e-6 m=1
C_LVS_XC9_59 vcp bp7 cap_cmomi w=2.67e-6 l=2.52e-6 m=1
C_LVS_XC9_60 vcp bp7 cap_cmomi w=2.67e-6 l=2.52e-6 m=1
C_LVS_XC9_61 vcp bp7 cap_cmomi w=2.67e-6 l=2.52e-6 m=1
C_LVS_XC9_62 vcp bp7 cap_cmomi w=2.67e-6 l=2.52e-6 m=1
C_LVS_XC9_63 vcp bp7 cap_cmomi w=2.67e-6 l=2.52e-6 m=1
C_LVS_XC9_64 vcp bp7 cap_cmomi w=2.67e-6 l=2.52e-6 m=1
C_LVS_XC9_65 vcp bp7 cap_cmomi w=2.67e-6 l=2.52e-6 m=1
C_LVS_XC9_66 vcp bp7 cap_cmomi w=2.67e-6 l=2.52e-6 m=1
C_LVS_XC9_67 vcp bp7 cap_cmomi w=2.67e-6 l=2.52e-6 m=1
C_LVS_XC9_68 vcp bp7 cap_cmomi w=2.67e-6 l=2.52e-6 m=1
C_LVS_XC9_69 vcp bp7 cap_cmomi w=2.67e-6 l=2.52e-6 m=1
C_LVS_XC9_70 vcp bp7 cap_cmomi w=2.67e-6 l=2.52e-6 m=1
C_LVS_XC9_71 vcp bp7 cap_cmomi w=2.67e-6 l=2.52e-6 m=1
C_LVS_XC9_72 vcp bp7 cap_cmomi w=2.67e-6 l=2.52e-6 m=1
C_LVS_XC9_73 vcp bp7 cap_cmomi w=2.67e-6 l=2.52e-6 m=1
C_LVS_XC9_74 vcp bp7 cap_cmomi w=2.67e-6 l=2.52e-6 m=1
C_LVS_XC9_75 vcp bp7 cap_cmomi w=2.67e-6 l=2.52e-6 m=1
C_LVS_XC9_76 vcp bp7 cap_cmomi w=2.67e-6 l=2.52e-6 m=1
C_LVS_XC9_77 vcp bp7 cap_cmomi w=2.67e-6 l=2.52e-6 m=1
C_LVS_XC9_78 vcp bp7 cap_cmomi w=2.67e-6 l=2.52e-6 m=1
C_LVS_XC9_79 vcp bp7 cap_cmomi w=2.67e-6 l=2.52e-6 m=1
C_LVS_XC9_80 vcp bp7 cap_cmomi w=2.67e-6 l=2.52e-6 m=1
C_LVS_XC9_81 vcp bp7 cap_cmomi w=2.67e-6 l=2.52e-6 m=1
C_LVS_XC9_82 vcp bp7 cap_cmomi w=2.67e-6 l=2.52e-6 m=1
C_LVS_XC9_83 vcp bp7 cap_cmomi w=2.67e-6 l=2.52e-6 m=1
C_LVS_XC9_84 vcp bp7 cap_cmomi w=2.67e-6 l=2.52e-6 m=1
C_LVS_XC9_85 vcp bp7 cap_cmomi w=2.67e-6 l=2.52e-6 m=1
C_LVS_XC9_86 vcp bp7 cap_cmomi w=2.67e-6 l=2.52e-6 m=1
C_LVS_XC9_87 vcp bp7 cap_cmomi w=2.67e-6 l=2.52e-6 m=1
C_LVS_XC9_88 vcp bp7 cap_cmomi w=2.67e-6 l=2.52e-6 m=1
C_LVS_XC9_89 vcp bp7 cap_cmomi w=2.67e-6 l=2.52e-6 m=1
C_LVS_XC9_90 vcp bp7 cap_cmomi w=2.67e-6 l=2.52e-6 m=1
C_LVS_XC9_91 vcp bp7 cap_cmomi w=2.67e-6 l=2.52e-6 m=1
C_LVS_XC9_92 vcp bp7 cap_cmomi w=2.67e-6 l=2.52e-6 m=1
C_LVS_XC9_93 vcp bp7 cap_cmomi w=2.67e-6 l=2.52e-6 m=1
C_LVS_XC9_94 vcp bp7 cap_cmomi w=2.67e-6 l=2.52e-6 m=1
C_LVS_XC9_95 vcp bp7 cap_cmomi w=2.67e-6 l=2.52e-6 m=1
C_LVS_XC9_96 vcp bp7 cap_cmomi w=2.67e-6 l=2.52e-6 m=1
C_LVS_XC9_97 vcp bp7 cap_cmomi w=2.67e-6 l=2.52e-6 m=1
C_LVS_XC9_98 vcp bp7 cap_cmomi w=2.67e-6 l=2.52e-6 m=1
C_LVS_XC9_99 vcp bp7 cap_cmomi w=2.67e-6 l=2.52e-6 m=1
C_LVS_XC9_100 vcp bp7 cap_cmomi w=2.67e-6 l=2.52e-6 m=1
C_LVS_XC9_101 vcp bp7 cap_cmomi w=2.67e-6 l=2.52e-6 m=1
C_LVS_XC9_102 vcp bp7 cap_cmomi w=2.67e-6 l=2.52e-6 m=1
C_LVS_XC9_103 vcp bp7 cap_cmomi w=2.67e-6 l=2.52e-6 m=1
C_LVS_XC9_104 vcp bp7 cap_cmomi w=2.67e-6 l=2.52e-6 m=1
C_LVS_XC9_105 vcp bp7 cap_cmomi w=2.67e-6 l=2.52e-6 m=1
C_LVS_XC9_106 vcp bp7 cap_cmomi w=2.67e-6 l=2.52e-6 m=1
C_LVS_XC9_107 vcp bp7 cap_cmomi w=2.67e-6 l=2.52e-6 m=1
C_LVS_XC9_108 vcp bp7 cap_cmomi w=2.67e-6 l=2.52e-6 m=1
C_LVS_XC9_109 vcp bp7 cap_cmomi w=2.67e-6 l=2.52e-6 m=1
C_LVS_XC9_110 vcp bp7 cap_cmomi w=2.67e-6 l=2.52e-6 m=1
C_LVS_XC9_111 vcp bp7 cap_cmomi w=2.67e-6 l=2.52e-6 m=1
C_LVS_XC9_112 vcp bp7 cap_cmomi w=2.67e-6 l=2.52e-6 m=1
C_LVS_XC9_113 vcp bp7 cap_cmomi w=2.67e-6 l=2.52e-6 m=1
C_LVS_XC9_114 vcp bp7 cap_cmomi w=2.67e-6 l=2.52e-6 m=1
C_LVS_XC9_115 vcp bp7 cap_cmomi w=2.67e-6 l=2.52e-6 m=1
C_LVS_XC9_116 vcp bp7 cap_cmomi w=2.67e-6 l=2.52e-6 m=1
C_LVS_XC9_117 vcp bp7 cap_cmomi w=2.67e-6 l=2.52e-6 m=1
C_LVS_XC9_118 vcp bp7 cap_cmomi w=2.67e-6 l=2.52e-6 m=1
C_LVS_XC9_119 vcp bp7 cap_cmomi w=2.67e-6 l=2.52e-6 m=1
C_LVS_XC9_120 vcp bp7 cap_cmomi w=2.67e-6 l=2.52e-6 m=1
C_LVS_XC9_121 vcp bp7 cap_cmomi w=2.67e-6 l=2.52e-6 m=1
C_LVS_XC9_122 vcp bp7 cap_cmomi w=2.67e-6 l=2.52e-6 m=1
C_LVS_XC9_123 vcp bp7 cap_cmomi w=2.67e-6 l=2.52e-6 m=1
C_LVS_XC9_124 vcp bp7 cap_cmomi w=2.67e-6 l=2.52e-6 m=1
C_LVS_XC9_125 vcp bp7 cap_cmomi w=2.67e-6 l=2.52e-6 m=1
C_LVS_XC9_126 vcp bp7 cap_cmomi w=2.67e-6 l=2.52e-6 m=1
C_LVS_XC9_127 vcp bp7 cap_cmomi w=2.67e-6 l=2.52e-6 m=1
C_LVS_XC9_128 vcp bp7 cap_cmomi w=2.67e-6 l=2.52e-6 m=1
C_LVS_XC10_1 vcp bp8 cap_cmomi w=2.67e-6 l=2.52e-6 m=1
C_LVS_XC10_2 vcp bp8 cap_cmomi w=2.67e-6 l=2.52e-6 m=1
C_LVS_XC10_3 vcp bp8 cap_cmomi w=2.67e-6 l=2.52e-6 m=1
C_LVS_XC10_4 vcp bp8 cap_cmomi w=2.67e-6 l=2.52e-6 m=1
C_LVS_XC10_5 vcp bp8 cap_cmomi w=2.67e-6 l=2.52e-6 m=1
C_LVS_XC10_6 vcp bp8 cap_cmomi w=2.67e-6 l=2.52e-6 m=1
C_LVS_XC10_7 vcp bp8 cap_cmomi w=2.67e-6 l=2.52e-6 m=1
C_LVS_XC10_8 vcp bp8 cap_cmomi w=2.67e-6 l=2.52e-6 m=1
C_LVS_XC10_9 vcp bp8 cap_cmomi w=2.67e-6 l=2.52e-6 m=1
C_LVS_XC10_10 vcp bp8 cap_cmomi w=2.67e-6 l=2.52e-6 m=1
C_LVS_XC10_11 vcp bp8 cap_cmomi w=2.67e-6 l=2.52e-6 m=1
C_LVS_XC10_12 vcp bp8 cap_cmomi w=2.67e-6 l=2.52e-6 m=1
C_LVS_XC10_13 vcp bp8 cap_cmomi w=2.67e-6 l=2.52e-6 m=1
C_LVS_XC10_14 vcp bp8 cap_cmomi w=2.67e-6 l=2.52e-6 m=1
C_LVS_XC10_15 vcp bp8 cap_cmomi w=2.67e-6 l=2.52e-6 m=1
C_LVS_XC10_16 vcp bp8 cap_cmomi w=2.67e-6 l=2.52e-6 m=1
C_LVS_XC10_17 vcp bp8 cap_cmomi w=2.67e-6 l=2.52e-6 m=1
C_LVS_XC10_18 vcp bp8 cap_cmomi w=2.67e-6 l=2.52e-6 m=1
C_LVS_XC10_19 vcp bp8 cap_cmomi w=2.67e-6 l=2.52e-6 m=1
C_LVS_XC10_20 vcp bp8 cap_cmomi w=2.67e-6 l=2.52e-6 m=1
C_LVS_XC10_21 vcp bp8 cap_cmomi w=2.67e-6 l=2.52e-6 m=1
C_LVS_XC10_22 vcp bp8 cap_cmomi w=2.67e-6 l=2.52e-6 m=1
C_LVS_XC10_23 vcp bp8 cap_cmomi w=2.67e-6 l=2.52e-6 m=1
C_LVS_XC10_24 vcp bp8 cap_cmomi w=2.67e-6 l=2.52e-6 m=1
C_LVS_XC10_25 vcp bp8 cap_cmomi w=2.67e-6 l=2.52e-6 m=1
C_LVS_XC10_26 vcp bp8 cap_cmomi w=2.67e-6 l=2.52e-6 m=1
C_LVS_XC10_27 vcp bp8 cap_cmomi w=2.67e-6 l=2.52e-6 m=1
C_LVS_XC10_28 vcp bp8 cap_cmomi w=2.67e-6 l=2.52e-6 m=1
C_LVS_XC10_29 vcp bp8 cap_cmomi w=2.67e-6 l=2.52e-6 m=1
C_LVS_XC10_30 vcp bp8 cap_cmomi w=2.67e-6 l=2.52e-6 m=1
C_LVS_XC10_31 vcp bp8 cap_cmomi w=2.67e-6 l=2.52e-6 m=1
C_LVS_XC10_32 vcp bp8 cap_cmomi w=2.67e-6 l=2.52e-6 m=1
C_LVS_XC10_33 vcp bp8 cap_cmomi w=2.67e-6 l=2.52e-6 m=1
C_LVS_XC10_34 vcp bp8 cap_cmomi w=2.67e-6 l=2.52e-6 m=1
C_LVS_XC10_35 vcp bp8 cap_cmomi w=2.67e-6 l=2.52e-6 m=1
C_LVS_XC10_36 vcp bp8 cap_cmomi w=2.67e-6 l=2.52e-6 m=1
C_LVS_XC10_37 vcp bp8 cap_cmomi w=2.67e-6 l=2.52e-6 m=1
C_LVS_XC10_38 vcp bp8 cap_cmomi w=2.67e-6 l=2.52e-6 m=1
C_LVS_XC10_39 vcp bp8 cap_cmomi w=2.67e-6 l=2.52e-6 m=1
C_LVS_XC10_40 vcp bp8 cap_cmomi w=2.67e-6 l=2.52e-6 m=1
C_LVS_XC10_41 vcp bp8 cap_cmomi w=2.67e-6 l=2.52e-6 m=1
C_LVS_XC10_42 vcp bp8 cap_cmomi w=2.67e-6 l=2.52e-6 m=1
C_LVS_XC10_43 vcp bp8 cap_cmomi w=2.67e-6 l=2.52e-6 m=1
C_LVS_XC10_44 vcp bp8 cap_cmomi w=2.67e-6 l=2.52e-6 m=1
C_LVS_XC10_45 vcp bp8 cap_cmomi w=2.67e-6 l=2.52e-6 m=1
C_LVS_XC10_46 vcp bp8 cap_cmomi w=2.67e-6 l=2.52e-6 m=1
C_LVS_XC10_47 vcp bp8 cap_cmomi w=2.67e-6 l=2.52e-6 m=1
C_LVS_XC10_48 vcp bp8 cap_cmomi w=2.67e-6 l=2.52e-6 m=1
C_LVS_XC10_49 vcp bp8 cap_cmomi w=2.67e-6 l=2.52e-6 m=1
C_LVS_XC10_50 vcp bp8 cap_cmomi w=2.67e-6 l=2.52e-6 m=1
C_LVS_XC10_51 vcp bp8 cap_cmomi w=2.67e-6 l=2.52e-6 m=1
C_LVS_XC10_52 vcp bp8 cap_cmomi w=2.67e-6 l=2.52e-6 m=1
C_LVS_XC10_53 vcp bp8 cap_cmomi w=2.67e-6 l=2.52e-6 m=1
C_LVS_XC10_54 vcp bp8 cap_cmomi w=2.67e-6 l=2.52e-6 m=1
C_LVS_XC10_55 vcp bp8 cap_cmomi w=2.67e-6 l=2.52e-6 m=1
C_LVS_XC10_56 vcp bp8 cap_cmomi w=2.67e-6 l=2.52e-6 m=1
C_LVS_XC10_57 vcp bp8 cap_cmomi w=2.67e-6 l=2.52e-6 m=1
C_LVS_XC10_58 vcp bp8 cap_cmomi w=2.67e-6 l=2.52e-6 m=1
C_LVS_XC10_59 vcp bp8 cap_cmomi w=2.67e-6 l=2.52e-6 m=1
C_LVS_XC10_60 vcp bp8 cap_cmomi w=2.67e-6 l=2.52e-6 m=1
C_LVS_XC10_61 vcp bp8 cap_cmomi w=2.67e-6 l=2.52e-6 m=1
C_LVS_XC10_62 vcp bp8 cap_cmomi w=2.67e-6 l=2.52e-6 m=1
C_LVS_XC10_63 vcp bp8 cap_cmomi w=2.67e-6 l=2.52e-6 m=1
C_LVS_XC10_64 vcp bp8 cap_cmomi w=2.67e-6 l=2.52e-6 m=1
C_LVS_XC10_65 vcp bp8 cap_cmomi w=2.67e-6 l=2.52e-6 m=1
C_LVS_XC10_66 vcp bp8 cap_cmomi w=2.67e-6 l=2.52e-6 m=1
C_LVS_XC10_67 vcp bp8 cap_cmomi w=2.67e-6 l=2.52e-6 m=1
C_LVS_XC10_68 vcp bp8 cap_cmomi w=2.67e-6 l=2.52e-6 m=1
C_LVS_XC10_69 vcp bp8 cap_cmomi w=2.67e-6 l=2.52e-6 m=1
C_LVS_XC10_70 vcp bp8 cap_cmomi w=2.67e-6 l=2.52e-6 m=1
C_LVS_XC10_71 vcp bp8 cap_cmomi w=2.67e-6 l=2.52e-6 m=1
C_LVS_XC10_72 vcp bp8 cap_cmomi w=2.67e-6 l=2.52e-6 m=1
C_LVS_XC10_73 vcp bp8 cap_cmomi w=2.67e-6 l=2.52e-6 m=1
C_LVS_XC10_74 vcp bp8 cap_cmomi w=2.67e-6 l=2.52e-6 m=1
C_LVS_XC10_75 vcp bp8 cap_cmomi w=2.67e-6 l=2.52e-6 m=1
C_LVS_XC10_76 vcp bp8 cap_cmomi w=2.67e-6 l=2.52e-6 m=1
C_LVS_XC10_77 vcp bp8 cap_cmomi w=2.67e-6 l=2.52e-6 m=1
C_LVS_XC10_78 vcp bp8 cap_cmomi w=2.67e-6 l=2.52e-6 m=1
C_LVS_XC10_79 vcp bp8 cap_cmomi w=2.67e-6 l=2.52e-6 m=1
C_LVS_XC10_80 vcp bp8 cap_cmomi w=2.67e-6 l=2.52e-6 m=1
C_LVS_XC10_81 vcp bp8 cap_cmomi w=2.67e-6 l=2.52e-6 m=1
C_LVS_XC10_82 vcp bp8 cap_cmomi w=2.67e-6 l=2.52e-6 m=1
C_LVS_XC10_83 vcp bp8 cap_cmomi w=2.67e-6 l=2.52e-6 m=1
C_LVS_XC10_84 vcp bp8 cap_cmomi w=2.67e-6 l=2.52e-6 m=1
C_LVS_XC10_85 vcp bp8 cap_cmomi w=2.67e-6 l=2.52e-6 m=1
C_LVS_XC10_86 vcp bp8 cap_cmomi w=2.67e-6 l=2.52e-6 m=1
C_LVS_XC10_87 vcp bp8 cap_cmomi w=2.67e-6 l=2.52e-6 m=1
C_LVS_XC10_88 vcp bp8 cap_cmomi w=2.67e-6 l=2.52e-6 m=1
C_LVS_XC10_89 vcp bp8 cap_cmomi w=2.67e-6 l=2.52e-6 m=1
C_LVS_XC10_90 vcp bp8 cap_cmomi w=2.67e-6 l=2.52e-6 m=1
C_LVS_XC10_91 vcp bp8 cap_cmomi w=2.67e-6 l=2.52e-6 m=1
C_LVS_XC10_92 vcp bp8 cap_cmomi w=2.67e-6 l=2.52e-6 m=1
C_LVS_XC10_93 vcp bp8 cap_cmomi w=2.67e-6 l=2.52e-6 m=1
C_LVS_XC10_94 vcp bp8 cap_cmomi w=2.67e-6 l=2.52e-6 m=1
C_LVS_XC10_95 vcp bp8 cap_cmomi w=2.67e-6 l=2.52e-6 m=1
C_LVS_XC10_96 vcp bp8 cap_cmomi w=2.67e-6 l=2.52e-6 m=1
C_LVS_XC10_97 vcp bp8 cap_cmomi w=2.67e-6 l=2.52e-6 m=1
C_LVS_XC10_98 vcp bp8 cap_cmomi w=2.67e-6 l=2.52e-6 m=1
C_LVS_XC10_99 vcp bp8 cap_cmomi w=2.67e-6 l=2.52e-6 m=1
C_LVS_XC10_100 vcp bp8 cap_cmomi w=2.67e-6 l=2.52e-6 m=1
C_LVS_XC10_101 vcp bp8 cap_cmomi w=2.67e-6 l=2.52e-6 m=1
C_LVS_XC10_102 vcp bp8 cap_cmomi w=2.67e-6 l=2.52e-6 m=1
C_LVS_XC10_103 vcp bp8 cap_cmomi w=2.67e-6 l=2.52e-6 m=1
C_LVS_XC10_104 vcp bp8 cap_cmomi w=2.67e-6 l=2.52e-6 m=1
C_LVS_XC10_105 vcp bp8 cap_cmomi w=2.67e-6 l=2.52e-6 m=1
C_LVS_XC10_106 vcp bp8 cap_cmomi w=2.67e-6 l=2.52e-6 m=1
C_LVS_XC10_107 vcp bp8 cap_cmomi w=2.67e-6 l=2.52e-6 m=1
C_LVS_XC10_108 vcp bp8 cap_cmomi w=2.67e-6 l=2.52e-6 m=1
C_LVS_XC10_109 vcp bp8 cap_cmomi w=2.67e-6 l=2.52e-6 m=1
C_LVS_XC10_110 vcp bp8 cap_cmomi w=2.67e-6 l=2.52e-6 m=1
C_LVS_XC10_111 vcp bp8 cap_cmomi w=2.67e-6 l=2.52e-6 m=1
C_LVS_XC10_112 vcp bp8 cap_cmomi w=2.67e-6 l=2.52e-6 m=1
C_LVS_XC10_113 vcp bp8 cap_cmomi w=2.67e-6 l=2.52e-6 m=1
C_LVS_XC10_114 vcp bp8 cap_cmomi w=2.67e-6 l=2.52e-6 m=1
C_LVS_XC10_115 vcp bp8 cap_cmomi w=2.67e-6 l=2.52e-6 m=1
C_LVS_XC10_116 vcp bp8 cap_cmomi w=2.67e-6 l=2.52e-6 m=1
C_LVS_XC10_117 vcp bp8 cap_cmomi w=2.67e-6 l=2.52e-6 m=1
C_LVS_XC10_118 vcp bp8 cap_cmomi w=2.67e-6 l=2.52e-6 m=1
C_LVS_XC10_119 vcp bp8 cap_cmomi w=2.67e-6 l=2.52e-6 m=1
C_LVS_XC10_120 vcp bp8 cap_cmomi w=2.67e-6 l=2.52e-6 m=1
C_LVS_XC10_121 vcp bp8 cap_cmomi w=2.67e-6 l=2.52e-6 m=1
C_LVS_XC10_122 vcp bp8 cap_cmomi w=2.67e-6 l=2.52e-6 m=1
C_LVS_XC10_123 vcp bp8 cap_cmomi w=2.67e-6 l=2.52e-6 m=1
C_LVS_XC10_124 vcp bp8 cap_cmomi w=2.67e-6 l=2.52e-6 m=1
C_LVS_XC10_125 vcp bp8 cap_cmomi w=2.67e-6 l=2.52e-6 m=1
C_LVS_XC10_126 vcp bp8 cap_cmomi w=2.67e-6 l=2.52e-6 m=1
C_LVS_XC10_127 vcp bp8 cap_cmomi w=2.67e-6 l=2.52e-6 m=1
C_LVS_XC10_128 vcp bp8 cap_cmomi w=2.67e-6 l=2.52e-6 m=1
C_LVS_XC10_129 vcp bp8 cap_cmomi w=2.67e-6 l=2.52e-6 m=1
C_LVS_XC10_130 vcp bp8 cap_cmomi w=2.67e-6 l=2.52e-6 m=1
C_LVS_XC10_131 vcp bp8 cap_cmomi w=2.67e-6 l=2.52e-6 m=1
C_LVS_XC10_132 vcp bp8 cap_cmomi w=2.67e-6 l=2.52e-6 m=1
C_LVS_XC10_133 vcp bp8 cap_cmomi w=2.67e-6 l=2.52e-6 m=1
C_LVS_XC10_134 vcp bp8 cap_cmomi w=2.67e-6 l=2.52e-6 m=1
C_LVS_XC10_135 vcp bp8 cap_cmomi w=2.67e-6 l=2.52e-6 m=1
C_LVS_XC10_136 vcp bp8 cap_cmomi w=2.67e-6 l=2.52e-6 m=1
C_LVS_XC10_137 vcp bp8 cap_cmomi w=2.67e-6 l=2.52e-6 m=1
C_LVS_XC10_138 vcp bp8 cap_cmomi w=2.67e-6 l=2.52e-6 m=1
C_LVS_XC10_139 vcp bp8 cap_cmomi w=2.67e-6 l=2.52e-6 m=1
C_LVS_XC10_140 vcp bp8 cap_cmomi w=2.67e-6 l=2.52e-6 m=1
C_LVS_XC10_141 vcp bp8 cap_cmomi w=2.67e-6 l=2.52e-6 m=1
C_LVS_XC10_142 vcp bp8 cap_cmomi w=2.67e-6 l=2.52e-6 m=1
C_LVS_XC10_143 vcp bp8 cap_cmomi w=2.67e-6 l=2.52e-6 m=1
C_LVS_XC10_144 vcp bp8 cap_cmomi w=2.67e-6 l=2.52e-6 m=1
C_LVS_XC10_145 vcp bp8 cap_cmomi w=2.67e-6 l=2.52e-6 m=1
C_LVS_XC10_146 vcp bp8 cap_cmomi w=2.67e-6 l=2.52e-6 m=1
C_LVS_XC10_147 vcp bp8 cap_cmomi w=2.67e-6 l=2.52e-6 m=1
C_LVS_XC10_148 vcp bp8 cap_cmomi w=2.67e-6 l=2.52e-6 m=1
C_LVS_XC10_149 vcp bp8 cap_cmomi w=2.67e-6 l=2.52e-6 m=1
C_LVS_XC10_150 vcp bp8 cap_cmomi w=2.67e-6 l=2.52e-6 m=1
C_LVS_XC10_151 vcp bp8 cap_cmomi w=2.67e-6 l=2.52e-6 m=1
C_LVS_XC10_152 vcp bp8 cap_cmomi w=2.67e-6 l=2.52e-6 m=1
C_LVS_XC10_153 vcp bp8 cap_cmomi w=2.67e-6 l=2.52e-6 m=1
C_LVS_XC10_154 vcp bp8 cap_cmomi w=2.67e-6 l=2.52e-6 m=1
C_LVS_XC10_155 vcp bp8 cap_cmomi w=2.67e-6 l=2.52e-6 m=1
C_LVS_XC10_156 vcp bp8 cap_cmomi w=2.67e-6 l=2.52e-6 m=1
C_LVS_XC10_157 vcp bp8 cap_cmomi w=2.67e-6 l=2.52e-6 m=1
C_LVS_XC10_158 vcp bp8 cap_cmomi w=2.67e-6 l=2.52e-6 m=1
C_LVS_XC10_159 vcp bp8 cap_cmomi w=2.67e-6 l=2.52e-6 m=1
C_LVS_XC10_160 vcp bp8 cap_cmomi w=2.67e-6 l=2.52e-6 m=1
C_LVS_XC10_161 vcp bp8 cap_cmomi w=2.67e-6 l=2.52e-6 m=1
C_LVS_XC10_162 vcp bp8 cap_cmomi w=2.67e-6 l=2.52e-6 m=1
C_LVS_XC10_163 vcp bp8 cap_cmomi w=2.67e-6 l=2.52e-6 m=1
C_LVS_XC10_164 vcp bp8 cap_cmomi w=2.67e-6 l=2.52e-6 m=1
C_LVS_XC10_165 vcp bp8 cap_cmomi w=2.67e-6 l=2.52e-6 m=1
C_LVS_XC10_166 vcp bp8 cap_cmomi w=2.67e-6 l=2.52e-6 m=1
C_LVS_XC10_167 vcp bp8 cap_cmomi w=2.67e-6 l=2.52e-6 m=1
C_LVS_XC10_168 vcp bp8 cap_cmomi w=2.67e-6 l=2.52e-6 m=1
C_LVS_XC10_169 vcp bp8 cap_cmomi w=2.67e-6 l=2.52e-6 m=1
C_LVS_XC10_170 vcp bp8 cap_cmomi w=2.67e-6 l=2.52e-6 m=1
C_LVS_XC10_171 vcp bp8 cap_cmomi w=2.67e-6 l=2.52e-6 m=1
C_LVS_XC10_172 vcp bp8 cap_cmomi w=2.67e-6 l=2.52e-6 m=1
C_LVS_XC10_173 vcp bp8 cap_cmomi w=2.67e-6 l=2.52e-6 m=1
C_LVS_XC10_174 vcp bp8 cap_cmomi w=2.67e-6 l=2.52e-6 m=1
C_LVS_XC10_175 vcp bp8 cap_cmomi w=2.67e-6 l=2.52e-6 m=1
C_LVS_XC10_176 vcp bp8 cap_cmomi w=2.67e-6 l=2.52e-6 m=1
C_LVS_XC10_177 vcp bp8 cap_cmomi w=2.67e-6 l=2.52e-6 m=1
C_LVS_XC10_178 vcp bp8 cap_cmomi w=2.67e-6 l=2.52e-6 m=1
C_LVS_XC10_179 vcp bp8 cap_cmomi w=2.67e-6 l=2.52e-6 m=1
C_LVS_XC10_180 vcp bp8 cap_cmomi w=2.67e-6 l=2.52e-6 m=1
C_LVS_XC10_181 vcp bp8 cap_cmomi w=2.67e-6 l=2.52e-6 m=1
C_LVS_XC10_182 vcp bp8 cap_cmomi w=2.67e-6 l=2.52e-6 m=1
C_LVS_XC10_183 vcp bp8 cap_cmomi w=2.67e-6 l=2.52e-6 m=1
C_LVS_XC10_184 vcp bp8 cap_cmomi w=2.67e-6 l=2.52e-6 m=1
C_LVS_XC10_185 vcp bp8 cap_cmomi w=2.67e-6 l=2.52e-6 m=1
C_LVS_XC10_186 vcp bp8 cap_cmomi w=2.67e-6 l=2.52e-6 m=1
C_LVS_XC10_187 vcp bp8 cap_cmomi w=2.67e-6 l=2.52e-6 m=1
C_LVS_XC10_188 vcp bp8 cap_cmomi w=2.67e-6 l=2.52e-6 m=1
C_LVS_XC10_189 vcp bp8 cap_cmomi w=2.67e-6 l=2.52e-6 m=1
C_LVS_XC10_190 vcp bp8 cap_cmomi w=2.67e-6 l=2.52e-6 m=1
C_LVS_XC10_191 vcp bp8 cap_cmomi w=2.67e-6 l=2.52e-6 m=1
C_LVS_XC10_192 vcp bp8 cap_cmomi w=2.67e-6 l=2.52e-6 m=1
C_LVS_XC10_193 vcp bp8 cap_cmomi w=2.67e-6 l=2.52e-6 m=1
C_LVS_XC10_194 vcp bp8 cap_cmomi w=2.67e-6 l=2.52e-6 m=1
C_LVS_XC10_195 vcp bp8 cap_cmomi w=2.67e-6 l=2.52e-6 m=1
C_LVS_XC10_196 vcp bp8 cap_cmomi w=2.67e-6 l=2.52e-6 m=1
C_LVS_XC10_197 vcp bp8 cap_cmomi w=2.67e-6 l=2.52e-6 m=1
C_LVS_XC10_198 vcp bp8 cap_cmomi w=2.67e-6 l=2.52e-6 m=1
C_LVS_XC10_199 vcp bp8 cap_cmomi w=2.67e-6 l=2.52e-6 m=1
C_LVS_XC10_200 vcp bp8 cap_cmomi w=2.67e-6 l=2.52e-6 m=1
C_LVS_XC10_201 vcp bp8 cap_cmomi w=2.67e-6 l=2.52e-6 m=1
C_LVS_XC10_202 vcp bp8 cap_cmomi w=2.67e-6 l=2.52e-6 m=1
C_LVS_XC10_203 vcp bp8 cap_cmomi w=2.67e-6 l=2.52e-6 m=1
C_LVS_XC10_204 vcp bp8 cap_cmomi w=2.67e-6 l=2.52e-6 m=1
C_LVS_XC10_205 vcp bp8 cap_cmomi w=2.67e-6 l=2.52e-6 m=1
C_LVS_XC10_206 vcp bp8 cap_cmomi w=2.67e-6 l=2.52e-6 m=1
C_LVS_XC10_207 vcp bp8 cap_cmomi w=2.67e-6 l=2.52e-6 m=1
C_LVS_XC10_208 vcp bp8 cap_cmomi w=2.67e-6 l=2.52e-6 m=1
C_LVS_XC10_209 vcp bp8 cap_cmomi w=2.67e-6 l=2.52e-6 m=1
C_LVS_XC10_210 vcp bp8 cap_cmomi w=2.67e-6 l=2.52e-6 m=1
C_LVS_XC10_211 vcp bp8 cap_cmomi w=2.67e-6 l=2.52e-6 m=1
C_LVS_XC10_212 vcp bp8 cap_cmomi w=2.67e-6 l=2.52e-6 m=1
C_LVS_XC10_213 vcp bp8 cap_cmomi w=2.67e-6 l=2.52e-6 m=1
C_LVS_XC10_214 vcp bp8 cap_cmomi w=2.67e-6 l=2.52e-6 m=1
C_LVS_XC10_215 vcp bp8 cap_cmomi w=2.67e-6 l=2.52e-6 m=1
C_LVS_XC10_216 vcp bp8 cap_cmomi w=2.67e-6 l=2.52e-6 m=1
C_LVS_XC10_217 vcp bp8 cap_cmomi w=2.67e-6 l=2.52e-6 m=1
C_LVS_XC10_218 vcp bp8 cap_cmomi w=2.67e-6 l=2.52e-6 m=1
C_LVS_XC10_219 vcp bp8 cap_cmomi w=2.67e-6 l=2.52e-6 m=1
C_LVS_XC10_220 vcp bp8 cap_cmomi w=2.67e-6 l=2.52e-6 m=1
C_LVS_XC10_221 vcp bp8 cap_cmomi w=2.67e-6 l=2.52e-6 m=1
C_LVS_XC10_222 vcp bp8 cap_cmomi w=2.67e-6 l=2.52e-6 m=1
C_LVS_XC10_223 vcp bp8 cap_cmomi w=2.67e-6 l=2.52e-6 m=1
C_LVS_XC10_224 vcp bp8 cap_cmomi w=2.67e-6 l=2.52e-6 m=1
C_LVS_XC10_225 vcp bp8 cap_cmomi w=2.67e-6 l=2.52e-6 m=1
C_LVS_XC10_226 vcp bp8 cap_cmomi w=2.67e-6 l=2.52e-6 m=1
C_LVS_XC10_227 vcp bp8 cap_cmomi w=2.67e-6 l=2.52e-6 m=1
C_LVS_XC10_228 vcp bp8 cap_cmomi w=2.67e-6 l=2.52e-6 m=1
C_LVS_XC10_229 vcp bp8 cap_cmomi w=2.67e-6 l=2.52e-6 m=1
C_LVS_XC10_230 vcp bp8 cap_cmomi w=2.67e-6 l=2.52e-6 m=1
C_LVS_XC10_231 vcp bp8 cap_cmomi w=2.67e-6 l=2.52e-6 m=1
C_LVS_XC10_232 vcp bp8 cap_cmomi w=2.67e-6 l=2.52e-6 m=1
C_LVS_XC10_233 vcp bp8 cap_cmomi w=2.67e-6 l=2.52e-6 m=1
C_LVS_XC10_234 vcp bp8 cap_cmomi w=2.67e-6 l=2.52e-6 m=1
C_LVS_XC10_235 vcp bp8 cap_cmomi w=2.67e-6 l=2.52e-6 m=1
C_LVS_XC10_236 vcp bp8 cap_cmomi w=2.67e-6 l=2.52e-6 m=1
C_LVS_XC10_237 vcp bp8 cap_cmomi w=2.67e-6 l=2.52e-6 m=1
C_LVS_XC10_238 vcp bp8 cap_cmomi w=2.67e-6 l=2.52e-6 m=1
C_LVS_XC10_239 vcp bp8 cap_cmomi w=2.67e-6 l=2.52e-6 m=1
C_LVS_XC10_240 vcp bp8 cap_cmomi w=2.67e-6 l=2.52e-6 m=1
C_LVS_XC10_241 vcp bp8 cap_cmomi w=2.67e-6 l=2.52e-6 m=1
C_LVS_XC10_242 vcp bp8 cap_cmomi w=2.67e-6 l=2.52e-6 m=1
C_LVS_XC10_243 vcp bp8 cap_cmomi w=2.67e-6 l=2.52e-6 m=1
C_LVS_XC10_244 vcp bp8 cap_cmomi w=2.67e-6 l=2.52e-6 m=1
C_LVS_XC10_245 vcp bp8 cap_cmomi w=2.67e-6 l=2.52e-6 m=1
C_LVS_XC10_246 vcp bp8 cap_cmomi w=2.67e-6 l=2.52e-6 m=1
C_LVS_XC10_247 vcp bp8 cap_cmomi w=2.67e-6 l=2.52e-6 m=1
C_LVS_XC10_248 vcp bp8 cap_cmomi w=2.67e-6 l=2.52e-6 m=1
C_LVS_XC10_249 vcp bp8 cap_cmomi w=2.67e-6 l=2.52e-6 m=1
C_LVS_XC10_250 vcp bp8 cap_cmomi w=2.67e-6 l=2.52e-6 m=1
C_LVS_XC10_251 vcp bp8 cap_cmomi w=2.67e-6 l=2.52e-6 m=1
C_LVS_XC10_252 vcp bp8 cap_cmomi w=2.67e-6 l=2.52e-6 m=1
C_LVS_XC10_253 vcp bp8 cap_cmomi w=2.67e-6 l=2.52e-6 m=1
C_LVS_XC10_254 vcp bp8 cap_cmomi w=2.67e-6 l=2.52e-6 m=1
C_LVS_XC10_255 vcp bp8 cap_cmomi w=2.67e-6 l=2.52e-6 m=1
C_LVS_XC10_256 vcp bp8 cap_cmomi w=2.67e-6 l=2.52e-6 m=1
C_LVS_XC12_1 vcp bp9 cap_cmomi w=2.67e-6 l=2.52e-6 m=1
C_LVS_XC12_2 vcp bp9 cap_cmomi w=2.67e-6 l=2.52e-6 m=1
C_LVS_XC12_3 vcp bp9 cap_cmomi w=2.67e-6 l=2.52e-6 m=1
C_LVS_XC12_4 vcp bp9 cap_cmomi w=2.67e-6 l=2.52e-6 m=1
C_LVS_XC12_5 vcp bp9 cap_cmomi w=2.67e-6 l=2.52e-6 m=1
C_LVS_XC12_6 vcp bp9 cap_cmomi w=2.67e-6 l=2.52e-6 m=1
C_LVS_XC12_7 vcp bp9 cap_cmomi w=2.67e-6 l=2.52e-6 m=1
C_LVS_XC12_8 vcp bp9 cap_cmomi w=2.67e-6 l=2.52e-6 m=1
C_LVS_XC12_9 vcp bp9 cap_cmomi w=2.67e-6 l=2.52e-6 m=1
C_LVS_XC12_10 vcp bp9 cap_cmomi w=2.67e-6 l=2.52e-6 m=1
C_LVS_XC12_11 vcp bp9 cap_cmomi w=2.67e-6 l=2.52e-6 m=1
C_LVS_XC12_12 vcp bp9 cap_cmomi w=2.67e-6 l=2.52e-6 m=1
C_LVS_XC12_13 vcp bp9 cap_cmomi w=2.67e-6 l=2.52e-6 m=1
C_LVS_XC12_14 vcp bp9 cap_cmomi w=2.67e-6 l=2.52e-6 m=1
C_LVS_XC12_15 vcp bp9 cap_cmomi w=2.67e-6 l=2.52e-6 m=1
C_LVS_XC12_16 vcp bp9 cap_cmomi w=2.67e-6 l=2.52e-6 m=1
C_LVS_XC12_17 vcp bp9 cap_cmomi w=2.67e-6 l=2.52e-6 m=1
C_LVS_XC12_18 vcp bp9 cap_cmomi w=2.67e-6 l=2.52e-6 m=1
C_LVS_XC12_19 vcp bp9 cap_cmomi w=2.67e-6 l=2.52e-6 m=1
C_LVS_XC12_20 vcp bp9 cap_cmomi w=2.67e-6 l=2.52e-6 m=1
C_LVS_XC12_21 vcp bp9 cap_cmomi w=2.67e-6 l=2.52e-6 m=1
C_LVS_XC12_22 vcp bp9 cap_cmomi w=2.67e-6 l=2.52e-6 m=1
C_LVS_XC12_23 vcp bp9 cap_cmomi w=2.67e-6 l=2.52e-6 m=1
C_LVS_XC12_24 vcp bp9 cap_cmomi w=2.67e-6 l=2.52e-6 m=1
C_LVS_XC12_25 vcp bp9 cap_cmomi w=2.67e-6 l=2.52e-6 m=1
C_LVS_XC12_26 vcp bp9 cap_cmomi w=2.67e-6 l=2.52e-6 m=1
C_LVS_XC12_27 vcp bp9 cap_cmomi w=2.67e-6 l=2.52e-6 m=1
C_LVS_XC12_28 vcp bp9 cap_cmomi w=2.67e-6 l=2.52e-6 m=1
C_LVS_XC12_29 vcp bp9 cap_cmomi w=2.67e-6 l=2.52e-6 m=1
C_LVS_XC12_30 vcp bp9 cap_cmomi w=2.67e-6 l=2.52e-6 m=1
C_LVS_XC12_31 vcp bp9 cap_cmomi w=2.67e-6 l=2.52e-6 m=1
C_LVS_XC12_32 vcp bp9 cap_cmomi w=2.67e-6 l=2.52e-6 m=1
C_LVS_XC12_33 vcp bp9 cap_cmomi w=2.67e-6 l=2.52e-6 m=1
C_LVS_XC12_34 vcp bp9 cap_cmomi w=2.67e-6 l=2.52e-6 m=1
C_LVS_XC12_35 vcp bp9 cap_cmomi w=2.67e-6 l=2.52e-6 m=1
C_LVS_XC12_36 vcp bp9 cap_cmomi w=2.67e-6 l=2.52e-6 m=1
C_LVS_XC12_37 vcp bp9 cap_cmomi w=2.67e-6 l=2.52e-6 m=1
C_LVS_XC12_38 vcp bp9 cap_cmomi w=2.67e-6 l=2.52e-6 m=1
C_LVS_XC12_39 vcp bp9 cap_cmomi w=2.67e-6 l=2.52e-6 m=1
C_LVS_XC12_40 vcp bp9 cap_cmomi w=2.67e-6 l=2.52e-6 m=1
C_LVS_XC12_41 vcp bp9 cap_cmomi w=2.67e-6 l=2.52e-6 m=1
C_LVS_XC12_42 vcp bp9 cap_cmomi w=2.67e-6 l=2.52e-6 m=1
C_LVS_XC12_43 vcp bp9 cap_cmomi w=2.67e-6 l=2.52e-6 m=1
C_LVS_XC12_44 vcp bp9 cap_cmomi w=2.67e-6 l=2.52e-6 m=1
C_LVS_XC12_45 vcp bp9 cap_cmomi w=2.67e-6 l=2.52e-6 m=1
C_LVS_XC12_46 vcp bp9 cap_cmomi w=2.67e-6 l=2.52e-6 m=1
C_LVS_XC12_47 vcp bp9 cap_cmomi w=2.67e-6 l=2.52e-6 m=1
C_LVS_XC12_48 vcp bp9 cap_cmomi w=2.67e-6 l=2.52e-6 m=1
C_LVS_XC12_49 vcp bp9 cap_cmomi w=2.67e-6 l=2.52e-6 m=1
C_LVS_XC12_50 vcp bp9 cap_cmomi w=2.67e-6 l=2.52e-6 m=1
C_LVS_XC12_51 vcp bp9 cap_cmomi w=2.67e-6 l=2.52e-6 m=1
C_LVS_XC12_52 vcp bp9 cap_cmomi w=2.67e-6 l=2.52e-6 m=1
C_LVS_XC12_53 vcp bp9 cap_cmomi w=2.67e-6 l=2.52e-6 m=1
C_LVS_XC12_54 vcp bp9 cap_cmomi w=2.67e-6 l=2.52e-6 m=1
C_LVS_XC12_55 vcp bp9 cap_cmomi w=2.67e-6 l=2.52e-6 m=1
C_LVS_XC12_56 vcp bp9 cap_cmomi w=2.67e-6 l=2.52e-6 m=1
C_LVS_XC12_57 vcp bp9 cap_cmomi w=2.67e-6 l=2.52e-6 m=1
C_LVS_XC12_58 vcp bp9 cap_cmomi w=2.67e-6 l=2.52e-6 m=1
C_LVS_XC12_59 vcp bp9 cap_cmomi w=2.67e-6 l=2.52e-6 m=1
C_LVS_XC12_60 vcp bp9 cap_cmomi w=2.67e-6 l=2.52e-6 m=1
C_LVS_XC12_61 vcp bp9 cap_cmomi w=2.67e-6 l=2.52e-6 m=1
C_LVS_XC12_62 vcp bp9 cap_cmomi w=2.67e-6 l=2.52e-6 m=1
C_LVS_XC12_63 vcp bp9 cap_cmomi w=2.67e-6 l=2.52e-6 m=1
C_LVS_XC12_64 vcp bp9 cap_cmomi w=2.67e-6 l=2.52e-6 m=1
C_LVS_XC12_65 vcp bp9 cap_cmomi w=2.67e-6 l=2.52e-6 m=1
C_LVS_XC12_66 vcp bp9 cap_cmomi w=2.67e-6 l=2.52e-6 m=1
C_LVS_XC12_67 vcp bp9 cap_cmomi w=2.67e-6 l=2.52e-6 m=1
C_LVS_XC12_68 vcp bp9 cap_cmomi w=2.67e-6 l=2.52e-6 m=1
C_LVS_XC12_69 vcp bp9 cap_cmomi w=2.67e-6 l=2.52e-6 m=1
C_LVS_XC12_70 vcp bp9 cap_cmomi w=2.67e-6 l=2.52e-6 m=1
C_LVS_XC12_71 vcp bp9 cap_cmomi w=2.67e-6 l=2.52e-6 m=1
C_LVS_XC12_72 vcp bp9 cap_cmomi w=2.67e-6 l=2.52e-6 m=1
C_LVS_XC12_73 vcp bp9 cap_cmomi w=2.67e-6 l=2.52e-6 m=1
C_LVS_XC12_74 vcp bp9 cap_cmomi w=2.67e-6 l=2.52e-6 m=1
C_LVS_XC12_75 vcp bp9 cap_cmomi w=2.67e-6 l=2.52e-6 m=1
C_LVS_XC12_76 vcp bp9 cap_cmomi w=2.67e-6 l=2.52e-6 m=1
C_LVS_XC12_77 vcp bp9 cap_cmomi w=2.67e-6 l=2.52e-6 m=1
C_LVS_XC12_78 vcp bp9 cap_cmomi w=2.67e-6 l=2.52e-6 m=1
C_LVS_XC12_79 vcp bp9 cap_cmomi w=2.67e-6 l=2.52e-6 m=1
C_LVS_XC12_80 vcp bp9 cap_cmomi w=2.67e-6 l=2.52e-6 m=1
C_LVS_XC12_81 vcp bp9 cap_cmomi w=2.67e-6 l=2.52e-6 m=1
C_LVS_XC12_82 vcp bp9 cap_cmomi w=2.67e-6 l=2.52e-6 m=1
C_LVS_XC12_83 vcp bp9 cap_cmomi w=2.67e-6 l=2.52e-6 m=1
C_LVS_XC12_84 vcp bp9 cap_cmomi w=2.67e-6 l=2.52e-6 m=1
C_LVS_XC12_85 vcp bp9 cap_cmomi w=2.67e-6 l=2.52e-6 m=1
C_LVS_XC12_86 vcp bp9 cap_cmomi w=2.67e-6 l=2.52e-6 m=1
C_LVS_XC12_87 vcp bp9 cap_cmomi w=2.67e-6 l=2.52e-6 m=1
C_LVS_XC12_88 vcp bp9 cap_cmomi w=2.67e-6 l=2.52e-6 m=1
C_LVS_XC12_89 vcp bp9 cap_cmomi w=2.67e-6 l=2.52e-6 m=1
C_LVS_XC12_90 vcp bp9 cap_cmomi w=2.67e-6 l=2.52e-6 m=1
C_LVS_XC12_91 vcp bp9 cap_cmomi w=2.67e-6 l=2.52e-6 m=1
C_LVS_XC12_92 vcp bp9 cap_cmomi w=2.67e-6 l=2.52e-6 m=1
C_LVS_XC12_93 vcp bp9 cap_cmomi w=2.67e-6 l=2.52e-6 m=1
C_LVS_XC12_94 vcp bp9 cap_cmomi w=2.67e-6 l=2.52e-6 m=1
C_LVS_XC12_95 vcp bp9 cap_cmomi w=2.67e-6 l=2.52e-6 m=1
C_LVS_XC12_96 vcp bp9 cap_cmomi w=2.67e-6 l=2.52e-6 m=1
C_LVS_XC12_97 vcp bp9 cap_cmomi w=2.67e-6 l=2.52e-6 m=1
C_LVS_XC12_98 vcp bp9 cap_cmomi w=2.67e-6 l=2.52e-6 m=1
C_LVS_XC12_99 vcp bp9 cap_cmomi w=2.67e-6 l=2.52e-6 m=1
C_LVS_XC12_100 vcp bp9 cap_cmomi w=2.67e-6 l=2.52e-6 m=1
C_LVS_XC12_101 vcp bp9 cap_cmomi w=2.67e-6 l=2.52e-6 m=1
C_LVS_XC12_102 vcp bp9 cap_cmomi w=2.67e-6 l=2.52e-6 m=1
C_LVS_XC12_103 vcp bp9 cap_cmomi w=2.67e-6 l=2.52e-6 m=1
C_LVS_XC12_104 vcp bp9 cap_cmomi w=2.67e-6 l=2.52e-6 m=1
C_LVS_XC12_105 vcp bp9 cap_cmomi w=2.67e-6 l=2.52e-6 m=1
C_LVS_XC12_106 vcp bp9 cap_cmomi w=2.67e-6 l=2.52e-6 m=1
C_LVS_XC12_107 vcp bp9 cap_cmomi w=2.67e-6 l=2.52e-6 m=1
C_LVS_XC12_108 vcp bp9 cap_cmomi w=2.67e-6 l=2.52e-6 m=1
C_LVS_XC12_109 vcp bp9 cap_cmomi w=2.67e-6 l=2.52e-6 m=1
C_LVS_XC12_110 vcp bp9 cap_cmomi w=2.67e-6 l=2.52e-6 m=1
C_LVS_XC12_111 vcp bp9 cap_cmomi w=2.67e-6 l=2.52e-6 m=1
C_LVS_XC12_112 vcp bp9 cap_cmomi w=2.67e-6 l=2.52e-6 m=1
C_LVS_XC12_113 vcp bp9 cap_cmomi w=2.67e-6 l=2.52e-6 m=1
C_LVS_XC12_114 vcp bp9 cap_cmomi w=2.67e-6 l=2.52e-6 m=1
C_LVS_XC12_115 vcp bp9 cap_cmomi w=2.67e-6 l=2.52e-6 m=1
C_LVS_XC12_116 vcp bp9 cap_cmomi w=2.67e-6 l=2.52e-6 m=1
C_LVS_XC12_117 vcp bp9 cap_cmomi w=2.67e-6 l=2.52e-6 m=1
C_LVS_XC12_118 vcp bp9 cap_cmomi w=2.67e-6 l=2.52e-6 m=1
C_LVS_XC12_119 vcp bp9 cap_cmomi w=2.67e-6 l=2.52e-6 m=1
C_LVS_XC12_120 vcp bp9 cap_cmomi w=2.67e-6 l=2.52e-6 m=1
C_LVS_XC12_121 vcp bp9 cap_cmomi w=2.67e-6 l=2.52e-6 m=1
C_LVS_XC12_122 vcp bp9 cap_cmomi w=2.67e-6 l=2.52e-6 m=1
C_LVS_XC12_123 vcp bp9 cap_cmomi w=2.67e-6 l=2.52e-6 m=1
C_LVS_XC12_124 vcp bp9 cap_cmomi w=2.67e-6 l=2.52e-6 m=1
C_LVS_XC12_125 vcp bp9 cap_cmomi w=2.67e-6 l=2.52e-6 m=1
C_LVS_XC12_126 vcp bp9 cap_cmomi w=2.67e-6 l=2.52e-6 m=1
C_LVS_XC12_127 vcp bp9 cap_cmomi w=2.67e-6 l=2.52e-6 m=1
C_LVS_XC12_128 vcp bp9 cap_cmomi w=2.67e-6 l=2.52e-6 m=1
C_LVS_XC12_129 vcp bp9 cap_cmomi w=2.67e-6 l=2.52e-6 m=1
C_LVS_XC12_130 vcp bp9 cap_cmomi w=2.67e-6 l=2.52e-6 m=1
C_LVS_XC12_131 vcp bp9 cap_cmomi w=2.67e-6 l=2.52e-6 m=1
C_LVS_XC12_132 vcp bp9 cap_cmomi w=2.67e-6 l=2.52e-6 m=1
C_LVS_XC12_133 vcp bp9 cap_cmomi w=2.67e-6 l=2.52e-6 m=1
C_LVS_XC12_134 vcp bp9 cap_cmomi w=2.67e-6 l=2.52e-6 m=1
C_LVS_XC12_135 vcp bp9 cap_cmomi w=2.67e-6 l=2.52e-6 m=1
C_LVS_XC12_136 vcp bp9 cap_cmomi w=2.67e-6 l=2.52e-6 m=1
C_LVS_XC12_137 vcp bp9 cap_cmomi w=2.67e-6 l=2.52e-6 m=1
C_LVS_XC12_138 vcp bp9 cap_cmomi w=2.67e-6 l=2.52e-6 m=1
C_LVS_XC12_139 vcp bp9 cap_cmomi w=2.67e-6 l=2.52e-6 m=1
C_LVS_XC12_140 vcp bp9 cap_cmomi w=2.67e-6 l=2.52e-6 m=1
C_LVS_XC12_141 vcp bp9 cap_cmomi w=2.67e-6 l=2.52e-6 m=1
C_LVS_XC12_142 vcp bp9 cap_cmomi w=2.67e-6 l=2.52e-6 m=1
C_LVS_XC12_143 vcp bp9 cap_cmomi w=2.67e-6 l=2.52e-6 m=1
C_LVS_XC12_144 vcp bp9 cap_cmomi w=2.67e-6 l=2.52e-6 m=1
C_LVS_XC12_145 vcp bp9 cap_cmomi w=2.67e-6 l=2.52e-6 m=1
C_LVS_XC12_146 vcp bp9 cap_cmomi w=2.67e-6 l=2.52e-6 m=1
C_LVS_XC12_147 vcp bp9 cap_cmomi w=2.67e-6 l=2.52e-6 m=1
C_LVS_XC12_148 vcp bp9 cap_cmomi w=2.67e-6 l=2.52e-6 m=1
C_LVS_XC12_149 vcp bp9 cap_cmomi w=2.67e-6 l=2.52e-6 m=1
C_LVS_XC12_150 vcp bp9 cap_cmomi w=2.67e-6 l=2.52e-6 m=1
C_LVS_XC12_151 vcp bp9 cap_cmomi w=2.67e-6 l=2.52e-6 m=1
C_LVS_XC12_152 vcp bp9 cap_cmomi w=2.67e-6 l=2.52e-6 m=1
C_LVS_XC12_153 vcp bp9 cap_cmomi w=2.67e-6 l=2.52e-6 m=1
C_LVS_XC12_154 vcp bp9 cap_cmomi w=2.67e-6 l=2.52e-6 m=1
C_LVS_XC12_155 vcp bp9 cap_cmomi w=2.67e-6 l=2.52e-6 m=1
C_LVS_XC12_156 vcp bp9 cap_cmomi w=2.67e-6 l=2.52e-6 m=1
C_LVS_XC12_157 vcp bp9 cap_cmomi w=2.67e-6 l=2.52e-6 m=1
C_LVS_XC12_158 vcp bp9 cap_cmomi w=2.67e-6 l=2.52e-6 m=1
C_LVS_XC12_159 vcp bp9 cap_cmomi w=2.67e-6 l=2.52e-6 m=1
C_LVS_XC12_160 vcp bp9 cap_cmomi w=2.67e-6 l=2.52e-6 m=1
C_LVS_XC12_161 vcp bp9 cap_cmomi w=2.67e-6 l=2.52e-6 m=1
C_LVS_XC12_162 vcp bp9 cap_cmomi w=2.67e-6 l=2.52e-6 m=1
C_LVS_XC12_163 vcp bp9 cap_cmomi w=2.67e-6 l=2.52e-6 m=1
C_LVS_XC12_164 vcp bp9 cap_cmomi w=2.67e-6 l=2.52e-6 m=1
C_LVS_XC12_165 vcp bp9 cap_cmomi w=2.67e-6 l=2.52e-6 m=1
C_LVS_XC12_166 vcp bp9 cap_cmomi w=2.67e-6 l=2.52e-6 m=1
C_LVS_XC12_167 vcp bp9 cap_cmomi w=2.67e-6 l=2.52e-6 m=1
C_LVS_XC12_168 vcp bp9 cap_cmomi w=2.67e-6 l=2.52e-6 m=1
C_LVS_XC12_169 vcp bp9 cap_cmomi w=2.67e-6 l=2.52e-6 m=1
C_LVS_XC12_170 vcp bp9 cap_cmomi w=2.67e-6 l=2.52e-6 m=1
C_LVS_XC12_171 vcp bp9 cap_cmomi w=2.67e-6 l=2.52e-6 m=1
C_LVS_XC12_172 vcp bp9 cap_cmomi w=2.67e-6 l=2.52e-6 m=1
C_LVS_XC12_173 vcp bp9 cap_cmomi w=2.67e-6 l=2.52e-6 m=1
C_LVS_XC12_174 vcp bp9 cap_cmomi w=2.67e-6 l=2.52e-6 m=1
C_LVS_XC12_175 vcp bp9 cap_cmomi w=2.67e-6 l=2.52e-6 m=1
C_LVS_XC12_176 vcp bp9 cap_cmomi w=2.67e-6 l=2.52e-6 m=1
C_LVS_XC12_177 vcp bp9 cap_cmomi w=2.67e-6 l=2.52e-6 m=1
C_LVS_XC12_178 vcp bp9 cap_cmomi w=2.67e-6 l=2.52e-6 m=1
C_LVS_XC12_179 vcp bp9 cap_cmomi w=2.67e-6 l=2.52e-6 m=1
C_LVS_XC12_180 vcp bp9 cap_cmomi w=2.67e-6 l=2.52e-6 m=1
C_LVS_XC12_181 vcp bp9 cap_cmomi w=2.67e-6 l=2.52e-6 m=1
C_LVS_XC12_182 vcp bp9 cap_cmomi w=2.67e-6 l=2.52e-6 m=1
C_LVS_XC12_183 vcp bp9 cap_cmomi w=2.67e-6 l=2.52e-6 m=1
C_LVS_XC12_184 vcp bp9 cap_cmomi w=2.67e-6 l=2.52e-6 m=1
C_LVS_XC12_185 vcp bp9 cap_cmomi w=2.67e-6 l=2.52e-6 m=1
C_LVS_XC12_186 vcp bp9 cap_cmomi w=2.67e-6 l=2.52e-6 m=1
C_LVS_XC12_187 vcp bp9 cap_cmomi w=2.67e-6 l=2.52e-6 m=1
C_LVS_XC12_188 vcp bp9 cap_cmomi w=2.67e-6 l=2.52e-6 m=1
C_LVS_XC12_189 vcp bp9 cap_cmomi w=2.67e-6 l=2.52e-6 m=1
C_LVS_XC12_190 vcp bp9 cap_cmomi w=2.67e-6 l=2.52e-6 m=1
C_LVS_XC12_191 vcp bp9 cap_cmomi w=2.67e-6 l=2.52e-6 m=1
C_LVS_XC12_192 vcp bp9 cap_cmomi w=2.67e-6 l=2.52e-6 m=1
C_LVS_XC12_193 vcp bp9 cap_cmomi w=2.67e-6 l=2.52e-6 m=1
C_LVS_XC12_194 vcp bp9 cap_cmomi w=2.67e-6 l=2.52e-6 m=1
C_LVS_XC12_195 vcp bp9 cap_cmomi w=2.67e-6 l=2.52e-6 m=1
C_LVS_XC12_196 vcp bp9 cap_cmomi w=2.67e-6 l=2.52e-6 m=1
C_LVS_XC12_197 vcp bp9 cap_cmomi w=2.67e-6 l=2.52e-6 m=1
C_LVS_XC12_198 vcp bp9 cap_cmomi w=2.67e-6 l=2.52e-6 m=1
C_LVS_XC12_199 vcp bp9 cap_cmomi w=2.67e-6 l=2.52e-6 m=1
C_LVS_XC12_200 vcp bp9 cap_cmomi w=2.67e-6 l=2.52e-6 m=1
C_LVS_XC12_201 vcp bp9 cap_cmomi w=2.67e-6 l=2.52e-6 m=1
C_LVS_XC12_202 vcp bp9 cap_cmomi w=2.67e-6 l=2.52e-6 m=1
C_LVS_XC12_203 vcp bp9 cap_cmomi w=2.67e-6 l=2.52e-6 m=1
C_LVS_XC12_204 vcp bp9 cap_cmomi w=2.67e-6 l=2.52e-6 m=1
C_LVS_XC12_205 vcp bp9 cap_cmomi w=2.67e-6 l=2.52e-6 m=1
C_LVS_XC12_206 vcp bp9 cap_cmomi w=2.67e-6 l=2.52e-6 m=1
C_LVS_XC12_207 vcp bp9 cap_cmomi w=2.67e-6 l=2.52e-6 m=1
C_LVS_XC12_208 vcp bp9 cap_cmomi w=2.67e-6 l=2.52e-6 m=1
C_LVS_XC12_209 vcp bp9 cap_cmomi w=2.67e-6 l=2.52e-6 m=1
C_LVS_XC12_210 vcp bp9 cap_cmomi w=2.67e-6 l=2.52e-6 m=1
C_LVS_XC12_211 vcp bp9 cap_cmomi w=2.67e-6 l=2.52e-6 m=1
C_LVS_XC12_212 vcp bp9 cap_cmomi w=2.67e-6 l=2.52e-6 m=1
C_LVS_XC12_213 vcp bp9 cap_cmomi w=2.67e-6 l=2.52e-6 m=1
C_LVS_XC12_214 vcp bp9 cap_cmomi w=2.67e-6 l=2.52e-6 m=1
C_LVS_XC12_215 vcp bp9 cap_cmomi w=2.67e-6 l=2.52e-6 m=1
C_LVS_XC12_216 vcp bp9 cap_cmomi w=2.67e-6 l=2.52e-6 m=1
C_LVS_XC12_217 vcp bp9 cap_cmomi w=2.67e-6 l=2.52e-6 m=1
C_LVS_XC12_218 vcp bp9 cap_cmomi w=2.67e-6 l=2.52e-6 m=1
C_LVS_XC12_219 vcp bp9 cap_cmomi w=2.67e-6 l=2.52e-6 m=1
C_LVS_XC12_220 vcp bp9 cap_cmomi w=2.67e-6 l=2.52e-6 m=1
C_LVS_XC12_221 vcp bp9 cap_cmomi w=2.67e-6 l=2.52e-6 m=1
C_LVS_XC12_222 vcp bp9 cap_cmomi w=2.67e-6 l=2.52e-6 m=1
C_LVS_XC12_223 vcp bp9 cap_cmomi w=2.67e-6 l=2.52e-6 m=1
C_LVS_XC12_224 vcp bp9 cap_cmomi w=2.67e-6 l=2.52e-6 m=1
C_LVS_XC12_225 vcp bp9 cap_cmomi w=2.67e-6 l=2.52e-6 m=1
C_LVS_XC12_226 vcp bp9 cap_cmomi w=2.67e-6 l=2.52e-6 m=1
C_LVS_XC12_227 vcp bp9 cap_cmomi w=2.67e-6 l=2.52e-6 m=1
C_LVS_XC12_228 vcp bp9 cap_cmomi w=2.67e-6 l=2.52e-6 m=1
C_LVS_XC12_229 vcp bp9 cap_cmomi w=2.67e-6 l=2.52e-6 m=1
C_LVS_XC12_230 vcp bp9 cap_cmomi w=2.67e-6 l=2.52e-6 m=1
C_LVS_XC12_231 vcp bp9 cap_cmomi w=2.67e-6 l=2.52e-6 m=1
C_LVS_XC12_232 vcp bp9 cap_cmomi w=2.67e-6 l=2.52e-6 m=1
C_LVS_XC12_233 vcp bp9 cap_cmomi w=2.67e-6 l=2.52e-6 m=1
C_LVS_XC12_234 vcp bp9 cap_cmomi w=2.67e-6 l=2.52e-6 m=1
C_LVS_XC12_235 vcp bp9 cap_cmomi w=2.67e-6 l=2.52e-6 m=1
C_LVS_XC12_236 vcp bp9 cap_cmomi w=2.67e-6 l=2.52e-6 m=1
C_LVS_XC12_237 vcp bp9 cap_cmomi w=2.67e-6 l=2.52e-6 m=1
C_LVS_XC12_238 vcp bp9 cap_cmomi w=2.67e-6 l=2.52e-6 m=1
C_LVS_XC12_239 vcp bp9 cap_cmomi w=2.67e-6 l=2.52e-6 m=1
C_LVS_XC12_240 vcp bp9 cap_cmomi w=2.67e-6 l=2.52e-6 m=1
C_LVS_XC12_241 vcp bp9 cap_cmomi w=2.67e-6 l=2.52e-6 m=1
C_LVS_XC12_242 vcp bp9 cap_cmomi w=2.67e-6 l=2.52e-6 m=1
C_LVS_XC12_243 vcp bp9 cap_cmomi w=2.67e-6 l=2.52e-6 m=1
C_LVS_XC12_244 vcp bp9 cap_cmomi w=2.67e-6 l=2.52e-6 m=1
C_LVS_XC12_245 vcp bp9 cap_cmomi w=2.67e-6 l=2.52e-6 m=1
C_LVS_XC12_246 vcp bp9 cap_cmomi w=2.67e-6 l=2.52e-6 m=1
C_LVS_XC12_247 vcp bp9 cap_cmomi w=2.67e-6 l=2.52e-6 m=1
C_LVS_XC12_248 vcp bp9 cap_cmomi w=2.67e-6 l=2.52e-6 m=1
C_LVS_XC12_249 vcp bp9 cap_cmomi w=2.67e-6 l=2.52e-6 m=1
C_LVS_XC12_250 vcp bp9 cap_cmomi w=2.67e-6 l=2.52e-6 m=1
C_LVS_XC12_251 vcp bp9 cap_cmomi w=2.67e-6 l=2.52e-6 m=1
C_LVS_XC12_252 vcp bp9 cap_cmomi w=2.67e-6 l=2.52e-6 m=1
C_LVS_XC12_253 vcp bp9 cap_cmomi w=2.67e-6 l=2.52e-6 m=1
C_LVS_XC12_254 vcp bp9 cap_cmomi w=2.67e-6 l=2.52e-6 m=1
C_LVS_XC12_255 vcp bp9 cap_cmomi w=2.67e-6 l=2.52e-6 m=1
C_LVS_XC12_256 vcp bp9 cap_cmomi w=2.67e-6 l=2.52e-6 m=1
C_LVS_XC12_257 vcp bp9 cap_cmomi w=2.67e-6 l=2.52e-6 m=1
C_LVS_XC12_258 vcp bp9 cap_cmomi w=2.67e-6 l=2.52e-6 m=1
C_LVS_XC12_259 vcp bp9 cap_cmomi w=2.67e-6 l=2.52e-6 m=1
C_LVS_XC12_260 vcp bp9 cap_cmomi w=2.67e-6 l=2.52e-6 m=1
C_LVS_XC12_261 vcp bp9 cap_cmomi w=2.67e-6 l=2.52e-6 m=1
C_LVS_XC12_262 vcp bp9 cap_cmomi w=2.67e-6 l=2.52e-6 m=1
C_LVS_XC12_263 vcp bp9 cap_cmomi w=2.67e-6 l=2.52e-6 m=1
C_LVS_XC12_264 vcp bp9 cap_cmomi w=2.67e-6 l=2.52e-6 m=1
C_LVS_XC12_265 vcp bp9 cap_cmomi w=2.67e-6 l=2.52e-6 m=1
C_LVS_XC12_266 vcp bp9 cap_cmomi w=2.67e-6 l=2.52e-6 m=1
C_LVS_XC12_267 vcp bp9 cap_cmomi w=2.67e-6 l=2.52e-6 m=1
C_LVS_XC12_268 vcp bp9 cap_cmomi w=2.67e-6 l=2.52e-6 m=1
C_LVS_XC12_269 vcp bp9 cap_cmomi w=2.67e-6 l=2.52e-6 m=1
C_LVS_XC12_270 vcp bp9 cap_cmomi w=2.67e-6 l=2.52e-6 m=1
C_LVS_XC12_271 vcp bp9 cap_cmomi w=2.67e-6 l=2.52e-6 m=1
C_LVS_XC12_272 vcp bp9 cap_cmomi w=2.67e-6 l=2.52e-6 m=1
C_LVS_XC12_273 vcp bp9 cap_cmomi w=2.67e-6 l=2.52e-6 m=1
C_LVS_XC12_274 vcp bp9 cap_cmomi w=2.67e-6 l=2.52e-6 m=1
C_LVS_XC12_275 vcp bp9 cap_cmomi w=2.67e-6 l=2.52e-6 m=1
C_LVS_XC12_276 vcp bp9 cap_cmomi w=2.67e-6 l=2.52e-6 m=1
C_LVS_XC12_277 vcp bp9 cap_cmomi w=2.67e-6 l=2.52e-6 m=1
C_LVS_XC12_278 vcp bp9 cap_cmomi w=2.67e-6 l=2.52e-6 m=1
C_LVS_XC12_279 vcp bp9 cap_cmomi w=2.67e-6 l=2.52e-6 m=1
C_LVS_XC12_280 vcp bp9 cap_cmomi w=2.67e-6 l=2.52e-6 m=1
C_LVS_XC12_281 vcp bp9 cap_cmomi w=2.67e-6 l=2.52e-6 m=1
C_LVS_XC12_282 vcp bp9 cap_cmomi w=2.67e-6 l=2.52e-6 m=1
C_LVS_XC12_283 vcp bp9 cap_cmomi w=2.67e-6 l=2.52e-6 m=1
C_LVS_XC12_284 vcp bp9 cap_cmomi w=2.67e-6 l=2.52e-6 m=1
C_LVS_XC12_285 vcp bp9 cap_cmomi w=2.67e-6 l=2.52e-6 m=1
C_LVS_XC12_286 vcp bp9 cap_cmomi w=2.67e-6 l=2.52e-6 m=1
C_LVS_XC12_287 vcp bp9 cap_cmomi w=2.67e-6 l=2.52e-6 m=1
C_LVS_XC12_288 vcp bp9 cap_cmomi w=2.67e-6 l=2.52e-6 m=1
C_LVS_XC12_289 vcp bp9 cap_cmomi w=2.67e-6 l=2.52e-6 m=1
C_LVS_XC12_290 vcp bp9 cap_cmomi w=2.67e-6 l=2.52e-6 m=1
C_LVS_XC12_291 vcp bp9 cap_cmomi w=2.67e-6 l=2.52e-6 m=1
C_LVS_XC12_292 vcp bp9 cap_cmomi w=2.67e-6 l=2.52e-6 m=1
C_LVS_XC12_293 vcp bp9 cap_cmomi w=2.67e-6 l=2.52e-6 m=1
C_LVS_XC12_294 vcp bp9 cap_cmomi w=2.67e-6 l=2.52e-6 m=1
C_LVS_XC12_295 vcp bp9 cap_cmomi w=2.67e-6 l=2.52e-6 m=1
C_LVS_XC12_296 vcp bp9 cap_cmomi w=2.67e-6 l=2.52e-6 m=1
C_LVS_XC12_297 vcp bp9 cap_cmomi w=2.67e-6 l=2.52e-6 m=1
C_LVS_XC12_298 vcp bp9 cap_cmomi w=2.67e-6 l=2.52e-6 m=1
C_LVS_XC12_299 vcp bp9 cap_cmomi w=2.67e-6 l=2.52e-6 m=1
C_LVS_XC12_300 vcp bp9 cap_cmomi w=2.67e-6 l=2.52e-6 m=1
C_LVS_XC12_301 vcp bp9 cap_cmomi w=2.67e-6 l=2.52e-6 m=1
C_LVS_XC12_302 vcp bp9 cap_cmomi w=2.67e-6 l=2.52e-6 m=1
C_LVS_XC12_303 vcp bp9 cap_cmomi w=2.67e-6 l=2.52e-6 m=1
C_LVS_XC12_304 vcp bp9 cap_cmomi w=2.67e-6 l=2.52e-6 m=1
C_LVS_XC12_305 vcp bp9 cap_cmomi w=2.67e-6 l=2.52e-6 m=1
C_LVS_XC12_306 vcp bp9 cap_cmomi w=2.67e-6 l=2.52e-6 m=1
C_LVS_XC12_307 vcp bp9 cap_cmomi w=2.67e-6 l=2.52e-6 m=1
C_LVS_XC12_308 vcp bp9 cap_cmomi w=2.67e-6 l=2.52e-6 m=1
C_LVS_XC12_309 vcp bp9 cap_cmomi w=2.67e-6 l=2.52e-6 m=1
C_LVS_XC12_310 vcp bp9 cap_cmomi w=2.67e-6 l=2.52e-6 m=1
C_LVS_XC12_311 vcp bp9 cap_cmomi w=2.67e-6 l=2.52e-6 m=1
C_LVS_XC12_312 vcp bp9 cap_cmomi w=2.67e-6 l=2.52e-6 m=1
C_LVS_XC12_313 vcp bp9 cap_cmomi w=2.67e-6 l=2.52e-6 m=1
C_LVS_XC12_314 vcp bp9 cap_cmomi w=2.67e-6 l=2.52e-6 m=1
C_LVS_XC12_315 vcp bp9 cap_cmomi w=2.67e-6 l=2.52e-6 m=1
C_LVS_XC12_316 vcp bp9 cap_cmomi w=2.67e-6 l=2.52e-6 m=1
C_LVS_XC12_317 vcp bp9 cap_cmomi w=2.67e-6 l=2.52e-6 m=1
C_LVS_XC12_318 vcp bp9 cap_cmomi w=2.67e-6 l=2.52e-6 m=1
C_LVS_XC12_319 vcp bp9 cap_cmomi w=2.67e-6 l=2.52e-6 m=1
C_LVS_XC12_320 vcp bp9 cap_cmomi w=2.67e-6 l=2.52e-6 m=1
C_LVS_XC12_321 vcp bp9 cap_cmomi w=2.67e-6 l=2.52e-6 m=1
C_LVS_XC12_322 vcp bp9 cap_cmomi w=2.67e-6 l=2.52e-6 m=1
C_LVS_XC12_323 vcp bp9 cap_cmomi w=2.67e-6 l=2.52e-6 m=1
C_LVS_XC12_324 vcp bp9 cap_cmomi w=2.67e-6 l=2.52e-6 m=1
C_LVS_XC12_325 vcp bp9 cap_cmomi w=2.67e-6 l=2.52e-6 m=1
C_LVS_XC12_326 vcp bp9 cap_cmomi w=2.67e-6 l=2.52e-6 m=1
C_LVS_XC12_327 vcp bp9 cap_cmomi w=2.67e-6 l=2.52e-6 m=1
C_LVS_XC12_328 vcp bp9 cap_cmomi w=2.67e-6 l=2.52e-6 m=1
C_LVS_XC12_329 vcp bp9 cap_cmomi w=2.67e-6 l=2.52e-6 m=1
C_LVS_XC12_330 vcp bp9 cap_cmomi w=2.67e-6 l=2.52e-6 m=1
C_LVS_XC12_331 vcp bp9 cap_cmomi w=2.67e-6 l=2.52e-6 m=1
C_LVS_XC12_332 vcp bp9 cap_cmomi w=2.67e-6 l=2.52e-6 m=1
C_LVS_XC12_333 vcp bp9 cap_cmomi w=2.67e-6 l=2.52e-6 m=1
C_LVS_XC12_334 vcp bp9 cap_cmomi w=2.67e-6 l=2.52e-6 m=1
C_LVS_XC12_335 vcp bp9 cap_cmomi w=2.67e-6 l=2.52e-6 m=1
C_LVS_XC12_336 vcp bp9 cap_cmomi w=2.67e-6 l=2.52e-6 m=1
C_LVS_XC12_337 vcp bp9 cap_cmomi w=2.67e-6 l=2.52e-6 m=1
C_LVS_XC12_338 vcp bp9 cap_cmomi w=2.67e-6 l=2.52e-6 m=1
C_LVS_XC12_339 vcp bp9 cap_cmomi w=2.67e-6 l=2.52e-6 m=1
C_LVS_XC12_340 vcp bp9 cap_cmomi w=2.67e-6 l=2.52e-6 m=1
C_LVS_XC12_341 vcp bp9 cap_cmomi w=2.67e-6 l=2.52e-6 m=1
C_LVS_XC12_342 vcp bp9 cap_cmomi w=2.67e-6 l=2.52e-6 m=1
C_LVS_XC12_343 vcp bp9 cap_cmomi w=2.67e-6 l=2.52e-6 m=1
C_LVS_XC12_344 vcp bp9 cap_cmomi w=2.67e-6 l=2.52e-6 m=1
C_LVS_XC12_345 vcp bp9 cap_cmomi w=2.67e-6 l=2.52e-6 m=1
C_LVS_XC12_346 vcp bp9 cap_cmomi w=2.67e-6 l=2.52e-6 m=1
C_LVS_XC12_347 vcp bp9 cap_cmomi w=2.67e-6 l=2.52e-6 m=1
C_LVS_XC12_348 vcp bp9 cap_cmomi w=2.67e-6 l=2.52e-6 m=1
C_LVS_XC12_349 vcp bp9 cap_cmomi w=2.67e-6 l=2.52e-6 m=1
C_LVS_XC12_350 vcp bp9 cap_cmomi w=2.67e-6 l=2.52e-6 m=1
C_LVS_XC12_351 vcp bp9 cap_cmomi w=2.67e-6 l=2.52e-6 m=1
C_LVS_XC12_352 vcp bp9 cap_cmomi w=2.67e-6 l=2.52e-6 m=1
C_LVS_XC12_353 vcp bp9 cap_cmomi w=2.67e-6 l=2.52e-6 m=1
C_LVS_XC12_354 vcp bp9 cap_cmomi w=2.67e-6 l=2.52e-6 m=1
C_LVS_XC12_355 vcp bp9 cap_cmomi w=2.67e-6 l=2.52e-6 m=1
C_LVS_XC12_356 vcp bp9 cap_cmomi w=2.67e-6 l=2.52e-6 m=1
C_LVS_XC12_357 vcp bp9 cap_cmomi w=2.67e-6 l=2.52e-6 m=1
C_LVS_XC12_358 vcp bp9 cap_cmomi w=2.67e-6 l=2.52e-6 m=1
C_LVS_XC12_359 vcp bp9 cap_cmomi w=2.67e-6 l=2.52e-6 m=1
C_LVS_XC12_360 vcp bp9 cap_cmomi w=2.67e-6 l=2.52e-6 m=1
C_LVS_XC12_361 vcp bp9 cap_cmomi w=2.67e-6 l=2.52e-6 m=1
C_LVS_XC12_362 vcp bp9 cap_cmomi w=2.67e-6 l=2.52e-6 m=1
C_LVS_XC12_363 vcp bp9 cap_cmomi w=2.67e-6 l=2.52e-6 m=1
C_LVS_XC12_364 vcp bp9 cap_cmomi w=2.67e-6 l=2.52e-6 m=1
C_LVS_XC12_365 vcp bp9 cap_cmomi w=2.67e-6 l=2.52e-6 m=1
C_LVS_XC12_366 vcp bp9 cap_cmomi w=2.67e-6 l=2.52e-6 m=1
C_LVS_XC12_367 vcp bp9 cap_cmomi w=2.67e-6 l=2.52e-6 m=1
C_LVS_XC12_368 vcp bp9 cap_cmomi w=2.67e-6 l=2.52e-6 m=1
C_LVS_XC12_369 vcp bp9 cap_cmomi w=2.67e-6 l=2.52e-6 m=1
C_LVS_XC12_370 vcp bp9 cap_cmomi w=2.67e-6 l=2.52e-6 m=1
C_LVS_XC12_371 vcp bp9 cap_cmomi w=2.67e-6 l=2.52e-6 m=1
C_LVS_XC12_372 vcp bp9 cap_cmomi w=2.67e-6 l=2.52e-6 m=1
C_LVS_XC12_373 vcp bp9 cap_cmomi w=2.67e-6 l=2.52e-6 m=1
C_LVS_XC12_374 vcp bp9 cap_cmomi w=2.67e-6 l=2.52e-6 m=1
C_LVS_XC12_375 vcp bp9 cap_cmomi w=2.67e-6 l=2.52e-6 m=1
C_LVS_XC12_376 vcp bp9 cap_cmomi w=2.67e-6 l=2.52e-6 m=1
C_LVS_XC12_377 vcp bp9 cap_cmomi w=2.67e-6 l=2.52e-6 m=1
C_LVS_XC12_378 vcp bp9 cap_cmomi w=2.67e-6 l=2.52e-6 m=1
C_LVS_XC12_379 vcp bp9 cap_cmomi w=2.67e-6 l=2.52e-6 m=1
C_LVS_XC12_380 vcp bp9 cap_cmomi w=2.67e-6 l=2.52e-6 m=1
C_LVS_XC12_381 vcp bp9 cap_cmomi w=2.67e-6 l=2.52e-6 m=1
C_LVS_XC12_382 vcp bp9 cap_cmomi w=2.67e-6 l=2.52e-6 m=1
C_LVS_XC12_383 vcp bp9 cap_cmomi w=2.67e-6 l=2.52e-6 m=1
C_LVS_XC12_384 vcp bp9 cap_cmomi w=2.67e-6 l=2.52e-6 m=1
C_LVS_XC12_385 vcp bp9 cap_cmomi w=2.67e-6 l=2.52e-6 m=1
C_LVS_XC12_386 vcp bp9 cap_cmomi w=2.67e-6 l=2.52e-6 m=1
C_LVS_XC12_387 vcp bp9 cap_cmomi w=2.67e-6 l=2.52e-6 m=1
C_LVS_XC12_388 vcp bp9 cap_cmomi w=2.67e-6 l=2.52e-6 m=1
C_LVS_XC12_389 vcp bp9 cap_cmomi w=2.67e-6 l=2.52e-6 m=1
C_LVS_XC12_390 vcp bp9 cap_cmomi w=2.67e-6 l=2.52e-6 m=1
C_LVS_XC12_391 vcp bp9 cap_cmomi w=2.67e-6 l=2.52e-6 m=1
C_LVS_XC12_392 vcp bp9 cap_cmomi w=2.67e-6 l=2.52e-6 m=1
C_LVS_XC12_393 vcp bp9 cap_cmomi w=2.67e-6 l=2.52e-6 m=1
C_LVS_XC12_394 vcp bp9 cap_cmomi w=2.67e-6 l=2.52e-6 m=1
C_LVS_XC12_395 vcp bp9 cap_cmomi w=2.67e-6 l=2.52e-6 m=1
C_LVS_XC12_396 vcp bp9 cap_cmomi w=2.67e-6 l=2.52e-6 m=1
C_LVS_XC12_397 vcp bp9 cap_cmomi w=2.67e-6 l=2.52e-6 m=1
C_LVS_XC12_398 vcp bp9 cap_cmomi w=2.67e-6 l=2.52e-6 m=1
C_LVS_XC12_399 vcp bp9 cap_cmomi w=2.67e-6 l=2.52e-6 m=1
C_LVS_XC12_400 vcp bp9 cap_cmomi w=2.67e-6 l=2.52e-6 m=1
C_LVS_XC12_401 vcp bp9 cap_cmomi w=2.67e-6 l=2.52e-6 m=1
C_LVS_XC12_402 vcp bp9 cap_cmomi w=2.67e-6 l=2.52e-6 m=1
C_LVS_XC12_403 vcp bp9 cap_cmomi w=2.67e-6 l=2.52e-6 m=1
C_LVS_XC12_404 vcp bp9 cap_cmomi w=2.67e-6 l=2.52e-6 m=1
C_LVS_XC12_405 vcp bp9 cap_cmomi w=2.67e-6 l=2.52e-6 m=1
C_LVS_XC12_406 vcp bp9 cap_cmomi w=2.67e-6 l=2.52e-6 m=1
C_LVS_XC12_407 vcp bp9 cap_cmomi w=2.67e-6 l=2.52e-6 m=1
C_LVS_XC12_408 vcp bp9 cap_cmomi w=2.67e-6 l=2.52e-6 m=1
C_LVS_XC12_409 vcp bp9 cap_cmomi w=2.67e-6 l=2.52e-6 m=1
C_LVS_XC12_410 vcp bp9 cap_cmomi w=2.67e-6 l=2.52e-6 m=1
C_LVS_XC12_411 vcp bp9 cap_cmomi w=2.67e-6 l=2.52e-6 m=1
C_LVS_XC12_412 vcp bp9 cap_cmomi w=2.67e-6 l=2.52e-6 m=1
C_LVS_XC12_413 vcp bp9 cap_cmomi w=2.67e-6 l=2.52e-6 m=1
C_LVS_XC12_414 vcp bp9 cap_cmomi w=2.67e-6 l=2.52e-6 m=1
C_LVS_XC12_415 vcp bp9 cap_cmomi w=2.67e-6 l=2.52e-6 m=1
C_LVS_XC12_416 vcp bp9 cap_cmomi w=2.67e-6 l=2.52e-6 m=1
C_LVS_XC12_417 vcp bp9 cap_cmomi w=2.67e-6 l=2.52e-6 m=1
C_LVS_XC12_418 vcp bp9 cap_cmomi w=2.67e-6 l=2.52e-6 m=1
C_LVS_XC12_419 vcp bp9 cap_cmomi w=2.67e-6 l=2.52e-6 m=1
C_LVS_XC12_420 vcp bp9 cap_cmomi w=2.67e-6 l=2.52e-6 m=1
C_LVS_XC12_421 vcp bp9 cap_cmomi w=2.67e-6 l=2.52e-6 m=1
C_LVS_XC12_422 vcp bp9 cap_cmomi w=2.67e-6 l=2.52e-6 m=1
C_LVS_XC12_423 vcp bp9 cap_cmomi w=2.67e-6 l=2.52e-6 m=1
C_LVS_XC12_424 vcp bp9 cap_cmomi w=2.67e-6 l=2.52e-6 m=1
C_LVS_XC12_425 vcp bp9 cap_cmomi w=2.67e-6 l=2.52e-6 m=1
C_LVS_XC12_426 vcp bp9 cap_cmomi w=2.67e-6 l=2.52e-6 m=1
C_LVS_XC12_427 vcp bp9 cap_cmomi w=2.67e-6 l=2.52e-6 m=1
C_LVS_XC12_428 vcp bp9 cap_cmomi w=2.67e-6 l=2.52e-6 m=1
C_LVS_XC12_429 vcp bp9 cap_cmomi w=2.67e-6 l=2.52e-6 m=1
C_LVS_XC12_430 vcp bp9 cap_cmomi w=2.67e-6 l=2.52e-6 m=1
C_LVS_XC12_431 vcp bp9 cap_cmomi w=2.67e-6 l=2.52e-6 m=1
C_LVS_XC12_432 vcp bp9 cap_cmomi w=2.67e-6 l=2.52e-6 m=1
C_LVS_XC12_433 vcp bp9 cap_cmomi w=2.67e-6 l=2.52e-6 m=1
C_LVS_XC12_434 vcp bp9 cap_cmomi w=2.67e-6 l=2.52e-6 m=1
C_LVS_XC12_435 vcp bp9 cap_cmomi w=2.67e-6 l=2.52e-6 m=1
C_LVS_XC12_436 vcp bp9 cap_cmomi w=2.67e-6 l=2.52e-6 m=1
C_LVS_XC12_437 vcp bp9 cap_cmomi w=2.67e-6 l=2.52e-6 m=1
C_LVS_XC12_438 vcp bp9 cap_cmomi w=2.67e-6 l=2.52e-6 m=1
C_LVS_XC12_439 vcp bp9 cap_cmomi w=2.67e-6 l=2.52e-6 m=1
C_LVS_XC12_440 vcp bp9 cap_cmomi w=2.67e-6 l=2.52e-6 m=1
C_LVS_XC12_441 vcp bp9 cap_cmomi w=2.67e-6 l=2.52e-6 m=1
C_LVS_XC12_442 vcp bp9 cap_cmomi w=2.67e-6 l=2.52e-6 m=1
C_LVS_XC12_443 vcp bp9 cap_cmomi w=2.67e-6 l=2.52e-6 m=1
C_LVS_XC12_444 vcp bp9 cap_cmomi w=2.67e-6 l=2.52e-6 m=1
C_LVS_XC12_445 vcp bp9 cap_cmomi w=2.67e-6 l=2.52e-6 m=1
C_LVS_XC12_446 vcp bp9 cap_cmomi w=2.67e-6 l=2.52e-6 m=1
C_LVS_XC12_447 vcp bp9 cap_cmomi w=2.67e-6 l=2.52e-6 m=1
C_LVS_XC12_448 vcp bp9 cap_cmomi w=2.67e-6 l=2.52e-6 m=1
C_LVS_XC12_449 vcp bp9 cap_cmomi w=2.67e-6 l=2.52e-6 m=1
C_LVS_XC12_450 vcp bp9 cap_cmomi w=2.67e-6 l=2.52e-6 m=1
C_LVS_XC12_451 vcp bp9 cap_cmomi w=2.67e-6 l=2.52e-6 m=1
C_LVS_XC12_452 vcp bp9 cap_cmomi w=2.67e-6 l=2.52e-6 m=1
C_LVS_XC12_453 vcp bp9 cap_cmomi w=2.67e-6 l=2.52e-6 m=1
C_LVS_XC12_454 vcp bp9 cap_cmomi w=2.67e-6 l=2.52e-6 m=1
C_LVS_XC12_455 vcp bp9 cap_cmomi w=2.67e-6 l=2.52e-6 m=1
C_LVS_XC12_456 vcp bp9 cap_cmomi w=2.67e-6 l=2.52e-6 m=1
C_LVS_XC12_457 vcp bp9 cap_cmomi w=2.67e-6 l=2.52e-6 m=1
C_LVS_XC12_458 vcp bp9 cap_cmomi w=2.67e-6 l=2.52e-6 m=1
C_LVS_XC12_459 vcp bp9 cap_cmomi w=2.67e-6 l=2.52e-6 m=1
C_LVS_XC12_460 vcp bp9 cap_cmomi w=2.67e-6 l=2.52e-6 m=1
C_LVS_XC12_461 vcp bp9 cap_cmomi w=2.67e-6 l=2.52e-6 m=1
C_LVS_XC12_462 vcp bp9 cap_cmomi w=2.67e-6 l=2.52e-6 m=1
C_LVS_XC12_463 vcp bp9 cap_cmomi w=2.67e-6 l=2.52e-6 m=1
C_LVS_XC12_464 vcp bp9 cap_cmomi w=2.67e-6 l=2.52e-6 m=1
C_LVS_XC12_465 vcp bp9 cap_cmomi w=2.67e-6 l=2.52e-6 m=1
C_LVS_XC12_466 vcp bp9 cap_cmomi w=2.67e-6 l=2.52e-6 m=1
C_LVS_XC12_467 vcp bp9 cap_cmomi w=2.67e-6 l=2.52e-6 m=1
C_LVS_XC12_468 vcp bp9 cap_cmomi w=2.67e-6 l=2.52e-6 m=1
C_LVS_XC12_469 vcp bp9 cap_cmomi w=2.67e-6 l=2.52e-6 m=1
C_LVS_XC12_470 vcp bp9 cap_cmomi w=2.67e-6 l=2.52e-6 m=1
C_LVS_XC12_471 vcp bp9 cap_cmomi w=2.67e-6 l=2.52e-6 m=1
C_LVS_XC12_472 vcp bp9 cap_cmomi w=2.67e-6 l=2.52e-6 m=1
C_LVS_XC12_473 vcp bp9 cap_cmomi w=2.67e-6 l=2.52e-6 m=1
C_LVS_XC12_474 vcp bp9 cap_cmomi w=2.67e-6 l=2.52e-6 m=1
C_LVS_XC12_475 vcp bp9 cap_cmomi w=2.67e-6 l=2.52e-6 m=1
C_LVS_XC12_476 vcp bp9 cap_cmomi w=2.67e-6 l=2.52e-6 m=1
C_LVS_XC12_477 vcp bp9 cap_cmomi w=2.67e-6 l=2.52e-6 m=1
C_LVS_XC12_478 vcp bp9 cap_cmomi w=2.67e-6 l=2.52e-6 m=1
C_LVS_XC12_479 vcp bp9 cap_cmomi w=2.67e-6 l=2.52e-6 m=1
C_LVS_XC12_480 vcp bp9 cap_cmomi w=2.67e-6 l=2.52e-6 m=1
C_LVS_XC12_481 vcp bp9 cap_cmomi w=2.67e-6 l=2.52e-6 m=1
C_LVS_XC12_482 vcp bp9 cap_cmomi w=2.67e-6 l=2.52e-6 m=1
C_LVS_XC12_483 vcp bp9 cap_cmomi w=2.67e-6 l=2.52e-6 m=1
C_LVS_XC12_484 vcp bp9 cap_cmomi w=2.67e-6 l=2.52e-6 m=1
C_LVS_XC12_485 vcp bp9 cap_cmomi w=2.67e-6 l=2.52e-6 m=1
C_LVS_XC12_486 vcp bp9 cap_cmomi w=2.67e-6 l=2.52e-6 m=1
C_LVS_XC12_487 vcp bp9 cap_cmomi w=2.67e-6 l=2.52e-6 m=1
C_LVS_XC12_488 vcp bp9 cap_cmomi w=2.67e-6 l=2.52e-6 m=1
C_LVS_XC12_489 vcp bp9 cap_cmomi w=2.67e-6 l=2.52e-6 m=1
C_LVS_XC12_490 vcp bp9 cap_cmomi w=2.67e-6 l=2.52e-6 m=1
C_LVS_XC12_491 vcp bp9 cap_cmomi w=2.67e-6 l=2.52e-6 m=1
C_LVS_XC12_492 vcp bp9 cap_cmomi w=2.67e-6 l=2.52e-6 m=1
C_LVS_XC12_493 vcp bp9 cap_cmomi w=2.67e-6 l=2.52e-6 m=1
C_LVS_XC12_494 vcp bp9 cap_cmomi w=2.67e-6 l=2.52e-6 m=1
C_LVS_XC12_495 vcp bp9 cap_cmomi w=2.67e-6 l=2.52e-6 m=1
C_LVS_XC12_496 vcp bp9 cap_cmomi w=2.67e-6 l=2.52e-6 m=1
C_LVS_XC12_497 vcp bp9 cap_cmomi w=2.67e-6 l=2.52e-6 m=1
C_LVS_XC12_498 vcp bp9 cap_cmomi w=2.67e-6 l=2.52e-6 m=1
C_LVS_XC12_499 vcp bp9 cap_cmomi w=2.67e-6 l=2.52e-6 m=1
C_LVS_XC12_500 vcp bp9 cap_cmomi w=2.67e-6 l=2.52e-6 m=1
C_LVS_XC12_501 vcp bp9 cap_cmomi w=2.67e-6 l=2.52e-6 m=1
C_LVS_XC12_502 vcp bp9 cap_cmomi w=2.67e-6 l=2.52e-6 m=1
C_LVS_XC12_503 vcp bp9 cap_cmomi w=2.67e-6 l=2.52e-6 m=1
C_LVS_XC12_504 vcp bp9 cap_cmomi w=2.67e-6 l=2.52e-6 m=1
C_LVS_XC12_505 vcp bp9 cap_cmomi w=2.67e-6 l=2.52e-6 m=1
C_LVS_XC12_506 vcp bp9 cap_cmomi w=2.67e-6 l=2.52e-6 m=1
C_LVS_XC12_507 vcp bp9 cap_cmomi w=2.67e-6 l=2.52e-6 m=1
C_LVS_XC12_508 vcp bp9 cap_cmomi w=2.67e-6 l=2.52e-6 m=1
C_LVS_XC12_509 vcp bp9 cap_cmomi w=2.67e-6 l=2.52e-6 m=1
C_LVS_XC12_510 vcp bp9 cap_cmomi w=2.67e-6 l=2.52e-6 m=1
C_LVS_XC12_511 vcp bp9 cap_cmomi w=2.67e-6 l=2.52e-6 m=1
C_LVS_XC12_512 vcp bp9 cap_cmomi w=2.67e-6 l=2.52e-6 m=1
C_LVS_XC12_513 vcp bp9 cap_cmomi w=2.67e-6 l=2.52e-6 m=1
C_LVS_XC12_514 vcp bp9 cap_cmomi w=2.67e-6 l=2.52e-6 m=1
C_LVS_XC12_515 vcp bp9 cap_cmomi w=2.67e-6 l=2.52e-6 m=1
C_LVS_XC11_1 vcn bnd cap_cmomi w=2.67e-6 l=2.52e-6 m=1
C_LVS_XC13_1 vcn bn0 cap_cmomi w=2.67e-6 l=2.52e-6 m=1
C_LVS_XC14_1 vcn bn1 cap_cmomi w=2.67e-6 l=2.52e-6 m=1
C_LVS_XC14_2 vcn bn1 cap_cmomi w=2.67e-6 l=2.52e-6 m=1
C_LVS_XC15_1 vcn bn2 cap_cmomi w=2.67e-6 l=2.52e-6 m=1
C_LVS_XC15_2 vcn bn2 cap_cmomi w=2.67e-6 l=2.52e-6 m=1
C_LVS_XC15_3 vcn bn2 cap_cmomi w=2.67e-6 l=2.52e-6 m=1
C_LVS_XC15_4 vcn bn2 cap_cmomi w=2.67e-6 l=2.52e-6 m=1
C_LVS_XC16_1 vcn bn3 cap_cmomi w=2.67e-6 l=2.52e-6 m=1
C_LVS_XC16_2 vcn bn3 cap_cmomi w=2.67e-6 l=2.52e-6 m=1
C_LVS_XC16_3 vcn bn3 cap_cmomi w=2.67e-6 l=2.52e-6 m=1
C_LVS_XC16_4 vcn bn3 cap_cmomi w=2.67e-6 l=2.52e-6 m=1
C_LVS_XC16_5 vcn bn3 cap_cmomi w=2.67e-6 l=2.52e-6 m=1
C_LVS_XC16_6 vcn bn3 cap_cmomi w=2.67e-6 l=2.52e-6 m=1
C_LVS_XC16_7 vcn bn3 cap_cmomi w=2.67e-6 l=2.52e-6 m=1
C_LVS_XC16_8 vcn bn3 cap_cmomi w=2.67e-6 l=2.52e-6 m=1
C_LVS_XC17_1 vcn bn4 cap_cmomi w=2.67e-6 l=2.52e-6 m=1
C_LVS_XC17_2 vcn bn4 cap_cmomi w=2.67e-6 l=2.52e-6 m=1
C_LVS_XC17_3 vcn bn4 cap_cmomi w=2.67e-6 l=2.52e-6 m=1
C_LVS_XC17_4 vcn bn4 cap_cmomi w=2.67e-6 l=2.52e-6 m=1
C_LVS_XC17_5 vcn bn4 cap_cmomi w=2.67e-6 l=2.52e-6 m=1
C_LVS_XC17_6 vcn bn4 cap_cmomi w=2.67e-6 l=2.52e-6 m=1
C_LVS_XC17_7 vcn bn4 cap_cmomi w=2.67e-6 l=2.52e-6 m=1
C_LVS_XC17_8 vcn bn4 cap_cmomi w=2.67e-6 l=2.52e-6 m=1
C_LVS_XC17_9 vcn bn4 cap_cmomi w=2.67e-6 l=2.52e-6 m=1
C_LVS_XC17_10 vcn bn4 cap_cmomi w=2.67e-6 l=2.52e-6 m=1
C_LVS_XC17_11 vcn bn4 cap_cmomi w=2.67e-6 l=2.52e-6 m=1
C_LVS_XC17_12 vcn bn4 cap_cmomi w=2.67e-6 l=2.52e-6 m=1
C_LVS_XC17_13 vcn bn4 cap_cmomi w=2.67e-6 l=2.52e-6 m=1
C_LVS_XC17_14 vcn bn4 cap_cmomi w=2.67e-6 l=2.52e-6 m=1
C_LVS_XC17_15 vcn bn4 cap_cmomi w=2.67e-6 l=2.52e-6 m=1
C_LVS_XC17_16 vcn bn4 cap_cmomi w=2.67e-6 l=2.52e-6 m=1
C_LVS_XC18_1 vcn bn5 cap_cmomi w=2.67e-6 l=2.52e-6 m=1
C_LVS_XC18_2 vcn bn5 cap_cmomi w=2.67e-6 l=2.52e-6 m=1
C_LVS_XC18_3 vcn bn5 cap_cmomi w=2.67e-6 l=2.52e-6 m=1
C_LVS_XC18_4 vcn bn5 cap_cmomi w=2.67e-6 l=2.52e-6 m=1
C_LVS_XC18_5 vcn bn5 cap_cmomi w=2.67e-6 l=2.52e-6 m=1
C_LVS_XC18_6 vcn bn5 cap_cmomi w=2.67e-6 l=2.52e-6 m=1
C_LVS_XC18_7 vcn bn5 cap_cmomi w=2.67e-6 l=2.52e-6 m=1
C_LVS_XC18_8 vcn bn5 cap_cmomi w=2.67e-6 l=2.52e-6 m=1
C_LVS_XC18_9 vcn bn5 cap_cmomi w=2.67e-6 l=2.52e-6 m=1
C_LVS_XC18_10 vcn bn5 cap_cmomi w=2.67e-6 l=2.52e-6 m=1
C_LVS_XC18_11 vcn bn5 cap_cmomi w=2.67e-6 l=2.52e-6 m=1
C_LVS_XC18_12 vcn bn5 cap_cmomi w=2.67e-6 l=2.52e-6 m=1
C_LVS_XC18_13 vcn bn5 cap_cmomi w=2.67e-6 l=2.52e-6 m=1
C_LVS_XC18_14 vcn bn5 cap_cmomi w=2.67e-6 l=2.52e-6 m=1
C_LVS_XC18_15 vcn bn5 cap_cmomi w=2.67e-6 l=2.52e-6 m=1
C_LVS_XC18_16 vcn bn5 cap_cmomi w=2.67e-6 l=2.52e-6 m=1
C_LVS_XC18_17 vcn bn5 cap_cmomi w=2.67e-6 l=2.52e-6 m=1
C_LVS_XC18_18 vcn bn5 cap_cmomi w=2.67e-6 l=2.52e-6 m=1
C_LVS_XC18_19 vcn bn5 cap_cmomi w=2.67e-6 l=2.52e-6 m=1
C_LVS_XC18_20 vcn bn5 cap_cmomi w=2.67e-6 l=2.52e-6 m=1
C_LVS_XC18_21 vcn bn5 cap_cmomi w=2.67e-6 l=2.52e-6 m=1
C_LVS_XC18_22 vcn bn5 cap_cmomi w=2.67e-6 l=2.52e-6 m=1
C_LVS_XC18_23 vcn bn5 cap_cmomi w=2.67e-6 l=2.52e-6 m=1
C_LVS_XC18_24 vcn bn5 cap_cmomi w=2.67e-6 l=2.52e-6 m=1
C_LVS_XC18_25 vcn bn5 cap_cmomi w=2.67e-6 l=2.52e-6 m=1
C_LVS_XC18_26 vcn bn5 cap_cmomi w=2.67e-6 l=2.52e-6 m=1
C_LVS_XC18_27 vcn bn5 cap_cmomi w=2.67e-6 l=2.52e-6 m=1
C_LVS_XC18_28 vcn bn5 cap_cmomi w=2.67e-6 l=2.52e-6 m=1
C_LVS_XC18_29 vcn bn5 cap_cmomi w=2.67e-6 l=2.52e-6 m=1
C_LVS_XC18_30 vcn bn5 cap_cmomi w=2.67e-6 l=2.52e-6 m=1
C_LVS_XC18_31 vcn bn5 cap_cmomi w=2.67e-6 l=2.52e-6 m=1
C_LVS_XC18_32 vcn bn5 cap_cmomi w=2.67e-6 l=2.52e-6 m=1
C_LVS_XC19_1 vcn bn6 cap_cmomi w=2.67e-6 l=2.52e-6 m=1
C_LVS_XC19_2 vcn bn6 cap_cmomi w=2.67e-6 l=2.52e-6 m=1
C_LVS_XC19_3 vcn bn6 cap_cmomi w=2.67e-6 l=2.52e-6 m=1
C_LVS_XC19_4 vcn bn6 cap_cmomi w=2.67e-6 l=2.52e-6 m=1
C_LVS_XC19_5 vcn bn6 cap_cmomi w=2.67e-6 l=2.52e-6 m=1
C_LVS_XC19_6 vcn bn6 cap_cmomi w=2.67e-6 l=2.52e-6 m=1
C_LVS_XC19_7 vcn bn6 cap_cmomi w=2.67e-6 l=2.52e-6 m=1
C_LVS_XC19_8 vcn bn6 cap_cmomi w=2.67e-6 l=2.52e-6 m=1
C_LVS_XC19_9 vcn bn6 cap_cmomi w=2.67e-6 l=2.52e-6 m=1
C_LVS_XC19_10 vcn bn6 cap_cmomi w=2.67e-6 l=2.52e-6 m=1
C_LVS_XC19_11 vcn bn6 cap_cmomi w=2.67e-6 l=2.52e-6 m=1
C_LVS_XC19_12 vcn bn6 cap_cmomi w=2.67e-6 l=2.52e-6 m=1
C_LVS_XC19_13 vcn bn6 cap_cmomi w=2.67e-6 l=2.52e-6 m=1
C_LVS_XC19_14 vcn bn6 cap_cmomi w=2.67e-6 l=2.52e-6 m=1
C_LVS_XC19_15 vcn bn6 cap_cmomi w=2.67e-6 l=2.52e-6 m=1
C_LVS_XC19_16 vcn bn6 cap_cmomi w=2.67e-6 l=2.52e-6 m=1
C_LVS_XC19_17 vcn bn6 cap_cmomi w=2.67e-6 l=2.52e-6 m=1
C_LVS_XC19_18 vcn bn6 cap_cmomi w=2.67e-6 l=2.52e-6 m=1
C_LVS_XC19_19 vcn bn6 cap_cmomi w=2.67e-6 l=2.52e-6 m=1
C_LVS_XC19_20 vcn bn6 cap_cmomi w=2.67e-6 l=2.52e-6 m=1
C_LVS_XC19_21 vcn bn6 cap_cmomi w=2.67e-6 l=2.52e-6 m=1
C_LVS_XC19_22 vcn bn6 cap_cmomi w=2.67e-6 l=2.52e-6 m=1
C_LVS_XC19_23 vcn bn6 cap_cmomi w=2.67e-6 l=2.52e-6 m=1
C_LVS_XC19_24 vcn bn6 cap_cmomi w=2.67e-6 l=2.52e-6 m=1
C_LVS_XC19_25 vcn bn6 cap_cmomi w=2.67e-6 l=2.52e-6 m=1
C_LVS_XC19_26 vcn bn6 cap_cmomi w=2.67e-6 l=2.52e-6 m=1
C_LVS_XC19_27 vcn bn6 cap_cmomi w=2.67e-6 l=2.52e-6 m=1
C_LVS_XC19_28 vcn bn6 cap_cmomi w=2.67e-6 l=2.52e-6 m=1
C_LVS_XC19_29 vcn bn6 cap_cmomi w=2.67e-6 l=2.52e-6 m=1
C_LVS_XC19_30 vcn bn6 cap_cmomi w=2.67e-6 l=2.52e-6 m=1
C_LVS_XC19_31 vcn bn6 cap_cmomi w=2.67e-6 l=2.52e-6 m=1
C_LVS_XC19_32 vcn bn6 cap_cmomi w=2.67e-6 l=2.52e-6 m=1
C_LVS_XC19_33 vcn bn6 cap_cmomi w=2.67e-6 l=2.52e-6 m=1
C_LVS_XC19_34 vcn bn6 cap_cmomi w=2.67e-6 l=2.52e-6 m=1
C_LVS_XC19_35 vcn bn6 cap_cmomi w=2.67e-6 l=2.52e-6 m=1
C_LVS_XC19_36 vcn bn6 cap_cmomi w=2.67e-6 l=2.52e-6 m=1
C_LVS_XC19_37 vcn bn6 cap_cmomi w=2.67e-6 l=2.52e-6 m=1
C_LVS_XC19_38 vcn bn6 cap_cmomi w=2.67e-6 l=2.52e-6 m=1
C_LVS_XC19_39 vcn bn6 cap_cmomi w=2.67e-6 l=2.52e-6 m=1
C_LVS_XC19_40 vcn bn6 cap_cmomi w=2.67e-6 l=2.52e-6 m=1
C_LVS_XC19_41 vcn bn6 cap_cmomi w=2.67e-6 l=2.52e-6 m=1
C_LVS_XC19_42 vcn bn6 cap_cmomi w=2.67e-6 l=2.52e-6 m=1
C_LVS_XC19_43 vcn bn6 cap_cmomi w=2.67e-6 l=2.52e-6 m=1
C_LVS_XC19_44 vcn bn6 cap_cmomi w=2.67e-6 l=2.52e-6 m=1
C_LVS_XC19_45 vcn bn6 cap_cmomi w=2.67e-6 l=2.52e-6 m=1
C_LVS_XC19_46 vcn bn6 cap_cmomi w=2.67e-6 l=2.52e-6 m=1
C_LVS_XC19_47 vcn bn6 cap_cmomi w=2.67e-6 l=2.52e-6 m=1
C_LVS_XC19_48 vcn bn6 cap_cmomi w=2.67e-6 l=2.52e-6 m=1
C_LVS_XC19_49 vcn bn6 cap_cmomi w=2.67e-6 l=2.52e-6 m=1
C_LVS_XC19_50 vcn bn6 cap_cmomi w=2.67e-6 l=2.52e-6 m=1
C_LVS_XC19_51 vcn bn6 cap_cmomi w=2.67e-6 l=2.52e-6 m=1
C_LVS_XC19_52 vcn bn6 cap_cmomi w=2.67e-6 l=2.52e-6 m=1
C_LVS_XC19_53 vcn bn6 cap_cmomi w=2.67e-6 l=2.52e-6 m=1
C_LVS_XC19_54 vcn bn6 cap_cmomi w=2.67e-6 l=2.52e-6 m=1
C_LVS_XC19_55 vcn bn6 cap_cmomi w=2.67e-6 l=2.52e-6 m=1
C_LVS_XC19_56 vcn bn6 cap_cmomi w=2.67e-6 l=2.52e-6 m=1
C_LVS_XC19_57 vcn bn6 cap_cmomi w=2.67e-6 l=2.52e-6 m=1
C_LVS_XC19_58 vcn bn6 cap_cmomi w=2.67e-6 l=2.52e-6 m=1
C_LVS_XC19_59 vcn bn6 cap_cmomi w=2.67e-6 l=2.52e-6 m=1
C_LVS_XC19_60 vcn bn6 cap_cmomi w=2.67e-6 l=2.52e-6 m=1
C_LVS_XC19_61 vcn bn6 cap_cmomi w=2.67e-6 l=2.52e-6 m=1
C_LVS_XC19_62 vcn bn6 cap_cmomi w=2.67e-6 l=2.52e-6 m=1
C_LVS_XC19_63 vcn bn6 cap_cmomi w=2.67e-6 l=2.52e-6 m=1
C_LVS_XC19_64 vcn bn6 cap_cmomi w=2.67e-6 l=2.52e-6 m=1
C_LVS_XC20_1 vcn bn7 cap_cmomi w=2.67e-6 l=2.52e-6 m=1
C_LVS_XC20_2 vcn bn7 cap_cmomi w=2.67e-6 l=2.52e-6 m=1
C_LVS_XC20_3 vcn bn7 cap_cmomi w=2.67e-6 l=2.52e-6 m=1
C_LVS_XC20_4 vcn bn7 cap_cmomi w=2.67e-6 l=2.52e-6 m=1
C_LVS_XC20_5 vcn bn7 cap_cmomi w=2.67e-6 l=2.52e-6 m=1
C_LVS_XC20_6 vcn bn7 cap_cmomi w=2.67e-6 l=2.52e-6 m=1
C_LVS_XC20_7 vcn bn7 cap_cmomi w=2.67e-6 l=2.52e-6 m=1
C_LVS_XC20_8 vcn bn7 cap_cmomi w=2.67e-6 l=2.52e-6 m=1
C_LVS_XC20_9 vcn bn7 cap_cmomi w=2.67e-6 l=2.52e-6 m=1
C_LVS_XC20_10 vcn bn7 cap_cmomi w=2.67e-6 l=2.52e-6 m=1
C_LVS_XC20_11 vcn bn7 cap_cmomi w=2.67e-6 l=2.52e-6 m=1
C_LVS_XC20_12 vcn bn7 cap_cmomi w=2.67e-6 l=2.52e-6 m=1
C_LVS_XC20_13 vcn bn7 cap_cmomi w=2.67e-6 l=2.52e-6 m=1
C_LVS_XC20_14 vcn bn7 cap_cmomi w=2.67e-6 l=2.52e-6 m=1
C_LVS_XC20_15 vcn bn7 cap_cmomi w=2.67e-6 l=2.52e-6 m=1
C_LVS_XC20_16 vcn bn7 cap_cmomi w=2.67e-6 l=2.52e-6 m=1
C_LVS_XC20_17 vcn bn7 cap_cmomi w=2.67e-6 l=2.52e-6 m=1
C_LVS_XC20_18 vcn bn7 cap_cmomi w=2.67e-6 l=2.52e-6 m=1
C_LVS_XC20_19 vcn bn7 cap_cmomi w=2.67e-6 l=2.52e-6 m=1
C_LVS_XC20_20 vcn bn7 cap_cmomi w=2.67e-6 l=2.52e-6 m=1
C_LVS_XC20_21 vcn bn7 cap_cmomi w=2.67e-6 l=2.52e-6 m=1
C_LVS_XC20_22 vcn bn7 cap_cmomi w=2.67e-6 l=2.52e-6 m=1
C_LVS_XC20_23 vcn bn7 cap_cmomi w=2.67e-6 l=2.52e-6 m=1
C_LVS_XC20_24 vcn bn7 cap_cmomi w=2.67e-6 l=2.52e-6 m=1
C_LVS_XC20_25 vcn bn7 cap_cmomi w=2.67e-6 l=2.52e-6 m=1
C_LVS_XC20_26 vcn bn7 cap_cmomi w=2.67e-6 l=2.52e-6 m=1
C_LVS_XC20_27 vcn bn7 cap_cmomi w=2.67e-6 l=2.52e-6 m=1
C_LVS_XC20_28 vcn bn7 cap_cmomi w=2.67e-6 l=2.52e-6 m=1
C_LVS_XC20_29 vcn bn7 cap_cmomi w=2.67e-6 l=2.52e-6 m=1
C_LVS_XC20_30 vcn bn7 cap_cmomi w=2.67e-6 l=2.52e-6 m=1
C_LVS_XC20_31 vcn bn7 cap_cmomi w=2.67e-6 l=2.52e-6 m=1
C_LVS_XC20_32 vcn bn7 cap_cmomi w=2.67e-6 l=2.52e-6 m=1
C_LVS_XC20_33 vcn bn7 cap_cmomi w=2.67e-6 l=2.52e-6 m=1
C_LVS_XC20_34 vcn bn7 cap_cmomi w=2.67e-6 l=2.52e-6 m=1
C_LVS_XC20_35 vcn bn7 cap_cmomi w=2.67e-6 l=2.52e-6 m=1
C_LVS_XC20_36 vcn bn7 cap_cmomi w=2.67e-6 l=2.52e-6 m=1
C_LVS_XC20_37 vcn bn7 cap_cmomi w=2.67e-6 l=2.52e-6 m=1
C_LVS_XC20_38 vcn bn7 cap_cmomi w=2.67e-6 l=2.52e-6 m=1
C_LVS_XC20_39 vcn bn7 cap_cmomi w=2.67e-6 l=2.52e-6 m=1
C_LVS_XC20_40 vcn bn7 cap_cmomi w=2.67e-6 l=2.52e-6 m=1
C_LVS_XC20_41 vcn bn7 cap_cmomi w=2.67e-6 l=2.52e-6 m=1
C_LVS_XC20_42 vcn bn7 cap_cmomi w=2.67e-6 l=2.52e-6 m=1
C_LVS_XC20_43 vcn bn7 cap_cmomi w=2.67e-6 l=2.52e-6 m=1
C_LVS_XC20_44 vcn bn7 cap_cmomi w=2.67e-6 l=2.52e-6 m=1
C_LVS_XC20_45 vcn bn7 cap_cmomi w=2.67e-6 l=2.52e-6 m=1
C_LVS_XC20_46 vcn bn7 cap_cmomi w=2.67e-6 l=2.52e-6 m=1
C_LVS_XC20_47 vcn bn7 cap_cmomi w=2.67e-6 l=2.52e-6 m=1
C_LVS_XC20_48 vcn bn7 cap_cmomi w=2.67e-6 l=2.52e-6 m=1
C_LVS_XC20_49 vcn bn7 cap_cmomi w=2.67e-6 l=2.52e-6 m=1
C_LVS_XC20_50 vcn bn7 cap_cmomi w=2.67e-6 l=2.52e-6 m=1
C_LVS_XC20_51 vcn bn7 cap_cmomi w=2.67e-6 l=2.52e-6 m=1
C_LVS_XC20_52 vcn bn7 cap_cmomi w=2.67e-6 l=2.52e-6 m=1
C_LVS_XC20_53 vcn bn7 cap_cmomi w=2.67e-6 l=2.52e-6 m=1
C_LVS_XC20_54 vcn bn7 cap_cmomi w=2.67e-6 l=2.52e-6 m=1
C_LVS_XC20_55 vcn bn7 cap_cmomi w=2.67e-6 l=2.52e-6 m=1
C_LVS_XC20_56 vcn bn7 cap_cmomi w=2.67e-6 l=2.52e-6 m=1
C_LVS_XC20_57 vcn bn7 cap_cmomi w=2.67e-6 l=2.52e-6 m=1
C_LVS_XC20_58 vcn bn7 cap_cmomi w=2.67e-6 l=2.52e-6 m=1
C_LVS_XC20_59 vcn bn7 cap_cmomi w=2.67e-6 l=2.52e-6 m=1
C_LVS_XC20_60 vcn bn7 cap_cmomi w=2.67e-6 l=2.52e-6 m=1
C_LVS_XC20_61 vcn bn7 cap_cmomi w=2.67e-6 l=2.52e-6 m=1
C_LVS_XC20_62 vcn bn7 cap_cmomi w=2.67e-6 l=2.52e-6 m=1
C_LVS_XC20_63 vcn bn7 cap_cmomi w=2.67e-6 l=2.52e-6 m=1
C_LVS_XC20_64 vcn bn7 cap_cmomi w=2.67e-6 l=2.52e-6 m=1
C_LVS_XC20_65 vcn bn7 cap_cmomi w=2.67e-6 l=2.52e-6 m=1
C_LVS_XC20_66 vcn bn7 cap_cmomi w=2.67e-6 l=2.52e-6 m=1
C_LVS_XC20_67 vcn bn7 cap_cmomi w=2.67e-6 l=2.52e-6 m=1
C_LVS_XC20_68 vcn bn7 cap_cmomi w=2.67e-6 l=2.52e-6 m=1
C_LVS_XC20_69 vcn bn7 cap_cmomi w=2.67e-6 l=2.52e-6 m=1
C_LVS_XC20_70 vcn bn7 cap_cmomi w=2.67e-6 l=2.52e-6 m=1
C_LVS_XC20_71 vcn bn7 cap_cmomi w=2.67e-6 l=2.52e-6 m=1
C_LVS_XC20_72 vcn bn7 cap_cmomi w=2.67e-6 l=2.52e-6 m=1
C_LVS_XC20_73 vcn bn7 cap_cmomi w=2.67e-6 l=2.52e-6 m=1
C_LVS_XC20_74 vcn bn7 cap_cmomi w=2.67e-6 l=2.52e-6 m=1
C_LVS_XC20_75 vcn bn7 cap_cmomi w=2.67e-6 l=2.52e-6 m=1
C_LVS_XC20_76 vcn bn7 cap_cmomi w=2.67e-6 l=2.52e-6 m=1
C_LVS_XC20_77 vcn bn7 cap_cmomi w=2.67e-6 l=2.52e-6 m=1
C_LVS_XC20_78 vcn bn7 cap_cmomi w=2.67e-6 l=2.52e-6 m=1
C_LVS_XC20_79 vcn bn7 cap_cmomi w=2.67e-6 l=2.52e-6 m=1
C_LVS_XC20_80 vcn bn7 cap_cmomi w=2.67e-6 l=2.52e-6 m=1
C_LVS_XC20_81 vcn bn7 cap_cmomi w=2.67e-6 l=2.52e-6 m=1
C_LVS_XC20_82 vcn bn7 cap_cmomi w=2.67e-6 l=2.52e-6 m=1
C_LVS_XC20_83 vcn bn7 cap_cmomi w=2.67e-6 l=2.52e-6 m=1
C_LVS_XC20_84 vcn bn7 cap_cmomi w=2.67e-6 l=2.52e-6 m=1
C_LVS_XC20_85 vcn bn7 cap_cmomi w=2.67e-6 l=2.52e-6 m=1
C_LVS_XC20_86 vcn bn7 cap_cmomi w=2.67e-6 l=2.52e-6 m=1
C_LVS_XC20_87 vcn bn7 cap_cmomi w=2.67e-6 l=2.52e-6 m=1
C_LVS_XC20_88 vcn bn7 cap_cmomi w=2.67e-6 l=2.52e-6 m=1
C_LVS_XC20_89 vcn bn7 cap_cmomi w=2.67e-6 l=2.52e-6 m=1
C_LVS_XC20_90 vcn bn7 cap_cmomi w=2.67e-6 l=2.52e-6 m=1
C_LVS_XC20_91 vcn bn7 cap_cmomi w=2.67e-6 l=2.52e-6 m=1
C_LVS_XC20_92 vcn bn7 cap_cmomi w=2.67e-6 l=2.52e-6 m=1
C_LVS_XC20_93 vcn bn7 cap_cmomi w=2.67e-6 l=2.52e-6 m=1
C_LVS_XC20_94 vcn bn7 cap_cmomi w=2.67e-6 l=2.52e-6 m=1
C_LVS_XC20_95 vcn bn7 cap_cmomi w=2.67e-6 l=2.52e-6 m=1
C_LVS_XC20_96 vcn bn7 cap_cmomi w=2.67e-6 l=2.52e-6 m=1
C_LVS_XC20_97 vcn bn7 cap_cmomi w=2.67e-6 l=2.52e-6 m=1
C_LVS_XC20_98 vcn bn7 cap_cmomi w=2.67e-6 l=2.52e-6 m=1
C_LVS_XC20_99 vcn bn7 cap_cmomi w=2.67e-6 l=2.52e-6 m=1
C_LVS_XC20_100 vcn bn7 cap_cmomi w=2.67e-6 l=2.52e-6 m=1
C_LVS_XC20_101 vcn bn7 cap_cmomi w=2.67e-6 l=2.52e-6 m=1
C_LVS_XC20_102 vcn bn7 cap_cmomi w=2.67e-6 l=2.52e-6 m=1
C_LVS_XC20_103 vcn bn7 cap_cmomi w=2.67e-6 l=2.52e-6 m=1
C_LVS_XC20_104 vcn bn7 cap_cmomi w=2.67e-6 l=2.52e-6 m=1
C_LVS_XC20_105 vcn bn7 cap_cmomi w=2.67e-6 l=2.52e-6 m=1
C_LVS_XC20_106 vcn bn7 cap_cmomi w=2.67e-6 l=2.52e-6 m=1
C_LVS_XC20_107 vcn bn7 cap_cmomi w=2.67e-6 l=2.52e-6 m=1
C_LVS_XC20_108 vcn bn7 cap_cmomi w=2.67e-6 l=2.52e-6 m=1
C_LVS_XC20_109 vcn bn7 cap_cmomi w=2.67e-6 l=2.52e-6 m=1
C_LVS_XC20_110 vcn bn7 cap_cmomi w=2.67e-6 l=2.52e-6 m=1
C_LVS_XC20_111 vcn bn7 cap_cmomi w=2.67e-6 l=2.52e-6 m=1
C_LVS_XC20_112 vcn bn7 cap_cmomi w=2.67e-6 l=2.52e-6 m=1
C_LVS_XC20_113 vcn bn7 cap_cmomi w=2.67e-6 l=2.52e-6 m=1
C_LVS_XC20_114 vcn bn7 cap_cmomi w=2.67e-6 l=2.52e-6 m=1
C_LVS_XC20_115 vcn bn7 cap_cmomi w=2.67e-6 l=2.52e-6 m=1
C_LVS_XC20_116 vcn bn7 cap_cmomi w=2.67e-6 l=2.52e-6 m=1
C_LVS_XC20_117 vcn bn7 cap_cmomi w=2.67e-6 l=2.52e-6 m=1
C_LVS_XC20_118 vcn bn7 cap_cmomi w=2.67e-6 l=2.52e-6 m=1
C_LVS_XC20_119 vcn bn7 cap_cmomi w=2.67e-6 l=2.52e-6 m=1
C_LVS_XC20_120 vcn bn7 cap_cmomi w=2.67e-6 l=2.52e-6 m=1
C_LVS_XC20_121 vcn bn7 cap_cmomi w=2.67e-6 l=2.52e-6 m=1
C_LVS_XC20_122 vcn bn7 cap_cmomi w=2.67e-6 l=2.52e-6 m=1
C_LVS_XC20_123 vcn bn7 cap_cmomi w=2.67e-6 l=2.52e-6 m=1
C_LVS_XC20_124 vcn bn7 cap_cmomi w=2.67e-6 l=2.52e-6 m=1
C_LVS_XC20_125 vcn bn7 cap_cmomi w=2.67e-6 l=2.52e-6 m=1
C_LVS_XC20_126 vcn bn7 cap_cmomi w=2.67e-6 l=2.52e-6 m=1
C_LVS_XC20_127 vcn bn7 cap_cmomi w=2.67e-6 l=2.52e-6 m=1
C_LVS_XC20_128 vcn bn7 cap_cmomi w=2.67e-6 l=2.52e-6 m=1
C_LVS_XC21_1 vcn bn8 cap_cmomi w=2.67e-6 l=2.52e-6 m=1
C_LVS_XC21_2 vcn bn8 cap_cmomi w=2.67e-6 l=2.52e-6 m=1
C_LVS_XC21_3 vcn bn8 cap_cmomi w=2.67e-6 l=2.52e-6 m=1
C_LVS_XC21_4 vcn bn8 cap_cmomi w=2.67e-6 l=2.52e-6 m=1
C_LVS_XC21_5 vcn bn8 cap_cmomi w=2.67e-6 l=2.52e-6 m=1
C_LVS_XC21_6 vcn bn8 cap_cmomi w=2.67e-6 l=2.52e-6 m=1
C_LVS_XC21_7 vcn bn8 cap_cmomi w=2.67e-6 l=2.52e-6 m=1
C_LVS_XC21_8 vcn bn8 cap_cmomi w=2.67e-6 l=2.52e-6 m=1
C_LVS_XC21_9 vcn bn8 cap_cmomi w=2.67e-6 l=2.52e-6 m=1
C_LVS_XC21_10 vcn bn8 cap_cmomi w=2.67e-6 l=2.52e-6 m=1
C_LVS_XC21_11 vcn bn8 cap_cmomi w=2.67e-6 l=2.52e-6 m=1
C_LVS_XC21_12 vcn bn8 cap_cmomi w=2.67e-6 l=2.52e-6 m=1
C_LVS_XC21_13 vcn bn8 cap_cmomi w=2.67e-6 l=2.52e-6 m=1
C_LVS_XC21_14 vcn bn8 cap_cmomi w=2.67e-6 l=2.52e-6 m=1
C_LVS_XC21_15 vcn bn8 cap_cmomi w=2.67e-6 l=2.52e-6 m=1
C_LVS_XC21_16 vcn bn8 cap_cmomi w=2.67e-6 l=2.52e-6 m=1
C_LVS_XC21_17 vcn bn8 cap_cmomi w=2.67e-6 l=2.52e-6 m=1
C_LVS_XC21_18 vcn bn8 cap_cmomi w=2.67e-6 l=2.52e-6 m=1
C_LVS_XC21_19 vcn bn8 cap_cmomi w=2.67e-6 l=2.52e-6 m=1
C_LVS_XC21_20 vcn bn8 cap_cmomi w=2.67e-6 l=2.52e-6 m=1
C_LVS_XC21_21 vcn bn8 cap_cmomi w=2.67e-6 l=2.52e-6 m=1
C_LVS_XC21_22 vcn bn8 cap_cmomi w=2.67e-6 l=2.52e-6 m=1
C_LVS_XC21_23 vcn bn8 cap_cmomi w=2.67e-6 l=2.52e-6 m=1
C_LVS_XC21_24 vcn bn8 cap_cmomi w=2.67e-6 l=2.52e-6 m=1
C_LVS_XC21_25 vcn bn8 cap_cmomi w=2.67e-6 l=2.52e-6 m=1
C_LVS_XC21_26 vcn bn8 cap_cmomi w=2.67e-6 l=2.52e-6 m=1
C_LVS_XC21_27 vcn bn8 cap_cmomi w=2.67e-6 l=2.52e-6 m=1
C_LVS_XC21_28 vcn bn8 cap_cmomi w=2.67e-6 l=2.52e-6 m=1
C_LVS_XC21_29 vcn bn8 cap_cmomi w=2.67e-6 l=2.52e-6 m=1
C_LVS_XC21_30 vcn bn8 cap_cmomi w=2.67e-6 l=2.52e-6 m=1
C_LVS_XC21_31 vcn bn8 cap_cmomi w=2.67e-6 l=2.52e-6 m=1
C_LVS_XC21_32 vcn bn8 cap_cmomi w=2.67e-6 l=2.52e-6 m=1
C_LVS_XC21_33 vcn bn8 cap_cmomi w=2.67e-6 l=2.52e-6 m=1
C_LVS_XC21_34 vcn bn8 cap_cmomi w=2.67e-6 l=2.52e-6 m=1
C_LVS_XC21_35 vcn bn8 cap_cmomi w=2.67e-6 l=2.52e-6 m=1
C_LVS_XC21_36 vcn bn8 cap_cmomi w=2.67e-6 l=2.52e-6 m=1
C_LVS_XC21_37 vcn bn8 cap_cmomi w=2.67e-6 l=2.52e-6 m=1
C_LVS_XC21_38 vcn bn8 cap_cmomi w=2.67e-6 l=2.52e-6 m=1
C_LVS_XC21_39 vcn bn8 cap_cmomi w=2.67e-6 l=2.52e-6 m=1
C_LVS_XC21_40 vcn bn8 cap_cmomi w=2.67e-6 l=2.52e-6 m=1
C_LVS_XC21_41 vcn bn8 cap_cmomi w=2.67e-6 l=2.52e-6 m=1
C_LVS_XC21_42 vcn bn8 cap_cmomi w=2.67e-6 l=2.52e-6 m=1
C_LVS_XC21_43 vcn bn8 cap_cmomi w=2.67e-6 l=2.52e-6 m=1
C_LVS_XC21_44 vcn bn8 cap_cmomi w=2.67e-6 l=2.52e-6 m=1
C_LVS_XC21_45 vcn bn8 cap_cmomi w=2.67e-6 l=2.52e-6 m=1
C_LVS_XC21_46 vcn bn8 cap_cmomi w=2.67e-6 l=2.52e-6 m=1
C_LVS_XC21_47 vcn bn8 cap_cmomi w=2.67e-6 l=2.52e-6 m=1
C_LVS_XC21_48 vcn bn8 cap_cmomi w=2.67e-6 l=2.52e-6 m=1
C_LVS_XC21_49 vcn bn8 cap_cmomi w=2.67e-6 l=2.52e-6 m=1
C_LVS_XC21_50 vcn bn8 cap_cmomi w=2.67e-6 l=2.52e-6 m=1
C_LVS_XC21_51 vcn bn8 cap_cmomi w=2.67e-6 l=2.52e-6 m=1
C_LVS_XC21_52 vcn bn8 cap_cmomi w=2.67e-6 l=2.52e-6 m=1
C_LVS_XC21_53 vcn bn8 cap_cmomi w=2.67e-6 l=2.52e-6 m=1
C_LVS_XC21_54 vcn bn8 cap_cmomi w=2.67e-6 l=2.52e-6 m=1
C_LVS_XC21_55 vcn bn8 cap_cmomi w=2.67e-6 l=2.52e-6 m=1
C_LVS_XC21_56 vcn bn8 cap_cmomi w=2.67e-6 l=2.52e-6 m=1
C_LVS_XC21_57 vcn bn8 cap_cmomi w=2.67e-6 l=2.52e-6 m=1
C_LVS_XC21_58 vcn bn8 cap_cmomi w=2.67e-6 l=2.52e-6 m=1
C_LVS_XC21_59 vcn bn8 cap_cmomi w=2.67e-6 l=2.52e-6 m=1
C_LVS_XC21_60 vcn bn8 cap_cmomi w=2.67e-6 l=2.52e-6 m=1
C_LVS_XC21_61 vcn bn8 cap_cmomi w=2.67e-6 l=2.52e-6 m=1
C_LVS_XC21_62 vcn bn8 cap_cmomi w=2.67e-6 l=2.52e-6 m=1
C_LVS_XC21_63 vcn bn8 cap_cmomi w=2.67e-6 l=2.52e-6 m=1
C_LVS_XC21_64 vcn bn8 cap_cmomi w=2.67e-6 l=2.52e-6 m=1
C_LVS_XC21_65 vcn bn8 cap_cmomi w=2.67e-6 l=2.52e-6 m=1
C_LVS_XC21_66 vcn bn8 cap_cmomi w=2.67e-6 l=2.52e-6 m=1
C_LVS_XC21_67 vcn bn8 cap_cmomi w=2.67e-6 l=2.52e-6 m=1
C_LVS_XC21_68 vcn bn8 cap_cmomi w=2.67e-6 l=2.52e-6 m=1
C_LVS_XC21_69 vcn bn8 cap_cmomi w=2.67e-6 l=2.52e-6 m=1
C_LVS_XC21_70 vcn bn8 cap_cmomi w=2.67e-6 l=2.52e-6 m=1
C_LVS_XC21_71 vcn bn8 cap_cmomi w=2.67e-6 l=2.52e-6 m=1
C_LVS_XC21_72 vcn bn8 cap_cmomi w=2.67e-6 l=2.52e-6 m=1
C_LVS_XC21_73 vcn bn8 cap_cmomi w=2.67e-6 l=2.52e-6 m=1
C_LVS_XC21_74 vcn bn8 cap_cmomi w=2.67e-6 l=2.52e-6 m=1
C_LVS_XC21_75 vcn bn8 cap_cmomi w=2.67e-6 l=2.52e-6 m=1
C_LVS_XC21_76 vcn bn8 cap_cmomi w=2.67e-6 l=2.52e-6 m=1
C_LVS_XC21_77 vcn bn8 cap_cmomi w=2.67e-6 l=2.52e-6 m=1
C_LVS_XC21_78 vcn bn8 cap_cmomi w=2.67e-6 l=2.52e-6 m=1
C_LVS_XC21_79 vcn bn8 cap_cmomi w=2.67e-6 l=2.52e-6 m=1
C_LVS_XC21_80 vcn bn8 cap_cmomi w=2.67e-6 l=2.52e-6 m=1
C_LVS_XC21_81 vcn bn8 cap_cmomi w=2.67e-6 l=2.52e-6 m=1
C_LVS_XC21_82 vcn bn8 cap_cmomi w=2.67e-6 l=2.52e-6 m=1
C_LVS_XC21_83 vcn bn8 cap_cmomi w=2.67e-6 l=2.52e-6 m=1
C_LVS_XC21_84 vcn bn8 cap_cmomi w=2.67e-6 l=2.52e-6 m=1
C_LVS_XC21_85 vcn bn8 cap_cmomi w=2.67e-6 l=2.52e-6 m=1
C_LVS_XC21_86 vcn bn8 cap_cmomi w=2.67e-6 l=2.52e-6 m=1
C_LVS_XC21_87 vcn bn8 cap_cmomi w=2.67e-6 l=2.52e-6 m=1
C_LVS_XC21_88 vcn bn8 cap_cmomi w=2.67e-6 l=2.52e-6 m=1
C_LVS_XC21_89 vcn bn8 cap_cmomi w=2.67e-6 l=2.52e-6 m=1
C_LVS_XC21_90 vcn bn8 cap_cmomi w=2.67e-6 l=2.52e-6 m=1
C_LVS_XC21_91 vcn bn8 cap_cmomi w=2.67e-6 l=2.52e-6 m=1
C_LVS_XC21_92 vcn bn8 cap_cmomi w=2.67e-6 l=2.52e-6 m=1
C_LVS_XC21_93 vcn bn8 cap_cmomi w=2.67e-6 l=2.52e-6 m=1
C_LVS_XC21_94 vcn bn8 cap_cmomi w=2.67e-6 l=2.52e-6 m=1
C_LVS_XC21_95 vcn bn8 cap_cmomi w=2.67e-6 l=2.52e-6 m=1
C_LVS_XC21_96 vcn bn8 cap_cmomi w=2.67e-6 l=2.52e-6 m=1
C_LVS_XC21_97 vcn bn8 cap_cmomi w=2.67e-6 l=2.52e-6 m=1
C_LVS_XC21_98 vcn bn8 cap_cmomi w=2.67e-6 l=2.52e-6 m=1
C_LVS_XC21_99 vcn bn8 cap_cmomi w=2.67e-6 l=2.52e-6 m=1
C_LVS_XC21_100 vcn bn8 cap_cmomi w=2.67e-6 l=2.52e-6 m=1
C_LVS_XC21_101 vcn bn8 cap_cmomi w=2.67e-6 l=2.52e-6 m=1
C_LVS_XC21_102 vcn bn8 cap_cmomi w=2.67e-6 l=2.52e-6 m=1
C_LVS_XC21_103 vcn bn8 cap_cmomi w=2.67e-6 l=2.52e-6 m=1
C_LVS_XC21_104 vcn bn8 cap_cmomi w=2.67e-6 l=2.52e-6 m=1
C_LVS_XC21_105 vcn bn8 cap_cmomi w=2.67e-6 l=2.52e-6 m=1
C_LVS_XC21_106 vcn bn8 cap_cmomi w=2.67e-6 l=2.52e-6 m=1
C_LVS_XC21_107 vcn bn8 cap_cmomi w=2.67e-6 l=2.52e-6 m=1
C_LVS_XC21_108 vcn bn8 cap_cmomi w=2.67e-6 l=2.52e-6 m=1
C_LVS_XC21_109 vcn bn8 cap_cmomi w=2.67e-6 l=2.52e-6 m=1
C_LVS_XC21_110 vcn bn8 cap_cmomi w=2.67e-6 l=2.52e-6 m=1
C_LVS_XC21_111 vcn bn8 cap_cmomi w=2.67e-6 l=2.52e-6 m=1
C_LVS_XC21_112 vcn bn8 cap_cmomi w=2.67e-6 l=2.52e-6 m=1
C_LVS_XC21_113 vcn bn8 cap_cmomi w=2.67e-6 l=2.52e-6 m=1
C_LVS_XC21_114 vcn bn8 cap_cmomi w=2.67e-6 l=2.52e-6 m=1
C_LVS_XC21_115 vcn bn8 cap_cmomi w=2.67e-6 l=2.52e-6 m=1
C_LVS_XC21_116 vcn bn8 cap_cmomi w=2.67e-6 l=2.52e-6 m=1
C_LVS_XC21_117 vcn bn8 cap_cmomi w=2.67e-6 l=2.52e-6 m=1
C_LVS_XC21_118 vcn bn8 cap_cmomi w=2.67e-6 l=2.52e-6 m=1
C_LVS_XC21_119 vcn bn8 cap_cmomi w=2.67e-6 l=2.52e-6 m=1
C_LVS_XC21_120 vcn bn8 cap_cmomi w=2.67e-6 l=2.52e-6 m=1
C_LVS_XC21_121 vcn bn8 cap_cmomi w=2.67e-6 l=2.52e-6 m=1
C_LVS_XC21_122 vcn bn8 cap_cmomi w=2.67e-6 l=2.52e-6 m=1
C_LVS_XC21_123 vcn bn8 cap_cmomi w=2.67e-6 l=2.52e-6 m=1
C_LVS_XC21_124 vcn bn8 cap_cmomi w=2.67e-6 l=2.52e-6 m=1
C_LVS_XC21_125 vcn bn8 cap_cmomi w=2.67e-6 l=2.52e-6 m=1
C_LVS_XC21_126 vcn bn8 cap_cmomi w=2.67e-6 l=2.52e-6 m=1
C_LVS_XC21_127 vcn bn8 cap_cmomi w=2.67e-6 l=2.52e-6 m=1
C_LVS_XC21_128 vcn bn8 cap_cmomi w=2.67e-6 l=2.52e-6 m=1
C_LVS_XC21_129 vcn bn8 cap_cmomi w=2.67e-6 l=2.52e-6 m=1
C_LVS_XC21_130 vcn bn8 cap_cmomi w=2.67e-6 l=2.52e-6 m=1
C_LVS_XC21_131 vcn bn8 cap_cmomi w=2.67e-6 l=2.52e-6 m=1
C_LVS_XC21_132 vcn bn8 cap_cmomi w=2.67e-6 l=2.52e-6 m=1
C_LVS_XC21_133 vcn bn8 cap_cmomi w=2.67e-6 l=2.52e-6 m=1
C_LVS_XC21_134 vcn bn8 cap_cmomi w=2.67e-6 l=2.52e-6 m=1
C_LVS_XC21_135 vcn bn8 cap_cmomi w=2.67e-6 l=2.52e-6 m=1
C_LVS_XC21_136 vcn bn8 cap_cmomi w=2.67e-6 l=2.52e-6 m=1
C_LVS_XC21_137 vcn bn8 cap_cmomi w=2.67e-6 l=2.52e-6 m=1
C_LVS_XC21_138 vcn bn8 cap_cmomi w=2.67e-6 l=2.52e-6 m=1
C_LVS_XC21_139 vcn bn8 cap_cmomi w=2.67e-6 l=2.52e-6 m=1
C_LVS_XC21_140 vcn bn8 cap_cmomi w=2.67e-6 l=2.52e-6 m=1
C_LVS_XC21_141 vcn bn8 cap_cmomi w=2.67e-6 l=2.52e-6 m=1
C_LVS_XC21_142 vcn bn8 cap_cmomi w=2.67e-6 l=2.52e-6 m=1
C_LVS_XC21_143 vcn bn8 cap_cmomi w=2.67e-6 l=2.52e-6 m=1
C_LVS_XC21_144 vcn bn8 cap_cmomi w=2.67e-6 l=2.52e-6 m=1
C_LVS_XC21_145 vcn bn8 cap_cmomi w=2.67e-6 l=2.52e-6 m=1
C_LVS_XC21_146 vcn bn8 cap_cmomi w=2.67e-6 l=2.52e-6 m=1
C_LVS_XC21_147 vcn bn8 cap_cmomi w=2.67e-6 l=2.52e-6 m=1
C_LVS_XC21_148 vcn bn8 cap_cmomi w=2.67e-6 l=2.52e-6 m=1
C_LVS_XC21_149 vcn bn8 cap_cmomi w=2.67e-6 l=2.52e-6 m=1
C_LVS_XC21_150 vcn bn8 cap_cmomi w=2.67e-6 l=2.52e-6 m=1
C_LVS_XC21_151 vcn bn8 cap_cmomi w=2.67e-6 l=2.52e-6 m=1
C_LVS_XC21_152 vcn bn8 cap_cmomi w=2.67e-6 l=2.52e-6 m=1
C_LVS_XC21_153 vcn bn8 cap_cmomi w=2.67e-6 l=2.52e-6 m=1
C_LVS_XC21_154 vcn bn8 cap_cmomi w=2.67e-6 l=2.52e-6 m=1
C_LVS_XC21_155 vcn bn8 cap_cmomi w=2.67e-6 l=2.52e-6 m=1
C_LVS_XC21_156 vcn bn8 cap_cmomi w=2.67e-6 l=2.52e-6 m=1
C_LVS_XC21_157 vcn bn8 cap_cmomi w=2.67e-6 l=2.52e-6 m=1
C_LVS_XC21_158 vcn bn8 cap_cmomi w=2.67e-6 l=2.52e-6 m=1
C_LVS_XC21_159 vcn bn8 cap_cmomi w=2.67e-6 l=2.52e-6 m=1
C_LVS_XC21_160 vcn bn8 cap_cmomi w=2.67e-6 l=2.52e-6 m=1
C_LVS_XC21_161 vcn bn8 cap_cmomi w=2.67e-6 l=2.52e-6 m=1
C_LVS_XC21_162 vcn bn8 cap_cmomi w=2.67e-6 l=2.52e-6 m=1
C_LVS_XC21_163 vcn bn8 cap_cmomi w=2.67e-6 l=2.52e-6 m=1
C_LVS_XC21_164 vcn bn8 cap_cmomi w=2.67e-6 l=2.52e-6 m=1
C_LVS_XC21_165 vcn bn8 cap_cmomi w=2.67e-6 l=2.52e-6 m=1
C_LVS_XC21_166 vcn bn8 cap_cmomi w=2.67e-6 l=2.52e-6 m=1
C_LVS_XC21_167 vcn bn8 cap_cmomi w=2.67e-6 l=2.52e-6 m=1
C_LVS_XC21_168 vcn bn8 cap_cmomi w=2.67e-6 l=2.52e-6 m=1
C_LVS_XC21_169 vcn bn8 cap_cmomi w=2.67e-6 l=2.52e-6 m=1
C_LVS_XC21_170 vcn bn8 cap_cmomi w=2.67e-6 l=2.52e-6 m=1
C_LVS_XC21_171 vcn bn8 cap_cmomi w=2.67e-6 l=2.52e-6 m=1
C_LVS_XC21_172 vcn bn8 cap_cmomi w=2.67e-6 l=2.52e-6 m=1
C_LVS_XC21_173 vcn bn8 cap_cmomi w=2.67e-6 l=2.52e-6 m=1
C_LVS_XC21_174 vcn bn8 cap_cmomi w=2.67e-6 l=2.52e-6 m=1
C_LVS_XC21_175 vcn bn8 cap_cmomi w=2.67e-6 l=2.52e-6 m=1
C_LVS_XC21_176 vcn bn8 cap_cmomi w=2.67e-6 l=2.52e-6 m=1
C_LVS_XC21_177 vcn bn8 cap_cmomi w=2.67e-6 l=2.52e-6 m=1
C_LVS_XC21_178 vcn bn8 cap_cmomi w=2.67e-6 l=2.52e-6 m=1
C_LVS_XC21_179 vcn bn8 cap_cmomi w=2.67e-6 l=2.52e-6 m=1
C_LVS_XC21_180 vcn bn8 cap_cmomi w=2.67e-6 l=2.52e-6 m=1
C_LVS_XC21_181 vcn bn8 cap_cmomi w=2.67e-6 l=2.52e-6 m=1
C_LVS_XC21_182 vcn bn8 cap_cmomi w=2.67e-6 l=2.52e-6 m=1
C_LVS_XC21_183 vcn bn8 cap_cmomi w=2.67e-6 l=2.52e-6 m=1
C_LVS_XC21_184 vcn bn8 cap_cmomi w=2.67e-6 l=2.52e-6 m=1
C_LVS_XC21_185 vcn bn8 cap_cmomi w=2.67e-6 l=2.52e-6 m=1
C_LVS_XC21_186 vcn bn8 cap_cmomi w=2.67e-6 l=2.52e-6 m=1
C_LVS_XC21_187 vcn bn8 cap_cmomi w=2.67e-6 l=2.52e-6 m=1
C_LVS_XC21_188 vcn bn8 cap_cmomi w=2.67e-6 l=2.52e-6 m=1
C_LVS_XC21_189 vcn bn8 cap_cmomi w=2.67e-6 l=2.52e-6 m=1
C_LVS_XC21_190 vcn bn8 cap_cmomi w=2.67e-6 l=2.52e-6 m=1
C_LVS_XC21_191 vcn bn8 cap_cmomi w=2.67e-6 l=2.52e-6 m=1
C_LVS_XC21_192 vcn bn8 cap_cmomi w=2.67e-6 l=2.52e-6 m=1
C_LVS_XC21_193 vcn bn8 cap_cmomi w=2.67e-6 l=2.52e-6 m=1
C_LVS_XC21_194 vcn bn8 cap_cmomi w=2.67e-6 l=2.52e-6 m=1
C_LVS_XC21_195 vcn bn8 cap_cmomi w=2.67e-6 l=2.52e-6 m=1
C_LVS_XC21_196 vcn bn8 cap_cmomi w=2.67e-6 l=2.52e-6 m=1
C_LVS_XC21_197 vcn bn8 cap_cmomi w=2.67e-6 l=2.52e-6 m=1
C_LVS_XC21_198 vcn bn8 cap_cmomi w=2.67e-6 l=2.52e-6 m=1
C_LVS_XC21_199 vcn bn8 cap_cmomi w=2.67e-6 l=2.52e-6 m=1
C_LVS_XC21_200 vcn bn8 cap_cmomi w=2.67e-6 l=2.52e-6 m=1
C_LVS_XC21_201 vcn bn8 cap_cmomi w=2.67e-6 l=2.52e-6 m=1
C_LVS_XC21_202 vcn bn8 cap_cmomi w=2.67e-6 l=2.52e-6 m=1
C_LVS_XC21_203 vcn bn8 cap_cmomi w=2.67e-6 l=2.52e-6 m=1
C_LVS_XC21_204 vcn bn8 cap_cmomi w=2.67e-6 l=2.52e-6 m=1
C_LVS_XC21_205 vcn bn8 cap_cmomi w=2.67e-6 l=2.52e-6 m=1
C_LVS_XC21_206 vcn bn8 cap_cmomi w=2.67e-6 l=2.52e-6 m=1
C_LVS_XC21_207 vcn bn8 cap_cmomi w=2.67e-6 l=2.52e-6 m=1
C_LVS_XC21_208 vcn bn8 cap_cmomi w=2.67e-6 l=2.52e-6 m=1
C_LVS_XC21_209 vcn bn8 cap_cmomi w=2.67e-6 l=2.52e-6 m=1
C_LVS_XC21_210 vcn bn8 cap_cmomi w=2.67e-6 l=2.52e-6 m=1
C_LVS_XC21_211 vcn bn8 cap_cmomi w=2.67e-6 l=2.52e-6 m=1
C_LVS_XC21_212 vcn bn8 cap_cmomi w=2.67e-6 l=2.52e-6 m=1
C_LVS_XC21_213 vcn bn8 cap_cmomi w=2.67e-6 l=2.52e-6 m=1
C_LVS_XC21_214 vcn bn8 cap_cmomi w=2.67e-6 l=2.52e-6 m=1
C_LVS_XC21_215 vcn bn8 cap_cmomi w=2.67e-6 l=2.52e-6 m=1
C_LVS_XC21_216 vcn bn8 cap_cmomi w=2.67e-6 l=2.52e-6 m=1
C_LVS_XC21_217 vcn bn8 cap_cmomi w=2.67e-6 l=2.52e-6 m=1
C_LVS_XC21_218 vcn bn8 cap_cmomi w=2.67e-6 l=2.52e-6 m=1
C_LVS_XC21_219 vcn bn8 cap_cmomi w=2.67e-6 l=2.52e-6 m=1
C_LVS_XC21_220 vcn bn8 cap_cmomi w=2.67e-6 l=2.52e-6 m=1
C_LVS_XC21_221 vcn bn8 cap_cmomi w=2.67e-6 l=2.52e-6 m=1
C_LVS_XC21_222 vcn bn8 cap_cmomi w=2.67e-6 l=2.52e-6 m=1
C_LVS_XC21_223 vcn bn8 cap_cmomi w=2.67e-6 l=2.52e-6 m=1
C_LVS_XC21_224 vcn bn8 cap_cmomi w=2.67e-6 l=2.52e-6 m=1
C_LVS_XC21_225 vcn bn8 cap_cmomi w=2.67e-6 l=2.52e-6 m=1
C_LVS_XC21_226 vcn bn8 cap_cmomi w=2.67e-6 l=2.52e-6 m=1
C_LVS_XC21_227 vcn bn8 cap_cmomi w=2.67e-6 l=2.52e-6 m=1
C_LVS_XC21_228 vcn bn8 cap_cmomi w=2.67e-6 l=2.52e-6 m=1
C_LVS_XC21_229 vcn bn8 cap_cmomi w=2.67e-6 l=2.52e-6 m=1
C_LVS_XC21_230 vcn bn8 cap_cmomi w=2.67e-6 l=2.52e-6 m=1
C_LVS_XC21_231 vcn bn8 cap_cmomi w=2.67e-6 l=2.52e-6 m=1
C_LVS_XC21_232 vcn bn8 cap_cmomi w=2.67e-6 l=2.52e-6 m=1
C_LVS_XC21_233 vcn bn8 cap_cmomi w=2.67e-6 l=2.52e-6 m=1
C_LVS_XC21_234 vcn bn8 cap_cmomi w=2.67e-6 l=2.52e-6 m=1
C_LVS_XC21_235 vcn bn8 cap_cmomi w=2.67e-6 l=2.52e-6 m=1
C_LVS_XC21_236 vcn bn8 cap_cmomi w=2.67e-6 l=2.52e-6 m=1
C_LVS_XC21_237 vcn bn8 cap_cmomi w=2.67e-6 l=2.52e-6 m=1
C_LVS_XC21_238 vcn bn8 cap_cmomi w=2.67e-6 l=2.52e-6 m=1
C_LVS_XC21_239 vcn bn8 cap_cmomi w=2.67e-6 l=2.52e-6 m=1
C_LVS_XC21_240 vcn bn8 cap_cmomi w=2.67e-6 l=2.52e-6 m=1
C_LVS_XC21_241 vcn bn8 cap_cmomi w=2.67e-6 l=2.52e-6 m=1
C_LVS_XC21_242 vcn bn8 cap_cmomi w=2.67e-6 l=2.52e-6 m=1
C_LVS_XC21_243 vcn bn8 cap_cmomi w=2.67e-6 l=2.52e-6 m=1
C_LVS_XC21_244 vcn bn8 cap_cmomi w=2.67e-6 l=2.52e-6 m=1
C_LVS_XC21_245 vcn bn8 cap_cmomi w=2.67e-6 l=2.52e-6 m=1
C_LVS_XC21_246 vcn bn8 cap_cmomi w=2.67e-6 l=2.52e-6 m=1
C_LVS_XC21_247 vcn bn8 cap_cmomi w=2.67e-6 l=2.52e-6 m=1
C_LVS_XC21_248 vcn bn8 cap_cmomi w=2.67e-6 l=2.52e-6 m=1
C_LVS_XC21_249 vcn bn8 cap_cmomi w=2.67e-6 l=2.52e-6 m=1
C_LVS_XC21_250 vcn bn8 cap_cmomi w=2.67e-6 l=2.52e-6 m=1
C_LVS_XC21_251 vcn bn8 cap_cmomi w=2.67e-6 l=2.52e-6 m=1
C_LVS_XC21_252 vcn bn8 cap_cmomi w=2.67e-6 l=2.52e-6 m=1
C_LVS_XC21_253 vcn bn8 cap_cmomi w=2.67e-6 l=2.52e-6 m=1
C_LVS_XC21_254 vcn bn8 cap_cmomi w=2.67e-6 l=2.52e-6 m=1
C_LVS_XC21_255 vcn bn8 cap_cmomi w=2.67e-6 l=2.52e-6 m=1
C_LVS_XC21_256 vcn bn8 cap_cmomi w=2.67e-6 l=2.52e-6 m=1
C_LVS_XC22_1 vcn bn9 cap_cmomi w=2.67e-6 l=2.52e-6 m=1
C_LVS_XC22_2 vcn bn9 cap_cmomi w=2.67e-6 l=2.52e-6 m=1
C_LVS_XC22_3 vcn bn9 cap_cmomi w=2.67e-6 l=2.52e-6 m=1
C_LVS_XC22_4 vcn bn9 cap_cmomi w=2.67e-6 l=2.52e-6 m=1
C_LVS_XC22_5 vcn bn9 cap_cmomi w=2.67e-6 l=2.52e-6 m=1
C_LVS_XC22_6 vcn bn9 cap_cmomi w=2.67e-6 l=2.52e-6 m=1
C_LVS_XC22_7 vcn bn9 cap_cmomi w=2.67e-6 l=2.52e-6 m=1
C_LVS_XC22_8 vcn bn9 cap_cmomi w=2.67e-6 l=2.52e-6 m=1
C_LVS_XC22_9 vcn bn9 cap_cmomi w=2.67e-6 l=2.52e-6 m=1
C_LVS_XC22_10 vcn bn9 cap_cmomi w=2.67e-6 l=2.52e-6 m=1
C_LVS_XC22_11 vcn bn9 cap_cmomi w=2.67e-6 l=2.52e-6 m=1
C_LVS_XC22_12 vcn bn9 cap_cmomi w=2.67e-6 l=2.52e-6 m=1
C_LVS_XC22_13 vcn bn9 cap_cmomi w=2.67e-6 l=2.52e-6 m=1
C_LVS_XC22_14 vcn bn9 cap_cmomi w=2.67e-6 l=2.52e-6 m=1
C_LVS_XC22_15 vcn bn9 cap_cmomi w=2.67e-6 l=2.52e-6 m=1
C_LVS_XC22_16 vcn bn9 cap_cmomi w=2.67e-6 l=2.52e-6 m=1
C_LVS_XC22_17 vcn bn9 cap_cmomi w=2.67e-6 l=2.52e-6 m=1
C_LVS_XC22_18 vcn bn9 cap_cmomi w=2.67e-6 l=2.52e-6 m=1
C_LVS_XC22_19 vcn bn9 cap_cmomi w=2.67e-6 l=2.52e-6 m=1
C_LVS_XC22_20 vcn bn9 cap_cmomi w=2.67e-6 l=2.52e-6 m=1
C_LVS_XC22_21 vcn bn9 cap_cmomi w=2.67e-6 l=2.52e-6 m=1
C_LVS_XC22_22 vcn bn9 cap_cmomi w=2.67e-6 l=2.52e-6 m=1
C_LVS_XC22_23 vcn bn9 cap_cmomi w=2.67e-6 l=2.52e-6 m=1
C_LVS_XC22_24 vcn bn9 cap_cmomi w=2.67e-6 l=2.52e-6 m=1
C_LVS_XC22_25 vcn bn9 cap_cmomi w=2.67e-6 l=2.52e-6 m=1
C_LVS_XC22_26 vcn bn9 cap_cmomi w=2.67e-6 l=2.52e-6 m=1
C_LVS_XC22_27 vcn bn9 cap_cmomi w=2.67e-6 l=2.52e-6 m=1
C_LVS_XC22_28 vcn bn9 cap_cmomi w=2.67e-6 l=2.52e-6 m=1
C_LVS_XC22_29 vcn bn9 cap_cmomi w=2.67e-6 l=2.52e-6 m=1
C_LVS_XC22_30 vcn bn9 cap_cmomi w=2.67e-6 l=2.52e-6 m=1
C_LVS_XC22_31 vcn bn9 cap_cmomi w=2.67e-6 l=2.52e-6 m=1
C_LVS_XC22_32 vcn bn9 cap_cmomi w=2.67e-6 l=2.52e-6 m=1
C_LVS_XC22_33 vcn bn9 cap_cmomi w=2.67e-6 l=2.52e-6 m=1
C_LVS_XC22_34 vcn bn9 cap_cmomi w=2.67e-6 l=2.52e-6 m=1
C_LVS_XC22_35 vcn bn9 cap_cmomi w=2.67e-6 l=2.52e-6 m=1
C_LVS_XC22_36 vcn bn9 cap_cmomi w=2.67e-6 l=2.52e-6 m=1
C_LVS_XC22_37 vcn bn9 cap_cmomi w=2.67e-6 l=2.52e-6 m=1
C_LVS_XC22_38 vcn bn9 cap_cmomi w=2.67e-6 l=2.52e-6 m=1
C_LVS_XC22_39 vcn bn9 cap_cmomi w=2.67e-6 l=2.52e-6 m=1
C_LVS_XC22_40 vcn bn9 cap_cmomi w=2.67e-6 l=2.52e-6 m=1
C_LVS_XC22_41 vcn bn9 cap_cmomi w=2.67e-6 l=2.52e-6 m=1
C_LVS_XC22_42 vcn bn9 cap_cmomi w=2.67e-6 l=2.52e-6 m=1
C_LVS_XC22_43 vcn bn9 cap_cmomi w=2.67e-6 l=2.52e-6 m=1
C_LVS_XC22_44 vcn bn9 cap_cmomi w=2.67e-6 l=2.52e-6 m=1
C_LVS_XC22_45 vcn bn9 cap_cmomi w=2.67e-6 l=2.52e-6 m=1
C_LVS_XC22_46 vcn bn9 cap_cmomi w=2.67e-6 l=2.52e-6 m=1
C_LVS_XC22_47 vcn bn9 cap_cmomi w=2.67e-6 l=2.52e-6 m=1
C_LVS_XC22_48 vcn bn9 cap_cmomi w=2.67e-6 l=2.52e-6 m=1
C_LVS_XC22_49 vcn bn9 cap_cmomi w=2.67e-6 l=2.52e-6 m=1
C_LVS_XC22_50 vcn bn9 cap_cmomi w=2.67e-6 l=2.52e-6 m=1
C_LVS_XC22_51 vcn bn9 cap_cmomi w=2.67e-6 l=2.52e-6 m=1
C_LVS_XC22_52 vcn bn9 cap_cmomi w=2.67e-6 l=2.52e-6 m=1
C_LVS_XC22_53 vcn bn9 cap_cmomi w=2.67e-6 l=2.52e-6 m=1
C_LVS_XC22_54 vcn bn9 cap_cmomi w=2.67e-6 l=2.52e-6 m=1
C_LVS_XC22_55 vcn bn9 cap_cmomi w=2.67e-6 l=2.52e-6 m=1
C_LVS_XC22_56 vcn bn9 cap_cmomi w=2.67e-6 l=2.52e-6 m=1
C_LVS_XC22_57 vcn bn9 cap_cmomi w=2.67e-6 l=2.52e-6 m=1
C_LVS_XC22_58 vcn bn9 cap_cmomi w=2.67e-6 l=2.52e-6 m=1
C_LVS_XC22_59 vcn bn9 cap_cmomi w=2.67e-6 l=2.52e-6 m=1
C_LVS_XC22_60 vcn bn9 cap_cmomi w=2.67e-6 l=2.52e-6 m=1
C_LVS_XC22_61 vcn bn9 cap_cmomi w=2.67e-6 l=2.52e-6 m=1
C_LVS_XC22_62 vcn bn9 cap_cmomi w=2.67e-6 l=2.52e-6 m=1
C_LVS_XC22_63 vcn bn9 cap_cmomi w=2.67e-6 l=2.52e-6 m=1
C_LVS_XC22_64 vcn bn9 cap_cmomi w=2.67e-6 l=2.52e-6 m=1
C_LVS_XC22_65 vcn bn9 cap_cmomi w=2.67e-6 l=2.52e-6 m=1
C_LVS_XC22_66 vcn bn9 cap_cmomi w=2.67e-6 l=2.52e-6 m=1
C_LVS_XC22_67 vcn bn9 cap_cmomi w=2.67e-6 l=2.52e-6 m=1
C_LVS_XC22_68 vcn bn9 cap_cmomi w=2.67e-6 l=2.52e-6 m=1
C_LVS_XC22_69 vcn bn9 cap_cmomi w=2.67e-6 l=2.52e-6 m=1
C_LVS_XC22_70 vcn bn9 cap_cmomi w=2.67e-6 l=2.52e-6 m=1
C_LVS_XC22_71 vcn bn9 cap_cmomi w=2.67e-6 l=2.52e-6 m=1
C_LVS_XC22_72 vcn bn9 cap_cmomi w=2.67e-6 l=2.52e-6 m=1
C_LVS_XC22_73 vcn bn9 cap_cmomi w=2.67e-6 l=2.52e-6 m=1
C_LVS_XC22_74 vcn bn9 cap_cmomi w=2.67e-6 l=2.52e-6 m=1
C_LVS_XC22_75 vcn bn9 cap_cmomi w=2.67e-6 l=2.52e-6 m=1
C_LVS_XC22_76 vcn bn9 cap_cmomi w=2.67e-6 l=2.52e-6 m=1
C_LVS_XC22_77 vcn bn9 cap_cmomi w=2.67e-6 l=2.52e-6 m=1
C_LVS_XC22_78 vcn bn9 cap_cmomi w=2.67e-6 l=2.52e-6 m=1
C_LVS_XC22_79 vcn bn9 cap_cmomi w=2.67e-6 l=2.52e-6 m=1
C_LVS_XC22_80 vcn bn9 cap_cmomi w=2.67e-6 l=2.52e-6 m=1
C_LVS_XC22_81 vcn bn9 cap_cmomi w=2.67e-6 l=2.52e-6 m=1
C_LVS_XC22_82 vcn bn9 cap_cmomi w=2.67e-6 l=2.52e-6 m=1
C_LVS_XC22_83 vcn bn9 cap_cmomi w=2.67e-6 l=2.52e-6 m=1
C_LVS_XC22_84 vcn bn9 cap_cmomi w=2.67e-6 l=2.52e-6 m=1
C_LVS_XC22_85 vcn bn9 cap_cmomi w=2.67e-6 l=2.52e-6 m=1
C_LVS_XC22_86 vcn bn9 cap_cmomi w=2.67e-6 l=2.52e-6 m=1
C_LVS_XC22_87 vcn bn9 cap_cmomi w=2.67e-6 l=2.52e-6 m=1
C_LVS_XC22_88 vcn bn9 cap_cmomi w=2.67e-6 l=2.52e-6 m=1
C_LVS_XC22_89 vcn bn9 cap_cmomi w=2.67e-6 l=2.52e-6 m=1
C_LVS_XC22_90 vcn bn9 cap_cmomi w=2.67e-6 l=2.52e-6 m=1
C_LVS_XC22_91 vcn bn9 cap_cmomi w=2.67e-6 l=2.52e-6 m=1
C_LVS_XC22_92 vcn bn9 cap_cmomi w=2.67e-6 l=2.52e-6 m=1
C_LVS_XC22_93 vcn bn9 cap_cmomi w=2.67e-6 l=2.52e-6 m=1
C_LVS_XC22_94 vcn bn9 cap_cmomi w=2.67e-6 l=2.52e-6 m=1
C_LVS_XC22_95 vcn bn9 cap_cmomi w=2.67e-6 l=2.52e-6 m=1
C_LVS_XC22_96 vcn bn9 cap_cmomi w=2.67e-6 l=2.52e-6 m=1
C_LVS_XC22_97 vcn bn9 cap_cmomi w=2.67e-6 l=2.52e-6 m=1
C_LVS_XC22_98 vcn bn9 cap_cmomi w=2.67e-6 l=2.52e-6 m=1
C_LVS_XC22_99 vcn bn9 cap_cmomi w=2.67e-6 l=2.52e-6 m=1
C_LVS_XC22_100 vcn bn9 cap_cmomi w=2.67e-6 l=2.52e-6 m=1
C_LVS_XC22_101 vcn bn9 cap_cmomi w=2.67e-6 l=2.52e-6 m=1
C_LVS_XC22_102 vcn bn9 cap_cmomi w=2.67e-6 l=2.52e-6 m=1
C_LVS_XC22_103 vcn bn9 cap_cmomi w=2.67e-6 l=2.52e-6 m=1
C_LVS_XC22_104 vcn bn9 cap_cmomi w=2.67e-6 l=2.52e-6 m=1
C_LVS_XC22_105 vcn bn9 cap_cmomi w=2.67e-6 l=2.52e-6 m=1
C_LVS_XC22_106 vcn bn9 cap_cmomi w=2.67e-6 l=2.52e-6 m=1
C_LVS_XC22_107 vcn bn9 cap_cmomi w=2.67e-6 l=2.52e-6 m=1
C_LVS_XC22_108 vcn bn9 cap_cmomi w=2.67e-6 l=2.52e-6 m=1
C_LVS_XC22_109 vcn bn9 cap_cmomi w=2.67e-6 l=2.52e-6 m=1
C_LVS_XC22_110 vcn bn9 cap_cmomi w=2.67e-6 l=2.52e-6 m=1
C_LVS_XC22_111 vcn bn9 cap_cmomi w=2.67e-6 l=2.52e-6 m=1
C_LVS_XC22_112 vcn bn9 cap_cmomi w=2.67e-6 l=2.52e-6 m=1
C_LVS_XC22_113 vcn bn9 cap_cmomi w=2.67e-6 l=2.52e-6 m=1
C_LVS_XC22_114 vcn bn9 cap_cmomi w=2.67e-6 l=2.52e-6 m=1
C_LVS_XC22_115 vcn bn9 cap_cmomi w=2.67e-6 l=2.52e-6 m=1
C_LVS_XC22_116 vcn bn9 cap_cmomi w=2.67e-6 l=2.52e-6 m=1
C_LVS_XC22_117 vcn bn9 cap_cmomi w=2.67e-6 l=2.52e-6 m=1
C_LVS_XC22_118 vcn bn9 cap_cmomi w=2.67e-6 l=2.52e-6 m=1
C_LVS_XC22_119 vcn bn9 cap_cmomi w=2.67e-6 l=2.52e-6 m=1
C_LVS_XC22_120 vcn bn9 cap_cmomi w=2.67e-6 l=2.52e-6 m=1
C_LVS_XC22_121 vcn bn9 cap_cmomi w=2.67e-6 l=2.52e-6 m=1
C_LVS_XC22_122 vcn bn9 cap_cmomi w=2.67e-6 l=2.52e-6 m=1
C_LVS_XC22_123 vcn bn9 cap_cmomi w=2.67e-6 l=2.52e-6 m=1
C_LVS_XC22_124 vcn bn9 cap_cmomi w=2.67e-6 l=2.52e-6 m=1
C_LVS_XC22_125 vcn bn9 cap_cmomi w=2.67e-6 l=2.52e-6 m=1
C_LVS_XC22_126 vcn bn9 cap_cmomi w=2.67e-6 l=2.52e-6 m=1
C_LVS_XC22_127 vcn bn9 cap_cmomi w=2.67e-6 l=2.52e-6 m=1
C_LVS_XC22_128 vcn bn9 cap_cmomi w=2.67e-6 l=2.52e-6 m=1
C_LVS_XC22_129 vcn bn9 cap_cmomi w=2.67e-6 l=2.52e-6 m=1
C_LVS_XC22_130 vcn bn9 cap_cmomi w=2.67e-6 l=2.52e-6 m=1
C_LVS_XC22_131 vcn bn9 cap_cmomi w=2.67e-6 l=2.52e-6 m=1
C_LVS_XC22_132 vcn bn9 cap_cmomi w=2.67e-6 l=2.52e-6 m=1
C_LVS_XC22_133 vcn bn9 cap_cmomi w=2.67e-6 l=2.52e-6 m=1
C_LVS_XC22_134 vcn bn9 cap_cmomi w=2.67e-6 l=2.52e-6 m=1
C_LVS_XC22_135 vcn bn9 cap_cmomi w=2.67e-6 l=2.52e-6 m=1
C_LVS_XC22_136 vcn bn9 cap_cmomi w=2.67e-6 l=2.52e-6 m=1
C_LVS_XC22_137 vcn bn9 cap_cmomi w=2.67e-6 l=2.52e-6 m=1
C_LVS_XC22_138 vcn bn9 cap_cmomi w=2.67e-6 l=2.52e-6 m=1
C_LVS_XC22_139 vcn bn9 cap_cmomi w=2.67e-6 l=2.52e-6 m=1
C_LVS_XC22_140 vcn bn9 cap_cmomi w=2.67e-6 l=2.52e-6 m=1
C_LVS_XC22_141 vcn bn9 cap_cmomi w=2.67e-6 l=2.52e-6 m=1
C_LVS_XC22_142 vcn bn9 cap_cmomi w=2.67e-6 l=2.52e-6 m=1
C_LVS_XC22_143 vcn bn9 cap_cmomi w=2.67e-6 l=2.52e-6 m=1
C_LVS_XC22_144 vcn bn9 cap_cmomi w=2.67e-6 l=2.52e-6 m=1
C_LVS_XC22_145 vcn bn9 cap_cmomi w=2.67e-6 l=2.52e-6 m=1
C_LVS_XC22_146 vcn bn9 cap_cmomi w=2.67e-6 l=2.52e-6 m=1
C_LVS_XC22_147 vcn bn9 cap_cmomi w=2.67e-6 l=2.52e-6 m=1
C_LVS_XC22_148 vcn bn9 cap_cmomi w=2.67e-6 l=2.52e-6 m=1
C_LVS_XC22_149 vcn bn9 cap_cmomi w=2.67e-6 l=2.52e-6 m=1
C_LVS_XC22_150 vcn bn9 cap_cmomi w=2.67e-6 l=2.52e-6 m=1
C_LVS_XC22_151 vcn bn9 cap_cmomi w=2.67e-6 l=2.52e-6 m=1
C_LVS_XC22_152 vcn bn9 cap_cmomi w=2.67e-6 l=2.52e-6 m=1
C_LVS_XC22_153 vcn bn9 cap_cmomi w=2.67e-6 l=2.52e-6 m=1
C_LVS_XC22_154 vcn bn9 cap_cmomi w=2.67e-6 l=2.52e-6 m=1
C_LVS_XC22_155 vcn bn9 cap_cmomi w=2.67e-6 l=2.52e-6 m=1
C_LVS_XC22_156 vcn bn9 cap_cmomi w=2.67e-6 l=2.52e-6 m=1
C_LVS_XC22_157 vcn bn9 cap_cmomi w=2.67e-6 l=2.52e-6 m=1
C_LVS_XC22_158 vcn bn9 cap_cmomi w=2.67e-6 l=2.52e-6 m=1
C_LVS_XC22_159 vcn bn9 cap_cmomi w=2.67e-6 l=2.52e-6 m=1
C_LVS_XC22_160 vcn bn9 cap_cmomi w=2.67e-6 l=2.52e-6 m=1
C_LVS_XC22_161 vcn bn9 cap_cmomi w=2.67e-6 l=2.52e-6 m=1
C_LVS_XC22_162 vcn bn9 cap_cmomi w=2.67e-6 l=2.52e-6 m=1
C_LVS_XC22_163 vcn bn9 cap_cmomi w=2.67e-6 l=2.52e-6 m=1
C_LVS_XC22_164 vcn bn9 cap_cmomi w=2.67e-6 l=2.52e-6 m=1
C_LVS_XC22_165 vcn bn9 cap_cmomi w=2.67e-6 l=2.52e-6 m=1
C_LVS_XC22_166 vcn bn9 cap_cmomi w=2.67e-6 l=2.52e-6 m=1
C_LVS_XC22_167 vcn bn9 cap_cmomi w=2.67e-6 l=2.52e-6 m=1
C_LVS_XC22_168 vcn bn9 cap_cmomi w=2.67e-6 l=2.52e-6 m=1
C_LVS_XC22_169 vcn bn9 cap_cmomi w=2.67e-6 l=2.52e-6 m=1
C_LVS_XC22_170 vcn bn9 cap_cmomi w=2.67e-6 l=2.52e-6 m=1
C_LVS_XC22_171 vcn bn9 cap_cmomi w=2.67e-6 l=2.52e-6 m=1
C_LVS_XC22_172 vcn bn9 cap_cmomi w=2.67e-6 l=2.52e-6 m=1
C_LVS_XC22_173 vcn bn9 cap_cmomi w=2.67e-6 l=2.52e-6 m=1
C_LVS_XC22_174 vcn bn9 cap_cmomi w=2.67e-6 l=2.52e-6 m=1
C_LVS_XC22_175 vcn bn9 cap_cmomi w=2.67e-6 l=2.52e-6 m=1
C_LVS_XC22_176 vcn bn9 cap_cmomi w=2.67e-6 l=2.52e-6 m=1
C_LVS_XC22_177 vcn bn9 cap_cmomi w=2.67e-6 l=2.52e-6 m=1
C_LVS_XC22_178 vcn bn9 cap_cmomi w=2.67e-6 l=2.52e-6 m=1
C_LVS_XC22_179 vcn bn9 cap_cmomi w=2.67e-6 l=2.52e-6 m=1
C_LVS_XC22_180 vcn bn9 cap_cmomi w=2.67e-6 l=2.52e-6 m=1
C_LVS_XC22_181 vcn bn9 cap_cmomi w=2.67e-6 l=2.52e-6 m=1
C_LVS_XC22_182 vcn bn9 cap_cmomi w=2.67e-6 l=2.52e-6 m=1
C_LVS_XC22_183 vcn bn9 cap_cmomi w=2.67e-6 l=2.52e-6 m=1
C_LVS_XC22_184 vcn bn9 cap_cmomi w=2.67e-6 l=2.52e-6 m=1
C_LVS_XC22_185 vcn bn9 cap_cmomi w=2.67e-6 l=2.52e-6 m=1
C_LVS_XC22_186 vcn bn9 cap_cmomi w=2.67e-6 l=2.52e-6 m=1
C_LVS_XC22_187 vcn bn9 cap_cmomi w=2.67e-6 l=2.52e-6 m=1
C_LVS_XC22_188 vcn bn9 cap_cmomi w=2.67e-6 l=2.52e-6 m=1
C_LVS_XC22_189 vcn bn9 cap_cmomi w=2.67e-6 l=2.52e-6 m=1
C_LVS_XC22_190 vcn bn9 cap_cmomi w=2.67e-6 l=2.52e-6 m=1
C_LVS_XC22_191 vcn bn9 cap_cmomi w=2.67e-6 l=2.52e-6 m=1
C_LVS_XC22_192 vcn bn9 cap_cmomi w=2.67e-6 l=2.52e-6 m=1
C_LVS_XC22_193 vcn bn9 cap_cmomi w=2.67e-6 l=2.52e-6 m=1
C_LVS_XC22_194 vcn bn9 cap_cmomi w=2.67e-6 l=2.52e-6 m=1
C_LVS_XC22_195 vcn bn9 cap_cmomi w=2.67e-6 l=2.52e-6 m=1
C_LVS_XC22_196 vcn bn9 cap_cmomi w=2.67e-6 l=2.52e-6 m=1
C_LVS_XC22_197 vcn bn9 cap_cmomi w=2.67e-6 l=2.52e-6 m=1
C_LVS_XC22_198 vcn bn9 cap_cmomi w=2.67e-6 l=2.52e-6 m=1
C_LVS_XC22_199 vcn bn9 cap_cmomi w=2.67e-6 l=2.52e-6 m=1
C_LVS_XC22_200 vcn bn9 cap_cmomi w=2.67e-6 l=2.52e-6 m=1
C_LVS_XC22_201 vcn bn9 cap_cmomi w=2.67e-6 l=2.52e-6 m=1
C_LVS_XC22_202 vcn bn9 cap_cmomi w=2.67e-6 l=2.52e-6 m=1
C_LVS_XC22_203 vcn bn9 cap_cmomi w=2.67e-6 l=2.52e-6 m=1
C_LVS_XC22_204 vcn bn9 cap_cmomi w=2.67e-6 l=2.52e-6 m=1
C_LVS_XC22_205 vcn bn9 cap_cmomi w=2.67e-6 l=2.52e-6 m=1
C_LVS_XC22_206 vcn bn9 cap_cmomi w=2.67e-6 l=2.52e-6 m=1
C_LVS_XC22_207 vcn bn9 cap_cmomi w=2.67e-6 l=2.52e-6 m=1
C_LVS_XC22_208 vcn bn9 cap_cmomi w=2.67e-6 l=2.52e-6 m=1
C_LVS_XC22_209 vcn bn9 cap_cmomi w=2.67e-6 l=2.52e-6 m=1
C_LVS_XC22_210 vcn bn9 cap_cmomi w=2.67e-6 l=2.52e-6 m=1
C_LVS_XC22_211 vcn bn9 cap_cmomi w=2.67e-6 l=2.52e-6 m=1
C_LVS_XC22_212 vcn bn9 cap_cmomi w=2.67e-6 l=2.52e-6 m=1
C_LVS_XC22_213 vcn bn9 cap_cmomi w=2.67e-6 l=2.52e-6 m=1
C_LVS_XC22_214 vcn bn9 cap_cmomi w=2.67e-6 l=2.52e-6 m=1
C_LVS_XC22_215 vcn bn9 cap_cmomi w=2.67e-6 l=2.52e-6 m=1
C_LVS_XC22_216 vcn bn9 cap_cmomi w=2.67e-6 l=2.52e-6 m=1
C_LVS_XC22_217 vcn bn9 cap_cmomi w=2.67e-6 l=2.52e-6 m=1
C_LVS_XC22_218 vcn bn9 cap_cmomi w=2.67e-6 l=2.52e-6 m=1
C_LVS_XC22_219 vcn bn9 cap_cmomi w=2.67e-6 l=2.52e-6 m=1
C_LVS_XC22_220 vcn bn9 cap_cmomi w=2.67e-6 l=2.52e-6 m=1
C_LVS_XC22_221 vcn bn9 cap_cmomi w=2.67e-6 l=2.52e-6 m=1
C_LVS_XC22_222 vcn bn9 cap_cmomi w=2.67e-6 l=2.52e-6 m=1
C_LVS_XC22_223 vcn bn9 cap_cmomi w=2.67e-6 l=2.52e-6 m=1
C_LVS_XC22_224 vcn bn9 cap_cmomi w=2.67e-6 l=2.52e-6 m=1
C_LVS_XC22_225 vcn bn9 cap_cmomi w=2.67e-6 l=2.52e-6 m=1
C_LVS_XC22_226 vcn bn9 cap_cmomi w=2.67e-6 l=2.52e-6 m=1
C_LVS_XC22_227 vcn bn9 cap_cmomi w=2.67e-6 l=2.52e-6 m=1
C_LVS_XC22_228 vcn bn9 cap_cmomi w=2.67e-6 l=2.52e-6 m=1
C_LVS_XC22_229 vcn bn9 cap_cmomi w=2.67e-6 l=2.52e-6 m=1
C_LVS_XC22_230 vcn bn9 cap_cmomi w=2.67e-6 l=2.52e-6 m=1
C_LVS_XC22_231 vcn bn9 cap_cmomi w=2.67e-6 l=2.52e-6 m=1
C_LVS_XC22_232 vcn bn9 cap_cmomi w=2.67e-6 l=2.52e-6 m=1
C_LVS_XC22_233 vcn bn9 cap_cmomi w=2.67e-6 l=2.52e-6 m=1
C_LVS_XC22_234 vcn bn9 cap_cmomi w=2.67e-6 l=2.52e-6 m=1
C_LVS_XC22_235 vcn bn9 cap_cmomi w=2.67e-6 l=2.52e-6 m=1
C_LVS_XC22_236 vcn bn9 cap_cmomi w=2.67e-6 l=2.52e-6 m=1
C_LVS_XC22_237 vcn bn9 cap_cmomi w=2.67e-6 l=2.52e-6 m=1
C_LVS_XC22_238 vcn bn9 cap_cmomi w=2.67e-6 l=2.52e-6 m=1
C_LVS_XC22_239 vcn bn9 cap_cmomi w=2.67e-6 l=2.52e-6 m=1
C_LVS_XC22_240 vcn bn9 cap_cmomi w=2.67e-6 l=2.52e-6 m=1
C_LVS_XC22_241 vcn bn9 cap_cmomi w=2.67e-6 l=2.52e-6 m=1
C_LVS_XC22_242 vcn bn9 cap_cmomi w=2.67e-6 l=2.52e-6 m=1
C_LVS_XC22_243 vcn bn9 cap_cmomi w=2.67e-6 l=2.52e-6 m=1
C_LVS_XC22_244 vcn bn9 cap_cmomi w=2.67e-6 l=2.52e-6 m=1
C_LVS_XC22_245 vcn bn9 cap_cmomi w=2.67e-6 l=2.52e-6 m=1
C_LVS_XC22_246 vcn bn9 cap_cmomi w=2.67e-6 l=2.52e-6 m=1
C_LVS_XC22_247 vcn bn9 cap_cmomi w=2.67e-6 l=2.52e-6 m=1
C_LVS_XC22_248 vcn bn9 cap_cmomi w=2.67e-6 l=2.52e-6 m=1
C_LVS_XC22_249 vcn bn9 cap_cmomi w=2.67e-6 l=2.52e-6 m=1
C_LVS_XC22_250 vcn bn9 cap_cmomi w=2.67e-6 l=2.52e-6 m=1
C_LVS_XC22_251 vcn bn9 cap_cmomi w=2.67e-6 l=2.52e-6 m=1
C_LVS_XC22_252 vcn bn9 cap_cmomi w=2.67e-6 l=2.52e-6 m=1
C_LVS_XC22_253 vcn bn9 cap_cmomi w=2.67e-6 l=2.52e-6 m=1
C_LVS_XC22_254 vcn bn9 cap_cmomi w=2.67e-6 l=2.52e-6 m=1
C_LVS_XC22_255 vcn bn9 cap_cmomi w=2.67e-6 l=2.52e-6 m=1
C_LVS_XC22_256 vcn bn9 cap_cmomi w=2.67e-6 l=2.52e-6 m=1
C_LVS_XC22_257 vcn bn9 cap_cmomi w=2.67e-6 l=2.52e-6 m=1
C_LVS_XC22_258 vcn bn9 cap_cmomi w=2.67e-6 l=2.52e-6 m=1
C_LVS_XC22_259 vcn bn9 cap_cmomi w=2.67e-6 l=2.52e-6 m=1
C_LVS_XC22_260 vcn bn9 cap_cmomi w=2.67e-6 l=2.52e-6 m=1
C_LVS_XC22_261 vcn bn9 cap_cmomi w=2.67e-6 l=2.52e-6 m=1
C_LVS_XC22_262 vcn bn9 cap_cmomi w=2.67e-6 l=2.52e-6 m=1
C_LVS_XC22_263 vcn bn9 cap_cmomi w=2.67e-6 l=2.52e-6 m=1
C_LVS_XC22_264 vcn bn9 cap_cmomi w=2.67e-6 l=2.52e-6 m=1
C_LVS_XC22_265 vcn bn9 cap_cmomi w=2.67e-6 l=2.52e-6 m=1
C_LVS_XC22_266 vcn bn9 cap_cmomi w=2.67e-6 l=2.52e-6 m=1
C_LVS_XC22_267 vcn bn9 cap_cmomi w=2.67e-6 l=2.52e-6 m=1
C_LVS_XC22_268 vcn bn9 cap_cmomi w=2.67e-6 l=2.52e-6 m=1
C_LVS_XC22_269 vcn bn9 cap_cmomi w=2.67e-6 l=2.52e-6 m=1
C_LVS_XC22_270 vcn bn9 cap_cmomi w=2.67e-6 l=2.52e-6 m=1
C_LVS_XC22_271 vcn bn9 cap_cmomi w=2.67e-6 l=2.52e-6 m=1
C_LVS_XC22_272 vcn bn9 cap_cmomi w=2.67e-6 l=2.52e-6 m=1
C_LVS_XC22_273 vcn bn9 cap_cmomi w=2.67e-6 l=2.52e-6 m=1
C_LVS_XC22_274 vcn bn9 cap_cmomi w=2.67e-6 l=2.52e-6 m=1
C_LVS_XC22_275 vcn bn9 cap_cmomi w=2.67e-6 l=2.52e-6 m=1
C_LVS_XC22_276 vcn bn9 cap_cmomi w=2.67e-6 l=2.52e-6 m=1
C_LVS_XC22_277 vcn bn9 cap_cmomi w=2.67e-6 l=2.52e-6 m=1
C_LVS_XC22_278 vcn bn9 cap_cmomi w=2.67e-6 l=2.52e-6 m=1
C_LVS_XC22_279 vcn bn9 cap_cmomi w=2.67e-6 l=2.52e-6 m=1
C_LVS_XC22_280 vcn bn9 cap_cmomi w=2.67e-6 l=2.52e-6 m=1
C_LVS_XC22_281 vcn bn9 cap_cmomi w=2.67e-6 l=2.52e-6 m=1
C_LVS_XC22_282 vcn bn9 cap_cmomi w=2.67e-6 l=2.52e-6 m=1
C_LVS_XC22_283 vcn bn9 cap_cmomi w=2.67e-6 l=2.52e-6 m=1
C_LVS_XC22_284 vcn bn9 cap_cmomi w=2.67e-6 l=2.52e-6 m=1
C_LVS_XC22_285 vcn bn9 cap_cmomi w=2.67e-6 l=2.52e-6 m=1
C_LVS_XC22_286 vcn bn9 cap_cmomi w=2.67e-6 l=2.52e-6 m=1
C_LVS_XC22_287 vcn bn9 cap_cmomi w=2.67e-6 l=2.52e-6 m=1
C_LVS_XC22_288 vcn bn9 cap_cmomi w=2.67e-6 l=2.52e-6 m=1
C_LVS_XC22_289 vcn bn9 cap_cmomi w=2.67e-6 l=2.52e-6 m=1
C_LVS_XC22_290 vcn bn9 cap_cmomi w=2.67e-6 l=2.52e-6 m=1
C_LVS_XC22_291 vcn bn9 cap_cmomi w=2.67e-6 l=2.52e-6 m=1
C_LVS_XC22_292 vcn bn9 cap_cmomi w=2.67e-6 l=2.52e-6 m=1
C_LVS_XC22_293 vcn bn9 cap_cmomi w=2.67e-6 l=2.52e-6 m=1
C_LVS_XC22_294 vcn bn9 cap_cmomi w=2.67e-6 l=2.52e-6 m=1
C_LVS_XC22_295 vcn bn9 cap_cmomi w=2.67e-6 l=2.52e-6 m=1
C_LVS_XC22_296 vcn bn9 cap_cmomi w=2.67e-6 l=2.52e-6 m=1
C_LVS_XC22_297 vcn bn9 cap_cmomi w=2.67e-6 l=2.52e-6 m=1
C_LVS_XC22_298 vcn bn9 cap_cmomi w=2.67e-6 l=2.52e-6 m=1
C_LVS_XC22_299 vcn bn9 cap_cmomi w=2.67e-6 l=2.52e-6 m=1
C_LVS_XC22_300 vcn bn9 cap_cmomi w=2.67e-6 l=2.52e-6 m=1
C_LVS_XC22_301 vcn bn9 cap_cmomi w=2.67e-6 l=2.52e-6 m=1
C_LVS_XC22_302 vcn bn9 cap_cmomi w=2.67e-6 l=2.52e-6 m=1
C_LVS_XC22_303 vcn bn9 cap_cmomi w=2.67e-6 l=2.52e-6 m=1
C_LVS_XC22_304 vcn bn9 cap_cmomi w=2.67e-6 l=2.52e-6 m=1
C_LVS_XC22_305 vcn bn9 cap_cmomi w=2.67e-6 l=2.52e-6 m=1
C_LVS_XC22_306 vcn bn9 cap_cmomi w=2.67e-6 l=2.52e-6 m=1
C_LVS_XC22_307 vcn bn9 cap_cmomi w=2.67e-6 l=2.52e-6 m=1
C_LVS_XC22_308 vcn bn9 cap_cmomi w=2.67e-6 l=2.52e-6 m=1
C_LVS_XC22_309 vcn bn9 cap_cmomi w=2.67e-6 l=2.52e-6 m=1
C_LVS_XC22_310 vcn bn9 cap_cmomi w=2.67e-6 l=2.52e-6 m=1
C_LVS_XC22_311 vcn bn9 cap_cmomi w=2.67e-6 l=2.52e-6 m=1
C_LVS_XC22_312 vcn bn9 cap_cmomi w=2.67e-6 l=2.52e-6 m=1
C_LVS_XC22_313 vcn bn9 cap_cmomi w=2.67e-6 l=2.52e-6 m=1
C_LVS_XC22_314 vcn bn9 cap_cmomi w=2.67e-6 l=2.52e-6 m=1
C_LVS_XC22_315 vcn bn9 cap_cmomi w=2.67e-6 l=2.52e-6 m=1
C_LVS_XC22_316 vcn bn9 cap_cmomi w=2.67e-6 l=2.52e-6 m=1
C_LVS_XC22_317 vcn bn9 cap_cmomi w=2.67e-6 l=2.52e-6 m=1
C_LVS_XC22_318 vcn bn9 cap_cmomi w=2.67e-6 l=2.52e-6 m=1
C_LVS_XC22_319 vcn bn9 cap_cmomi w=2.67e-6 l=2.52e-6 m=1
C_LVS_XC22_320 vcn bn9 cap_cmomi w=2.67e-6 l=2.52e-6 m=1
C_LVS_XC22_321 vcn bn9 cap_cmomi w=2.67e-6 l=2.52e-6 m=1
C_LVS_XC22_322 vcn bn9 cap_cmomi w=2.67e-6 l=2.52e-6 m=1
C_LVS_XC22_323 vcn bn9 cap_cmomi w=2.67e-6 l=2.52e-6 m=1
C_LVS_XC22_324 vcn bn9 cap_cmomi w=2.67e-6 l=2.52e-6 m=1
C_LVS_XC22_325 vcn bn9 cap_cmomi w=2.67e-6 l=2.52e-6 m=1
C_LVS_XC22_326 vcn bn9 cap_cmomi w=2.67e-6 l=2.52e-6 m=1
C_LVS_XC22_327 vcn bn9 cap_cmomi w=2.67e-6 l=2.52e-6 m=1
C_LVS_XC22_328 vcn bn9 cap_cmomi w=2.67e-6 l=2.52e-6 m=1
C_LVS_XC22_329 vcn bn9 cap_cmomi w=2.67e-6 l=2.52e-6 m=1
C_LVS_XC22_330 vcn bn9 cap_cmomi w=2.67e-6 l=2.52e-6 m=1
C_LVS_XC22_331 vcn bn9 cap_cmomi w=2.67e-6 l=2.52e-6 m=1
C_LVS_XC22_332 vcn bn9 cap_cmomi w=2.67e-6 l=2.52e-6 m=1
C_LVS_XC22_333 vcn bn9 cap_cmomi w=2.67e-6 l=2.52e-6 m=1
C_LVS_XC22_334 vcn bn9 cap_cmomi w=2.67e-6 l=2.52e-6 m=1
C_LVS_XC22_335 vcn bn9 cap_cmomi w=2.67e-6 l=2.52e-6 m=1
C_LVS_XC22_336 vcn bn9 cap_cmomi w=2.67e-6 l=2.52e-6 m=1
C_LVS_XC22_337 vcn bn9 cap_cmomi w=2.67e-6 l=2.52e-6 m=1
C_LVS_XC22_338 vcn bn9 cap_cmomi w=2.67e-6 l=2.52e-6 m=1
C_LVS_XC22_339 vcn bn9 cap_cmomi w=2.67e-6 l=2.52e-6 m=1
C_LVS_XC22_340 vcn bn9 cap_cmomi w=2.67e-6 l=2.52e-6 m=1
C_LVS_XC22_341 vcn bn9 cap_cmomi w=2.67e-6 l=2.52e-6 m=1
C_LVS_XC22_342 vcn bn9 cap_cmomi w=2.67e-6 l=2.52e-6 m=1
C_LVS_XC22_343 vcn bn9 cap_cmomi w=2.67e-6 l=2.52e-6 m=1
C_LVS_XC22_344 vcn bn9 cap_cmomi w=2.67e-6 l=2.52e-6 m=1
C_LVS_XC22_345 vcn bn9 cap_cmomi w=2.67e-6 l=2.52e-6 m=1
C_LVS_XC22_346 vcn bn9 cap_cmomi w=2.67e-6 l=2.52e-6 m=1
C_LVS_XC22_347 vcn bn9 cap_cmomi w=2.67e-6 l=2.52e-6 m=1
C_LVS_XC22_348 vcn bn9 cap_cmomi w=2.67e-6 l=2.52e-6 m=1
C_LVS_XC22_349 vcn bn9 cap_cmomi w=2.67e-6 l=2.52e-6 m=1
C_LVS_XC22_350 vcn bn9 cap_cmomi w=2.67e-6 l=2.52e-6 m=1
C_LVS_XC22_351 vcn bn9 cap_cmomi w=2.67e-6 l=2.52e-6 m=1
C_LVS_XC22_352 vcn bn9 cap_cmomi w=2.67e-6 l=2.52e-6 m=1
C_LVS_XC22_353 vcn bn9 cap_cmomi w=2.67e-6 l=2.52e-6 m=1
C_LVS_XC22_354 vcn bn9 cap_cmomi w=2.67e-6 l=2.52e-6 m=1
C_LVS_XC22_355 vcn bn9 cap_cmomi w=2.67e-6 l=2.52e-6 m=1
C_LVS_XC22_356 vcn bn9 cap_cmomi w=2.67e-6 l=2.52e-6 m=1
C_LVS_XC22_357 vcn bn9 cap_cmomi w=2.67e-6 l=2.52e-6 m=1
C_LVS_XC22_358 vcn bn9 cap_cmomi w=2.67e-6 l=2.52e-6 m=1
C_LVS_XC22_359 vcn bn9 cap_cmomi w=2.67e-6 l=2.52e-6 m=1
C_LVS_XC22_360 vcn bn9 cap_cmomi w=2.67e-6 l=2.52e-6 m=1
C_LVS_XC22_361 vcn bn9 cap_cmomi w=2.67e-6 l=2.52e-6 m=1
C_LVS_XC22_362 vcn bn9 cap_cmomi w=2.67e-6 l=2.52e-6 m=1
C_LVS_XC22_363 vcn bn9 cap_cmomi w=2.67e-6 l=2.52e-6 m=1
C_LVS_XC22_364 vcn bn9 cap_cmomi w=2.67e-6 l=2.52e-6 m=1
C_LVS_XC22_365 vcn bn9 cap_cmomi w=2.67e-6 l=2.52e-6 m=1
C_LVS_XC22_366 vcn bn9 cap_cmomi w=2.67e-6 l=2.52e-6 m=1
C_LVS_XC22_367 vcn bn9 cap_cmomi w=2.67e-6 l=2.52e-6 m=1
C_LVS_XC22_368 vcn bn9 cap_cmomi w=2.67e-6 l=2.52e-6 m=1
C_LVS_XC22_369 vcn bn9 cap_cmomi w=2.67e-6 l=2.52e-6 m=1
C_LVS_XC22_370 vcn bn9 cap_cmomi w=2.67e-6 l=2.52e-6 m=1
C_LVS_XC22_371 vcn bn9 cap_cmomi w=2.67e-6 l=2.52e-6 m=1
C_LVS_XC22_372 vcn bn9 cap_cmomi w=2.67e-6 l=2.52e-6 m=1
C_LVS_XC22_373 vcn bn9 cap_cmomi w=2.67e-6 l=2.52e-6 m=1
C_LVS_XC22_374 vcn bn9 cap_cmomi w=2.67e-6 l=2.52e-6 m=1
C_LVS_XC22_375 vcn bn9 cap_cmomi w=2.67e-6 l=2.52e-6 m=1
C_LVS_XC22_376 vcn bn9 cap_cmomi w=2.67e-6 l=2.52e-6 m=1
C_LVS_XC22_377 vcn bn9 cap_cmomi w=2.67e-6 l=2.52e-6 m=1
C_LVS_XC22_378 vcn bn9 cap_cmomi w=2.67e-6 l=2.52e-6 m=1
C_LVS_XC22_379 vcn bn9 cap_cmomi w=2.67e-6 l=2.52e-6 m=1
C_LVS_XC22_380 vcn bn9 cap_cmomi w=2.67e-6 l=2.52e-6 m=1
C_LVS_XC22_381 vcn bn9 cap_cmomi w=2.67e-6 l=2.52e-6 m=1
C_LVS_XC22_382 vcn bn9 cap_cmomi w=2.67e-6 l=2.52e-6 m=1
C_LVS_XC22_383 vcn bn9 cap_cmomi w=2.67e-6 l=2.52e-6 m=1
C_LVS_XC22_384 vcn bn9 cap_cmomi w=2.67e-6 l=2.52e-6 m=1
C_LVS_XC22_385 vcn bn9 cap_cmomi w=2.67e-6 l=2.52e-6 m=1
C_LVS_XC22_386 vcn bn9 cap_cmomi w=2.67e-6 l=2.52e-6 m=1
C_LVS_XC22_387 vcn bn9 cap_cmomi w=2.67e-6 l=2.52e-6 m=1
C_LVS_XC22_388 vcn bn9 cap_cmomi w=2.67e-6 l=2.52e-6 m=1
C_LVS_XC22_389 vcn bn9 cap_cmomi w=2.67e-6 l=2.52e-6 m=1
C_LVS_XC22_390 vcn bn9 cap_cmomi w=2.67e-6 l=2.52e-6 m=1
C_LVS_XC22_391 vcn bn9 cap_cmomi w=2.67e-6 l=2.52e-6 m=1
C_LVS_XC22_392 vcn bn9 cap_cmomi w=2.67e-6 l=2.52e-6 m=1
C_LVS_XC22_393 vcn bn9 cap_cmomi w=2.67e-6 l=2.52e-6 m=1
C_LVS_XC22_394 vcn bn9 cap_cmomi w=2.67e-6 l=2.52e-6 m=1
C_LVS_XC22_395 vcn bn9 cap_cmomi w=2.67e-6 l=2.52e-6 m=1
C_LVS_XC22_396 vcn bn9 cap_cmomi w=2.67e-6 l=2.52e-6 m=1
C_LVS_XC22_397 vcn bn9 cap_cmomi w=2.67e-6 l=2.52e-6 m=1
C_LVS_XC22_398 vcn bn9 cap_cmomi w=2.67e-6 l=2.52e-6 m=1
C_LVS_XC22_399 vcn bn9 cap_cmomi w=2.67e-6 l=2.52e-6 m=1
C_LVS_XC22_400 vcn bn9 cap_cmomi w=2.67e-6 l=2.52e-6 m=1
C_LVS_XC22_401 vcn bn9 cap_cmomi w=2.67e-6 l=2.52e-6 m=1
C_LVS_XC22_402 vcn bn9 cap_cmomi w=2.67e-6 l=2.52e-6 m=1
C_LVS_XC22_403 vcn bn9 cap_cmomi w=2.67e-6 l=2.52e-6 m=1
C_LVS_XC22_404 vcn bn9 cap_cmomi w=2.67e-6 l=2.52e-6 m=1
C_LVS_XC22_405 vcn bn9 cap_cmomi w=2.67e-6 l=2.52e-6 m=1
C_LVS_XC22_406 vcn bn9 cap_cmomi w=2.67e-6 l=2.52e-6 m=1
C_LVS_XC22_407 vcn bn9 cap_cmomi w=2.67e-6 l=2.52e-6 m=1
C_LVS_XC22_408 vcn bn9 cap_cmomi w=2.67e-6 l=2.52e-6 m=1
C_LVS_XC22_409 vcn bn9 cap_cmomi w=2.67e-6 l=2.52e-6 m=1
C_LVS_XC22_410 vcn bn9 cap_cmomi w=2.67e-6 l=2.52e-6 m=1
C_LVS_XC22_411 vcn bn9 cap_cmomi w=2.67e-6 l=2.52e-6 m=1
C_LVS_XC22_412 vcn bn9 cap_cmomi w=2.67e-6 l=2.52e-6 m=1
C_LVS_XC22_413 vcn bn9 cap_cmomi w=2.67e-6 l=2.52e-6 m=1
C_LVS_XC22_414 vcn bn9 cap_cmomi w=2.67e-6 l=2.52e-6 m=1
C_LVS_XC22_415 vcn bn9 cap_cmomi w=2.67e-6 l=2.52e-6 m=1
C_LVS_XC22_416 vcn bn9 cap_cmomi w=2.67e-6 l=2.52e-6 m=1
C_LVS_XC22_417 vcn bn9 cap_cmomi w=2.67e-6 l=2.52e-6 m=1
C_LVS_XC22_418 vcn bn9 cap_cmomi w=2.67e-6 l=2.52e-6 m=1
C_LVS_XC22_419 vcn bn9 cap_cmomi w=2.67e-6 l=2.52e-6 m=1
C_LVS_XC22_420 vcn bn9 cap_cmomi w=2.67e-6 l=2.52e-6 m=1
C_LVS_XC22_421 vcn bn9 cap_cmomi w=2.67e-6 l=2.52e-6 m=1
C_LVS_XC22_422 vcn bn9 cap_cmomi w=2.67e-6 l=2.52e-6 m=1
C_LVS_XC22_423 vcn bn9 cap_cmomi w=2.67e-6 l=2.52e-6 m=1
C_LVS_XC22_424 vcn bn9 cap_cmomi w=2.67e-6 l=2.52e-6 m=1
C_LVS_XC22_425 vcn bn9 cap_cmomi w=2.67e-6 l=2.52e-6 m=1
C_LVS_XC22_426 vcn bn9 cap_cmomi w=2.67e-6 l=2.52e-6 m=1
C_LVS_XC22_427 vcn bn9 cap_cmomi w=2.67e-6 l=2.52e-6 m=1
C_LVS_XC22_428 vcn bn9 cap_cmomi w=2.67e-6 l=2.52e-6 m=1
C_LVS_XC22_429 vcn bn9 cap_cmomi w=2.67e-6 l=2.52e-6 m=1
C_LVS_XC22_430 vcn bn9 cap_cmomi w=2.67e-6 l=2.52e-6 m=1
C_LVS_XC22_431 vcn bn9 cap_cmomi w=2.67e-6 l=2.52e-6 m=1
C_LVS_XC22_432 vcn bn9 cap_cmomi w=2.67e-6 l=2.52e-6 m=1
C_LVS_XC22_433 vcn bn9 cap_cmomi w=2.67e-6 l=2.52e-6 m=1
C_LVS_XC22_434 vcn bn9 cap_cmomi w=2.67e-6 l=2.52e-6 m=1
C_LVS_XC22_435 vcn bn9 cap_cmomi w=2.67e-6 l=2.52e-6 m=1
C_LVS_XC22_436 vcn bn9 cap_cmomi w=2.67e-6 l=2.52e-6 m=1
C_LVS_XC22_437 vcn bn9 cap_cmomi w=2.67e-6 l=2.52e-6 m=1
C_LVS_XC22_438 vcn bn9 cap_cmomi w=2.67e-6 l=2.52e-6 m=1
C_LVS_XC22_439 vcn bn9 cap_cmomi w=2.67e-6 l=2.52e-6 m=1
C_LVS_XC22_440 vcn bn9 cap_cmomi w=2.67e-6 l=2.52e-6 m=1
C_LVS_XC22_441 vcn bn9 cap_cmomi w=2.67e-6 l=2.52e-6 m=1
C_LVS_XC22_442 vcn bn9 cap_cmomi w=2.67e-6 l=2.52e-6 m=1
C_LVS_XC22_443 vcn bn9 cap_cmomi w=2.67e-6 l=2.52e-6 m=1
C_LVS_XC22_444 vcn bn9 cap_cmomi w=2.67e-6 l=2.52e-6 m=1
C_LVS_XC22_445 vcn bn9 cap_cmomi w=2.67e-6 l=2.52e-6 m=1
C_LVS_XC22_446 vcn bn9 cap_cmomi w=2.67e-6 l=2.52e-6 m=1
C_LVS_XC22_447 vcn bn9 cap_cmomi w=2.67e-6 l=2.52e-6 m=1
C_LVS_XC22_448 vcn bn9 cap_cmomi w=2.67e-6 l=2.52e-6 m=1
C_LVS_XC22_449 vcn bn9 cap_cmomi w=2.67e-6 l=2.52e-6 m=1
C_LVS_XC22_450 vcn bn9 cap_cmomi w=2.67e-6 l=2.52e-6 m=1
C_LVS_XC22_451 vcn bn9 cap_cmomi w=2.67e-6 l=2.52e-6 m=1
C_LVS_XC22_452 vcn bn9 cap_cmomi w=2.67e-6 l=2.52e-6 m=1
C_LVS_XC22_453 vcn bn9 cap_cmomi w=2.67e-6 l=2.52e-6 m=1
C_LVS_XC22_454 vcn bn9 cap_cmomi w=2.67e-6 l=2.52e-6 m=1
C_LVS_XC22_455 vcn bn9 cap_cmomi w=2.67e-6 l=2.52e-6 m=1
C_LVS_XC22_456 vcn bn9 cap_cmomi w=2.67e-6 l=2.52e-6 m=1
C_LVS_XC22_457 vcn bn9 cap_cmomi w=2.67e-6 l=2.52e-6 m=1
C_LVS_XC22_458 vcn bn9 cap_cmomi w=2.67e-6 l=2.52e-6 m=1
C_LVS_XC22_459 vcn bn9 cap_cmomi w=2.67e-6 l=2.52e-6 m=1
C_LVS_XC22_460 vcn bn9 cap_cmomi w=2.67e-6 l=2.52e-6 m=1
C_LVS_XC22_461 vcn bn9 cap_cmomi w=2.67e-6 l=2.52e-6 m=1
C_LVS_XC22_462 vcn bn9 cap_cmomi w=2.67e-6 l=2.52e-6 m=1
C_LVS_XC22_463 vcn bn9 cap_cmomi w=2.67e-6 l=2.52e-6 m=1
C_LVS_XC22_464 vcn bn9 cap_cmomi w=2.67e-6 l=2.52e-6 m=1
C_LVS_XC22_465 vcn bn9 cap_cmomi w=2.67e-6 l=2.52e-6 m=1
C_LVS_XC22_466 vcn bn9 cap_cmomi w=2.67e-6 l=2.52e-6 m=1
C_LVS_XC22_467 vcn bn9 cap_cmomi w=2.67e-6 l=2.52e-6 m=1
C_LVS_XC22_468 vcn bn9 cap_cmomi w=2.67e-6 l=2.52e-6 m=1
C_LVS_XC22_469 vcn bn9 cap_cmomi w=2.67e-6 l=2.52e-6 m=1
C_LVS_XC22_470 vcn bn9 cap_cmomi w=2.67e-6 l=2.52e-6 m=1
C_LVS_XC22_471 vcn bn9 cap_cmomi w=2.67e-6 l=2.52e-6 m=1
C_LVS_XC22_472 vcn bn9 cap_cmomi w=2.67e-6 l=2.52e-6 m=1
C_LVS_XC22_473 vcn bn9 cap_cmomi w=2.67e-6 l=2.52e-6 m=1
C_LVS_XC22_474 vcn bn9 cap_cmomi w=2.67e-6 l=2.52e-6 m=1
C_LVS_XC22_475 vcn bn9 cap_cmomi w=2.67e-6 l=2.52e-6 m=1
C_LVS_XC22_476 vcn bn9 cap_cmomi w=2.67e-6 l=2.52e-6 m=1
C_LVS_XC22_477 vcn bn9 cap_cmomi w=2.67e-6 l=2.52e-6 m=1
C_LVS_XC22_478 vcn bn9 cap_cmomi w=2.67e-6 l=2.52e-6 m=1
C_LVS_XC22_479 vcn bn9 cap_cmomi w=2.67e-6 l=2.52e-6 m=1
C_LVS_XC22_480 vcn bn9 cap_cmomi w=2.67e-6 l=2.52e-6 m=1
C_LVS_XC22_481 vcn bn9 cap_cmomi w=2.67e-6 l=2.52e-6 m=1
C_LVS_XC22_482 vcn bn9 cap_cmomi w=2.67e-6 l=2.52e-6 m=1
C_LVS_XC22_483 vcn bn9 cap_cmomi w=2.67e-6 l=2.52e-6 m=1
C_LVS_XC22_484 vcn bn9 cap_cmomi w=2.67e-6 l=2.52e-6 m=1
C_LVS_XC22_485 vcn bn9 cap_cmomi w=2.67e-6 l=2.52e-6 m=1
C_LVS_XC22_486 vcn bn9 cap_cmomi w=2.67e-6 l=2.52e-6 m=1
C_LVS_XC22_487 vcn bn9 cap_cmomi w=2.67e-6 l=2.52e-6 m=1
C_LVS_XC22_488 vcn bn9 cap_cmomi w=2.67e-6 l=2.52e-6 m=1
C_LVS_XC22_489 vcn bn9 cap_cmomi w=2.67e-6 l=2.52e-6 m=1
C_LVS_XC22_490 vcn bn9 cap_cmomi w=2.67e-6 l=2.52e-6 m=1
C_LVS_XC22_491 vcn bn9 cap_cmomi w=2.67e-6 l=2.52e-6 m=1
C_LVS_XC22_492 vcn bn9 cap_cmomi w=2.67e-6 l=2.52e-6 m=1
C_LVS_XC22_493 vcn bn9 cap_cmomi w=2.67e-6 l=2.52e-6 m=1
C_LVS_XC22_494 vcn bn9 cap_cmomi w=2.67e-6 l=2.52e-6 m=1
C_LVS_XC22_495 vcn bn9 cap_cmomi w=2.67e-6 l=2.52e-6 m=1
C_LVS_XC22_496 vcn bn9 cap_cmomi w=2.67e-6 l=2.52e-6 m=1
C_LVS_XC22_497 vcn bn9 cap_cmomi w=2.67e-6 l=2.52e-6 m=1
C_LVS_XC22_498 vcn bn9 cap_cmomi w=2.67e-6 l=2.52e-6 m=1
C_LVS_XC22_499 vcn bn9 cap_cmomi w=2.67e-6 l=2.52e-6 m=1
C_LVS_XC22_500 vcn bn9 cap_cmomi w=2.67e-6 l=2.52e-6 m=1
C_LVS_XC22_501 vcn bn9 cap_cmomi w=2.67e-6 l=2.52e-6 m=1
C_LVS_XC22_502 vcn bn9 cap_cmomi w=2.67e-6 l=2.52e-6 m=1
C_LVS_XC22_503 vcn bn9 cap_cmomi w=2.67e-6 l=2.52e-6 m=1
C_LVS_XC22_504 vcn bn9 cap_cmomi w=2.67e-6 l=2.52e-6 m=1
C_LVS_XC22_505 vcn bn9 cap_cmomi w=2.67e-6 l=2.52e-6 m=1
C_LVS_XC22_506 vcn bn9 cap_cmomi w=2.67e-6 l=2.52e-6 m=1
C_LVS_XC22_507 vcn bn9 cap_cmomi w=2.67e-6 l=2.52e-6 m=1
C_LVS_XC22_508 vcn bn9 cap_cmomi w=2.67e-6 l=2.52e-6 m=1
C_LVS_XC22_509 vcn bn9 cap_cmomi w=2.67e-6 l=2.52e-6 m=1
C_LVS_XC22_510 vcn bn9 cap_cmomi w=2.67e-6 l=2.52e-6 m=1
C_LVS_XC22_511 vcn bn9 cap_cmomi w=2.67e-6 l=2.52e-6 m=1
C_LVS_XC22_512 vcn bn9 cap_cmomi w=2.67e-6 l=2.52e-6 m=1
C_LVS_XC22_513 vcn bn9 cap_cmomi w=2.67e-6 l=2.52e-6 m=1
C_LVS_XC22_514 vcn bn9 cap_cmomi w=2.67e-6 l=2.52e-6 m=1
C_LVS_XC22_515 vcn bn9 cap_cmomi w=2.67e-6 l=2.52e-6 m=1
.ends
