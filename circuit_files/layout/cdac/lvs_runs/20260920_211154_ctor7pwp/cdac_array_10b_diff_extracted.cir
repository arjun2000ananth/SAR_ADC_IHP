* Extracted by KLayout with SG13CMOS5L LVS runset on : 20/09/2026 21:11

.SUBCKT cdac_array_10b_diff bn0 bn1 bn2 bn3 bn4 bn5 bn6 bn7 bn8 bn9 bnd bp0 bp1
+ bp2 bp3 bp4 bp5 bp6 bp7 bp8 bp9 bpd vcn vcp
C$1 bn9 vcn cap_cmomi w=3.31u l=4.32u A=0p P=0u m=1
C$2 bn9 vcn cap_cmomi w=3.31u l=4.32u A=0p P=0u m=1
C$3 bn9 vcn cap_cmomi w=3.31u l=4.32u A=0p P=0u m=1
C$4 vcp bp9 cap_cmomi w=3.31u l=4.32u A=0p P=0u m=1
C$5 bn9 vcn cap_cmomi w=3.31u l=4.32u A=0p P=0u m=1
C$6 vcp bp7 cap_cmomi w=3.31u l=4.32u A=0p P=0u m=1
C$7 bn7 vcn cap_cmomi w=3.31u l=4.32u A=0p P=0u m=1
C$8 vcp bp9 cap_cmomi w=3.31u l=4.32u A=0p P=0u m=1
C$9 bn9 vcn cap_cmomi w=3.31u l=4.32u A=0p P=0u m=1
C$10 vcp bp5 cap_cmomi w=3.31u l=4.32u A=0p P=0u m=1
C$11 bn5 vcn cap_cmomi w=3.31u l=4.32u A=0p P=0u m=1
C$12 vcp bp9 cap_cmomi w=3.31u l=4.32u A=0p P=0u m=1
C$13 bn9 vcn cap_cmomi w=3.31u l=4.32u A=0p P=0u m=1
C$14 vcp bp7 cap_cmomi w=3.31u l=4.32u A=0p P=0u m=1
C$15 bn7 vcn cap_cmomi w=3.31u l=4.32u A=0p P=0u m=1
C$16 vcp bp9 cap_cmomi w=3.31u l=4.32u A=0p P=0u m=1
C$17 bn9 vcn cap_cmomi w=3.31u l=4.32u A=0p P=0u m=1
C$18 vcp bp4 cap_cmomi w=3.31u l=4.32u A=0p P=0u m=1
C$19 bn4 vcn cap_cmomi w=3.31u l=4.32u A=0p P=0u m=1
C$20 vcp bp9 cap_cmomi w=3.31u l=4.32u A=0p P=0u m=1
C$21 bn9 vcn cap_cmomi w=3.31u l=4.32u A=0p P=0u m=1
C$22 vcp bp7 cap_cmomi w=3.31u l=4.32u A=0p P=0u m=1
C$23 bn7 vcn cap_cmomi w=3.31u l=4.32u A=0p P=0u m=1
C$24 vcp bp9 cap_cmomi w=3.31u l=4.32u A=0p P=0u m=1
C$25 bn9 vcn cap_cmomi w=3.31u l=4.32u A=0p P=0u m=1
C$26 vcp bp5 cap_cmomi w=3.31u l=4.32u A=0p P=0u m=1
C$27 bn5 vcn cap_cmomi w=3.31u l=4.32u A=0p P=0u m=1
C$28 vcp bp9 cap_cmomi w=3.31u l=4.32u A=0p P=0u m=1
C$29 bn9 vcn cap_cmomi w=3.31u l=4.32u A=0p P=0u m=1
C$30 vcp bp7 cap_cmomi w=3.31u l=4.32u A=0p P=0u m=1
C$31 bn7 vcn cap_cmomi w=3.31u l=4.32u A=0p P=0u m=1
C$32 vcp bp9 cap_cmomi w=3.31u l=4.32u A=0p P=0u m=1
C$33 bn9 vcn cap_cmomi w=3.31u l=4.32u A=0p P=0u m=1
C$34 vcp bp3 cap_cmomi w=3.31u l=4.32u A=0p P=0u m=1
C$35 bn3 vcn cap_cmomi w=3.31u l=4.32u A=0p P=0u m=1
C$36 vcp bp3 cap_cmomi w=3.31u l=4.32u A=0p P=0u m=1
C$37 bn3 vcn cap_cmomi w=3.31u l=4.32u A=0p P=0u m=1
C$38 vcp bp9 cap_cmomi w=3.31u l=4.32u A=0p P=0u m=1
C$39 bn9 vcn cap_cmomi w=3.31u l=4.32u A=0p P=0u m=1
C$40 vcp bp7 cap_cmomi w=3.31u l=4.32u A=0p P=0u m=1
C$41 bn7 vcn cap_cmomi w=3.31u l=4.32u A=0p P=0u m=1
C$42 vcp bp9 cap_cmomi w=3.31u l=4.32u A=0p P=0u m=1
C$43 bn9 vcn cap_cmomi w=3.31u l=4.32u A=0p P=0u m=1
C$44 vcp bp5 cap_cmomi w=3.31u l=4.32u A=0p P=0u m=1
C$45 bn5 vcn cap_cmomi w=3.31u l=4.32u A=0p P=0u m=1
C$46 vcp bp9 cap_cmomi w=3.31u l=4.32u A=0p P=0u m=1
C$47 bn9 vcn cap_cmomi w=3.31u l=4.32u A=0p P=0u m=1
C$48 vcp bp7 cap_cmomi w=3.31u l=4.32u A=0p P=0u m=1
C$49 bn7 vcn cap_cmomi w=3.31u l=4.32u A=0p P=0u m=1
C$50 vcp bp9 cap_cmomi w=3.31u l=4.32u A=0p P=0u m=1
C$51 bn9 vcn cap_cmomi w=3.31u l=4.32u A=0p P=0u m=1
C$52 vcp bp4 cap_cmomi w=3.31u l=4.32u A=0p P=0u m=1
C$53 bn4 vcn cap_cmomi w=3.31u l=4.32u A=0p P=0u m=1
C$54 vcp bp9 cap_cmomi w=3.31u l=4.32u A=0p P=0u m=1
C$55 bn9 vcn cap_cmomi w=3.31u l=4.32u A=0p P=0u m=1
C$56 vcp bp7 cap_cmomi w=3.31u l=4.32u A=0p P=0u m=1
C$57 bn7 vcn cap_cmomi w=3.31u l=4.32u A=0p P=0u m=1
C$58 vcp bp9 cap_cmomi w=3.31u l=4.32u A=0p P=0u m=1
C$59 bn9 vcn cap_cmomi w=3.31u l=4.32u A=0p P=0u m=1
C$60 vcp bp5 cap_cmomi w=3.31u l=4.32u A=0p P=0u m=1
C$61 bn5 vcn cap_cmomi w=3.31u l=4.32u A=0p P=0u m=1
C$62 vcp bp9 cap_cmomi w=3.31u l=4.32u A=0p P=0u m=1
C$63 bn9 vcn cap_cmomi w=3.31u l=4.32u A=0p P=0u m=1
C$64 vcp bp7 cap_cmomi w=3.31u l=4.32u A=0p P=0u m=1
C$65 bn7 vcn cap_cmomi w=3.31u l=4.32u A=0p P=0u m=1
C$66 vcp bp9 cap_cmomi w=3.31u l=4.32u A=0p P=0u m=1
C$67 bn9 vcn cap_cmomi w=3.31u l=4.32u A=0p P=0u m=1
C$68 vcp bp8 cap_cmomi w=3.31u l=4.32u A=0p P=0u m=1
C$69 bn8 vcn cap_cmomi w=3.31u l=4.32u A=0p P=0u m=1
C$70 vcp bp9 cap_cmomi w=3.31u l=4.32u A=0p P=0u m=1
C$71 bn9 vcn cap_cmomi w=3.31u l=4.32u A=0p P=0u m=1
C$72 vcp bp8 cap_cmomi w=3.31u l=4.32u A=0p P=0u m=1
C$73 bn8 vcn cap_cmomi w=3.31u l=4.32u A=0p P=0u m=1
C$74 vcp bp9 cap_cmomi w=3.31u l=4.32u A=0p P=0u m=1
C$75 bn9 vcn cap_cmomi w=3.31u l=4.32u A=0p P=0u m=1
C$76 vcp bp8 cap_cmomi w=3.31u l=4.32u A=0p P=0u m=1
C$77 bn8 vcn cap_cmomi w=3.31u l=4.32u A=0p P=0u m=1
C$78 vcp bp9 cap_cmomi w=3.31u l=4.32u A=0p P=0u m=1
C$79 bn9 vcn cap_cmomi w=3.31u l=4.32u A=0p P=0u m=1
C$80 vcp bp8 cap_cmomi w=3.31u l=4.32u A=0p P=0u m=1
C$81 bn8 vcn cap_cmomi w=3.31u l=4.32u A=0p P=0u m=1
C$82 vcp bp9 cap_cmomi w=3.31u l=4.32u A=0p P=0u m=1
C$83 bn9 vcn cap_cmomi w=3.31u l=4.32u A=0p P=0u m=1
C$84 vcp bp8 cap_cmomi w=3.31u l=4.32u A=0p P=0u m=1
C$85 bn8 vcn cap_cmomi w=3.31u l=4.32u A=0p P=0u m=1
C$86 vcp bp9 cap_cmomi w=3.31u l=4.32u A=0p P=0u m=1
C$87 bn9 vcn cap_cmomi w=3.31u l=4.32u A=0p P=0u m=1
C$88 vcp bp8 cap_cmomi w=3.31u l=4.32u A=0p P=0u m=1
C$89 bn8 vcn cap_cmomi w=3.31u l=4.32u A=0p P=0u m=1
C$90 vcp bp9 cap_cmomi w=3.31u l=4.32u A=0p P=0u m=1
C$91 bn9 vcn cap_cmomi w=3.31u l=4.32u A=0p P=0u m=1
C$92 vcp bp8 cap_cmomi w=3.31u l=4.32u A=0p P=0u m=1
C$93 bn8 vcn cap_cmomi w=3.31u l=4.32u A=0p P=0u m=1
C$94 vcp bp9 cap_cmomi w=3.31u l=4.32u A=0p P=0u m=1
C$95 bn9 vcn cap_cmomi w=3.31u l=4.32u A=0p P=0u m=1
C$96 vcp bp8 cap_cmomi w=3.31u l=4.32u A=0p P=0u m=1
C$97 bn8 vcn cap_cmomi w=3.31u l=4.32u A=0p P=0u m=1
C$98 vcp bp9 cap_cmomi w=3.31u l=4.32u A=0p P=0u m=1
C$99 bn9 vcn cap_cmomi w=3.31u l=4.32u A=0p P=0u m=1
C$100 vcp bp9 cap_cmomi w=3.31u l=4.32u A=0p P=0u m=1
C$101 bn9 vcn cap_cmomi w=3.31u l=4.32u A=0p P=0u m=1
C$102 vcp bp8 cap_cmomi w=3.31u l=4.32u A=0p P=0u m=1
C$103 bn8 vcn cap_cmomi w=3.31u l=4.32u A=0p P=0u m=1
C$104 vcp bp9 cap_cmomi w=3.31u l=4.32u A=0p P=0u m=1
C$105 bn9 vcn cap_cmomi w=3.31u l=4.32u A=0p P=0u m=1
C$106 vcp bp8 cap_cmomi w=3.31u l=4.32u A=0p P=0u m=1
C$107 bn8 vcn cap_cmomi w=3.31u l=4.32u A=0p P=0u m=1
C$108 vcp bp9 cap_cmomi w=3.31u l=4.32u A=0p P=0u m=1
C$109 bn9 vcn cap_cmomi w=3.31u l=4.32u A=0p P=0u m=1
C$110 vcp bp8 cap_cmomi w=3.31u l=4.32u A=0p P=0u m=1
C$111 bn8 vcn cap_cmomi w=3.31u l=4.32u A=0p P=0u m=1
C$112 vcp bp9 cap_cmomi w=3.31u l=4.32u A=0p P=0u m=1
C$113 bn9 vcn cap_cmomi w=3.31u l=4.32u A=0p P=0u m=1
C$114 vcp bp8 cap_cmomi w=3.31u l=4.32u A=0p P=0u m=1
C$115 bn8 vcn cap_cmomi w=3.31u l=4.32u A=0p P=0u m=1
C$116 vcp bp9 cap_cmomi w=3.31u l=4.32u A=0p P=0u m=1
C$117 bn9 vcn cap_cmomi w=3.31u l=4.32u A=0p P=0u m=1
C$118 vcp bp8 cap_cmomi w=3.31u l=4.32u A=0p P=0u m=1
C$119 bn8 vcn cap_cmomi w=3.31u l=4.32u A=0p P=0u m=1
C$120 vcp bp9 cap_cmomi w=3.31u l=4.32u A=0p P=0u m=1
C$121 bn9 vcn cap_cmomi w=3.31u l=4.32u A=0p P=0u m=1
C$122 vcp bp8 cap_cmomi w=3.31u l=4.32u A=0p P=0u m=1
C$123 bn8 vcn cap_cmomi w=3.31u l=4.32u A=0p P=0u m=1
C$124 vcp bp9 cap_cmomi w=3.31u l=4.32u A=0p P=0u m=1
C$125 bn9 vcn cap_cmomi w=3.31u l=4.32u A=0p P=0u m=1
C$126 vcp bp8 cap_cmomi w=3.31u l=4.32u A=0p P=0u m=1
C$127 bn8 vcn cap_cmomi w=3.31u l=4.32u A=0p P=0u m=1
C$128 vcp bp9 cap_cmomi w=3.31u l=4.32u A=0p P=0u m=1
C$129 bn9 vcn cap_cmomi w=3.31u l=4.32u A=0p P=0u m=1
C$130 vcp bp8 cap_cmomi w=3.31u l=4.32u A=0p P=0u m=1
C$131 bn8 vcn cap_cmomi w=3.31u l=4.32u A=0p P=0u m=1
C$132 vcp bp9 cap_cmomi w=3.31u l=4.32u A=0p P=0u m=1
C$133 bn9 vcn cap_cmomi w=3.31u l=4.32u A=0p P=0u m=1
C$134 vcp bp6 cap_cmomi w=3.31u l=4.32u A=0p P=0u m=1
C$135 bn6 vcn cap_cmomi w=3.31u l=4.32u A=0p P=0u m=1
C$136 vcp bp9 cap_cmomi w=3.31u l=4.32u A=0p P=0u m=1
C$137 bn9 vcn cap_cmomi w=3.31u l=4.32u A=0p P=0u m=1
C$138 vcp bp7 cap_cmomi w=3.31u l=4.32u A=0p P=0u m=1
C$139 bn7 vcn cap_cmomi w=3.31u l=4.32u A=0p P=0u m=1
C$140 vcp bp9 cap_cmomi w=3.31u l=4.32u A=0p P=0u m=1
C$141 bn9 vcn cap_cmomi w=3.31u l=4.32u A=0p P=0u m=1
C$142 vcp bp6 cap_cmomi w=3.31u l=4.32u A=0p P=0u m=1
C$143 bn6 vcn cap_cmomi w=3.31u l=4.32u A=0p P=0u m=1
C$144 vcp bp9 cap_cmomi w=3.31u l=4.32u A=0p P=0u m=1
C$145 bn9 vcn cap_cmomi w=3.31u l=4.32u A=0p P=0u m=1
C$146 vcp bp7 cap_cmomi w=3.31u l=4.32u A=0p P=0u m=1
C$147 bn7 vcn cap_cmomi w=3.31u l=4.32u A=0p P=0u m=1
C$148 vcp bp9 cap_cmomi w=3.31u l=4.32u A=0p P=0u m=1
C$149 bn9 vcn cap_cmomi w=3.31u l=4.32u A=0p P=0u m=1
C$150 vcp bp6 cap_cmomi w=3.31u l=4.32u A=0p P=0u m=1
C$151 bn6 vcn cap_cmomi w=3.31u l=4.32u A=0p P=0u m=1
C$152 vcp bp9 cap_cmomi w=3.31u l=4.32u A=0p P=0u m=1
C$153 bn9 vcn cap_cmomi w=3.31u l=4.32u A=0p P=0u m=1
C$154 vcp bp7 cap_cmomi w=3.31u l=4.32u A=0p P=0u m=1
C$155 bn7 vcn cap_cmomi w=3.31u l=4.32u A=0p P=0u m=1
C$156 vcp bp9 cap_cmomi w=3.31u l=4.32u A=0p P=0u m=1
C$157 bn9 vcn cap_cmomi w=3.31u l=4.32u A=0p P=0u m=1
C$158 vcp bp6 cap_cmomi w=3.31u l=4.32u A=0p P=0u m=1
C$159 bn6 vcn cap_cmomi w=3.31u l=4.32u A=0p P=0u m=1
C$160 vcp bp9 cap_cmomi w=3.31u l=4.32u A=0p P=0u m=1
C$161 bn9 vcn cap_cmomi w=3.31u l=4.32u A=0p P=0u m=1
C$162 vcp bp7 cap_cmomi w=3.31u l=4.32u A=0p P=0u m=1
C$163 bn7 vcn cap_cmomi w=3.31u l=4.32u A=0p P=0u m=1
C$164 vcp bp7 cap_cmomi w=3.31u l=4.32u A=0p P=0u m=1
C$165 bn7 vcn cap_cmomi w=3.31u l=4.32u A=0p P=0u m=1
C$166 vcp bp9 cap_cmomi w=3.31u l=4.32u A=0p P=0u m=1
C$167 bn9 vcn cap_cmomi w=3.31u l=4.32u A=0p P=0u m=1
C$168 vcp bp6 cap_cmomi w=3.31u l=4.32u A=0p P=0u m=1
C$169 bn6 vcn cap_cmomi w=3.31u l=4.32u A=0p P=0u m=1
C$170 vcp bp9 cap_cmomi w=3.31u l=4.32u A=0p P=0u m=1
C$171 bn9 vcn cap_cmomi w=3.31u l=4.32u A=0p P=0u m=1
C$172 vcp bp7 cap_cmomi w=3.31u l=4.32u A=0p P=0u m=1
C$173 bn7 vcn cap_cmomi w=3.31u l=4.32u A=0p P=0u m=1
C$174 vcp bp9 cap_cmomi w=3.31u l=4.32u A=0p P=0u m=1
C$175 bn9 vcn cap_cmomi w=3.31u l=4.32u A=0p P=0u m=1
C$176 vcp bp6 cap_cmomi w=3.31u l=4.32u A=0p P=0u m=1
C$177 bn6 vcn cap_cmomi w=3.31u l=4.32u A=0p P=0u m=1
C$178 vcp bp9 cap_cmomi w=3.31u l=4.32u A=0p P=0u m=1
C$179 bn9 vcn cap_cmomi w=3.31u l=4.32u A=0p P=0u m=1
C$180 vcp bp7 cap_cmomi w=3.31u l=4.32u A=0p P=0u m=1
C$181 bn7 vcn cap_cmomi w=3.31u l=4.32u A=0p P=0u m=1
C$182 vcp bp9 cap_cmomi w=3.31u l=4.32u A=0p P=0u m=1
C$183 bn9 vcn cap_cmomi w=3.31u l=4.32u A=0p P=0u m=1
C$184 vcp bp6 cap_cmomi w=3.31u l=4.32u A=0p P=0u m=1
C$185 bn6 vcn cap_cmomi w=3.31u l=4.32u A=0p P=0u m=1
C$186 vcp bp9 cap_cmomi w=3.31u l=4.32u A=0p P=0u m=1
C$187 bn9 vcn cap_cmomi w=3.31u l=4.32u A=0p P=0u m=1
C$188 vcp bp7 cap_cmomi w=3.31u l=4.32u A=0p P=0u m=1
C$189 bn7 vcn cap_cmomi w=3.31u l=4.32u A=0p P=0u m=1
C$190 vcp bp9 cap_cmomi w=3.31u l=4.32u A=0p P=0u m=1
C$191 bn9 vcn cap_cmomi w=3.31u l=4.32u A=0p P=0u m=1
C$192 vcp bp6 cap_cmomi w=3.31u l=4.32u A=0p P=0u m=1
C$193 bn6 vcn cap_cmomi w=3.31u l=4.32u A=0p P=0u m=1
C$194 vcp bp9 cap_cmomi w=3.31u l=4.32u A=0p P=0u m=1
C$195 bn9 vcn cap_cmomi w=3.31u l=4.32u A=0p P=0u m=1
C$196 vcp bp8 cap_cmomi w=3.31u l=4.32u A=0p P=0u m=1
C$197 bn8 vcn cap_cmomi w=3.31u l=4.32u A=0p P=0u m=1
C$198 vcp bp9 cap_cmomi w=3.31u l=4.32u A=0p P=0u m=1
C$199 bn9 vcn cap_cmomi w=3.31u l=4.32u A=0p P=0u m=1
C$200 vcp bp8 cap_cmomi w=3.31u l=4.32u A=0p P=0u m=1
C$201 bn8 vcn cap_cmomi w=3.31u l=4.32u A=0p P=0u m=1
C$202 vcp bp9 cap_cmomi w=3.31u l=4.32u A=0p P=0u m=1
C$203 bn9 vcn cap_cmomi w=3.31u l=4.32u A=0p P=0u m=1
C$204 vcp bp8 cap_cmomi w=3.31u l=4.32u A=0p P=0u m=1
C$205 bn8 vcn cap_cmomi w=3.31u l=4.32u A=0p P=0u m=1
C$206 vcp bp9 cap_cmomi w=3.31u l=4.32u A=0p P=0u m=1
C$207 bn9 vcn cap_cmomi w=3.31u l=4.32u A=0p P=0u m=1
C$208 vcp bp8 cap_cmomi w=3.31u l=4.32u A=0p P=0u m=1
C$209 bn8 vcn cap_cmomi w=3.31u l=4.32u A=0p P=0u m=1
C$210 vcp bp9 cap_cmomi w=3.31u l=4.32u A=0p P=0u m=1
C$211 bn9 vcn cap_cmomi w=3.31u l=4.32u A=0p P=0u m=1
C$212 vcp bp8 cap_cmomi w=3.31u l=4.32u A=0p P=0u m=1
C$213 bn8 vcn cap_cmomi w=3.31u l=4.32u A=0p P=0u m=1
C$214 vcp bp9 cap_cmomi w=3.31u l=4.32u A=0p P=0u m=1
C$215 bn9 vcn cap_cmomi w=3.31u l=4.32u A=0p P=0u m=1
C$216 vcp bp8 cap_cmomi w=3.31u l=4.32u A=0p P=0u m=1
C$217 bn8 vcn cap_cmomi w=3.31u l=4.32u A=0p P=0u m=1
C$218 vcp bp9 cap_cmomi w=3.31u l=4.32u A=0p P=0u m=1
C$219 bn9 vcn cap_cmomi w=3.31u l=4.32u A=0p P=0u m=1
C$220 vcp bp8 cap_cmomi w=3.31u l=4.32u A=0p P=0u m=1
C$221 bn8 vcn cap_cmomi w=3.31u l=4.32u A=0p P=0u m=1
C$222 vcp bp9 cap_cmomi w=3.31u l=4.32u A=0p P=0u m=1
C$223 bn9 vcn cap_cmomi w=3.31u l=4.32u A=0p P=0u m=1
C$224 vcp bp8 cap_cmomi w=3.31u l=4.32u A=0p P=0u m=1
C$225 bn8 vcn cap_cmomi w=3.31u l=4.32u A=0p P=0u m=1
C$226 vcp bp9 cap_cmomi w=3.31u l=4.32u A=0p P=0u m=1
C$227 bn9 vcn cap_cmomi w=3.31u l=4.32u A=0p P=0u m=1
C$228 vcp bp9 cap_cmomi w=3.31u l=4.32u A=0p P=0u m=1
C$229 bn9 vcn cap_cmomi w=3.31u l=4.32u A=0p P=0u m=1
C$230 vcp bp8 cap_cmomi w=3.31u l=4.32u A=0p P=0u m=1
C$231 bn8 vcn cap_cmomi w=3.31u l=4.32u A=0p P=0u m=1
C$232 vcp bp9 cap_cmomi w=3.31u l=4.32u A=0p P=0u m=1
C$233 bn9 vcn cap_cmomi w=3.31u l=4.32u A=0p P=0u m=1
C$234 vcp bp8 cap_cmomi w=3.31u l=4.32u A=0p P=0u m=1
C$235 bn8 vcn cap_cmomi w=3.31u l=4.32u A=0p P=0u m=1
C$236 vcp bp9 cap_cmomi w=3.31u l=4.32u A=0p P=0u m=1
C$237 bn9 vcn cap_cmomi w=3.31u l=4.32u A=0p P=0u m=1
C$238 vcp bp8 cap_cmomi w=3.31u l=4.32u A=0p P=0u m=1
C$239 bn8 vcn cap_cmomi w=3.31u l=4.32u A=0p P=0u m=1
C$240 vcp bp9 cap_cmomi w=3.31u l=4.32u A=0p P=0u m=1
C$241 bn9 vcn cap_cmomi w=3.31u l=4.32u A=0p P=0u m=1
C$242 vcp bp8 cap_cmomi w=3.31u l=4.32u A=0p P=0u m=1
C$243 bn8 vcn cap_cmomi w=3.31u l=4.32u A=0p P=0u m=1
C$244 vcp bp9 cap_cmomi w=3.31u l=4.32u A=0p P=0u m=1
C$245 bn9 vcn cap_cmomi w=3.31u l=4.32u A=0p P=0u m=1
C$246 vcp bp8 cap_cmomi w=3.31u l=4.32u A=0p P=0u m=1
C$247 bn8 vcn cap_cmomi w=3.31u l=4.32u A=0p P=0u m=1
C$248 vcp bp9 cap_cmomi w=3.31u l=4.32u A=0p P=0u m=1
C$249 bn9 vcn cap_cmomi w=3.31u l=4.32u A=0p P=0u m=1
C$250 vcp bp8 cap_cmomi w=3.31u l=4.32u A=0p P=0u m=1
C$251 bn8 vcn cap_cmomi w=3.31u l=4.32u A=0p P=0u m=1
C$252 vcp bp9 cap_cmomi w=3.31u l=4.32u A=0p P=0u m=1
C$253 bn9 vcn cap_cmomi w=3.31u l=4.32u A=0p P=0u m=1
C$254 vcp bp8 cap_cmomi w=3.31u l=4.32u A=0p P=0u m=1
C$255 bn8 vcn cap_cmomi w=3.31u l=4.32u A=0p P=0u m=1
C$256 vcp bp9 cap_cmomi w=3.31u l=4.32u A=0p P=0u m=1
C$257 bn9 vcn cap_cmomi w=3.31u l=4.32u A=0p P=0u m=1
C$258 vcp bp8 cap_cmomi w=3.31u l=4.32u A=0p P=0u m=1
C$259 bn8 vcn cap_cmomi w=3.31u l=4.32u A=0p P=0u m=1
C$260 vcp bp9 cap_cmomi w=3.31u l=4.32u A=0p P=0u m=1
C$261 bn9 vcn cap_cmomi w=3.31u l=4.32u A=0p P=0u m=1
C$262 vcp bp7 cap_cmomi w=3.31u l=4.32u A=0p P=0u m=1
C$263 bn7 vcn cap_cmomi w=3.31u l=4.32u A=0p P=0u m=1
C$264 vcp bp9 cap_cmomi w=3.31u l=4.32u A=0p P=0u m=1
C$265 bn9 vcn cap_cmomi w=3.31u l=4.32u A=0p P=0u m=1
C$266 vcp bp5 cap_cmomi w=3.31u l=4.32u A=0p P=0u m=1
C$267 bn5 vcn cap_cmomi w=3.31u l=4.32u A=0p P=0u m=1
C$268 vcp bp9 cap_cmomi w=3.31u l=4.32u A=0p P=0u m=1
C$269 bn9 vcn cap_cmomi w=3.31u l=4.32u A=0p P=0u m=1
C$270 vcp bp7 cap_cmomi w=3.31u l=4.32u A=0p P=0u m=1
C$271 bn7 vcn cap_cmomi w=3.31u l=4.32u A=0p P=0u m=1
C$272 vcp bp9 cap_cmomi w=3.31u l=4.32u A=0p P=0u m=1
C$273 bn9 vcn cap_cmomi w=3.31u l=4.32u A=0p P=0u m=1
C$274 vcp bp6 cap_cmomi w=3.31u l=4.32u A=0p P=0u m=1
C$275 bn6 vcn cap_cmomi w=3.31u l=4.32u A=0p P=0u m=1
C$276 vcp bp9 cap_cmomi w=3.31u l=4.32u A=0p P=0u m=1
C$277 bn9 vcn cap_cmomi w=3.31u l=4.32u A=0p P=0u m=1
C$278 vcp bp7 cap_cmomi w=3.31u l=4.32u A=0p P=0u m=1
C$279 bn7 vcn cap_cmomi w=3.31u l=4.32u A=0p P=0u m=1
C$280 vcp bp9 cap_cmomi w=3.31u l=4.32u A=0p P=0u m=1
C$281 bn9 vcn cap_cmomi w=3.31u l=4.32u A=0p P=0u m=1
C$282 vcp bp4 cap_cmomi w=3.31u l=4.32u A=0p P=0u m=1
C$283 bn4 vcn cap_cmomi w=3.31u l=4.32u A=0p P=0u m=1
C$284 vcp bp9 cap_cmomi w=3.31u l=4.32u A=0p P=0u m=1
C$285 bn9 vcn cap_cmomi w=3.31u l=4.32u A=0p P=0u m=1
C$286 vcp bp7 cap_cmomi w=3.31u l=4.32u A=0p P=0u m=1
C$287 bn7 vcn cap_cmomi w=3.31u l=4.32u A=0p P=0u m=1
C$288 vcp bp9 cap_cmomi w=3.31u l=4.32u A=0p P=0u m=1
C$289 bn9 vcn cap_cmomi w=3.31u l=4.32u A=0p P=0u m=1
C$290 vcp bp5 cap_cmomi w=3.31u l=4.32u A=0p P=0u m=1
C$291 bn5 vcn cap_cmomi w=3.31u l=4.32u A=0p P=0u m=1
C$292 vcp bp5 cap_cmomi w=3.31u l=4.32u A=0p P=0u m=1
C$293 bn5 vcn cap_cmomi w=3.31u l=4.32u A=0p P=0u m=1
C$294 vcp bp9 cap_cmomi w=3.31u l=4.32u A=0p P=0u m=1
C$295 bn9 vcn cap_cmomi w=3.31u l=4.32u A=0p P=0u m=1
C$296 vcp bp7 cap_cmomi w=3.31u l=4.32u A=0p P=0u m=1
C$297 bn7 vcn cap_cmomi w=3.31u l=4.32u A=0p P=0u m=1
C$298 vcp bp9 cap_cmomi w=3.31u l=4.32u A=0p P=0u m=1
C$299 bn9 vcn cap_cmomi w=3.31u l=4.32u A=0p P=0u m=1
C$300 vcp bp4 cap_cmomi w=3.31u l=4.32u A=0p P=0u m=1
C$301 bn4 vcn cap_cmomi w=3.31u l=4.32u A=0p P=0u m=1
C$302 vcp bp9 cap_cmomi w=3.31u l=4.32u A=0p P=0u m=1
C$303 bn9 vcn cap_cmomi w=3.31u l=4.32u A=0p P=0u m=1
C$304 vcp bp7 cap_cmomi w=3.31u l=4.32u A=0p P=0u m=1
C$305 bn7 vcn cap_cmomi w=3.31u l=4.32u A=0p P=0u m=1
C$306 vcp bp9 cap_cmomi w=3.31u l=4.32u A=0p P=0u m=1
C$307 bn9 vcn cap_cmomi w=3.31u l=4.32u A=0p P=0u m=1
C$308 vcp bp6 cap_cmomi w=3.31u l=4.32u A=0p P=0u m=1
C$309 bn6 vcn cap_cmomi w=3.31u l=4.32u A=0p P=0u m=1
C$310 vcp bp9 cap_cmomi w=3.31u l=4.32u A=0p P=0u m=1
C$311 bn9 vcn cap_cmomi w=3.31u l=4.32u A=0p P=0u m=1
C$312 vcp bp7 cap_cmomi w=3.31u l=4.32u A=0p P=0u m=1
C$313 bn7 vcn cap_cmomi w=3.31u l=4.32u A=0p P=0u m=1
C$314 vcp bp9 cap_cmomi w=3.31u l=4.32u A=0p P=0u m=1
C$315 bn9 vcn cap_cmomi w=3.31u l=4.32u A=0p P=0u m=1
C$316 vcp bp5 cap_cmomi w=3.31u l=4.32u A=0p P=0u m=1
C$317 bn5 vcn cap_cmomi w=3.31u l=4.32u A=0p P=0u m=1
C$318 vcp bp9 cap_cmomi w=3.31u l=4.32u A=0p P=0u m=1
C$319 bn9 vcn cap_cmomi w=3.31u l=4.32u A=0p P=0u m=1
C$320 vcp bp7 cap_cmomi w=3.31u l=4.32u A=0p P=0u m=1
C$321 bn7 vcn cap_cmomi w=3.31u l=4.32u A=0p P=0u m=1
C$322 vcp bp9 cap_cmomi w=3.31u l=4.32u A=0p P=0u m=1
C$323 bn9 vcn cap_cmomi w=3.31u l=4.32u A=0p P=0u m=1
C$324 vcp bp8 cap_cmomi w=3.31u l=4.32u A=0p P=0u m=1
C$325 bn8 vcn cap_cmomi w=3.31u l=4.32u A=0p P=0u m=1
C$326 vcp bp9 cap_cmomi w=3.31u l=4.32u A=0p P=0u m=1
C$327 bn9 vcn cap_cmomi w=3.31u l=4.32u A=0p P=0u m=1
C$328 vcp bp8 cap_cmomi w=3.31u l=4.32u A=0p P=0u m=1
C$329 bn8 vcn cap_cmomi w=3.31u l=4.32u A=0p P=0u m=1
C$330 vcp bp9 cap_cmomi w=3.31u l=4.32u A=0p P=0u m=1
C$331 bn9 vcn cap_cmomi w=3.31u l=4.32u A=0p P=0u m=1
C$332 vcp bp8 cap_cmomi w=3.31u l=4.32u A=0p P=0u m=1
C$333 bn8 vcn cap_cmomi w=3.31u l=4.32u A=0p P=0u m=1
C$334 vcp bp9 cap_cmomi w=3.31u l=4.32u A=0p P=0u m=1
C$335 bn9 vcn cap_cmomi w=3.31u l=4.32u A=0p P=0u m=1
C$336 vcp bp8 cap_cmomi w=3.31u l=4.32u A=0p P=0u m=1
C$337 bn8 vcn cap_cmomi w=3.31u l=4.32u A=0p P=0u m=1
C$338 vcp bp9 cap_cmomi w=3.31u l=4.32u A=0p P=0u m=1
C$339 bn9 vcn cap_cmomi w=3.31u l=4.32u A=0p P=0u m=1
C$340 vcp bp8 cap_cmomi w=3.31u l=4.32u A=0p P=0u m=1
C$341 bn8 vcn cap_cmomi w=3.31u l=4.32u A=0p P=0u m=1
C$342 vcp bp9 cap_cmomi w=3.31u l=4.32u A=0p P=0u m=1
C$343 bn9 vcn cap_cmomi w=3.31u l=4.32u A=0p P=0u m=1
C$344 vcp bp8 cap_cmomi w=3.31u l=4.32u A=0p P=0u m=1
C$345 bn8 vcn cap_cmomi w=3.31u l=4.32u A=0p P=0u m=1
C$346 vcp bp9 cap_cmomi w=3.31u l=4.32u A=0p P=0u m=1
C$347 bn9 vcn cap_cmomi w=3.31u l=4.32u A=0p P=0u m=1
C$348 vcp bp8 cap_cmomi w=3.31u l=4.32u A=0p P=0u m=1
C$349 bn8 vcn cap_cmomi w=3.31u l=4.32u A=0p P=0u m=1
C$350 vcp bp9 cap_cmomi w=3.31u l=4.32u A=0p P=0u m=1
C$351 bn9 vcn cap_cmomi w=3.31u l=4.32u A=0p P=0u m=1
C$352 vcp bp8 cap_cmomi w=3.31u l=4.32u A=0p P=0u m=1
C$353 bn8 vcn cap_cmomi w=3.31u l=4.32u A=0p P=0u m=1
C$354 vcp bp9 cap_cmomi w=3.31u l=4.32u A=0p P=0u m=1
C$355 bn9 vcn cap_cmomi w=3.31u l=4.32u A=0p P=0u m=1
C$356 vcp bp9 cap_cmomi w=3.31u l=4.32u A=0p P=0u m=1
C$357 bn9 vcn cap_cmomi w=3.31u l=4.32u A=0p P=0u m=1
C$358 vcp bp8 cap_cmomi w=3.31u l=4.32u A=0p P=0u m=1
C$359 bn8 vcn cap_cmomi w=3.31u l=4.32u A=0p P=0u m=1
C$360 vcp bp9 cap_cmomi w=3.31u l=4.32u A=0p P=0u m=1
C$361 bn9 vcn cap_cmomi w=3.31u l=4.32u A=0p P=0u m=1
C$362 vcp bp8 cap_cmomi w=3.31u l=4.32u A=0p P=0u m=1
C$363 bn8 vcn cap_cmomi w=3.31u l=4.32u A=0p P=0u m=1
C$364 vcp bp9 cap_cmomi w=3.31u l=4.32u A=0p P=0u m=1
C$365 bn9 vcn cap_cmomi w=3.31u l=4.32u A=0p P=0u m=1
C$366 vcp bp8 cap_cmomi w=3.31u l=4.32u A=0p P=0u m=1
C$367 bn8 vcn cap_cmomi w=3.31u l=4.32u A=0p P=0u m=1
C$368 vcp bp9 cap_cmomi w=3.31u l=4.32u A=0p P=0u m=1
C$369 bn9 vcn cap_cmomi w=3.31u l=4.32u A=0p P=0u m=1
C$370 vcp bp8 cap_cmomi w=3.31u l=4.32u A=0p P=0u m=1
C$371 bn8 vcn cap_cmomi w=3.31u l=4.32u A=0p P=0u m=1
C$372 vcp bp9 cap_cmomi w=3.31u l=4.32u A=0p P=0u m=1
C$373 bn9 vcn cap_cmomi w=3.31u l=4.32u A=0p P=0u m=1
C$374 vcp bp8 cap_cmomi w=3.31u l=4.32u A=0p P=0u m=1
C$375 bn8 vcn cap_cmomi w=3.31u l=4.32u A=0p P=0u m=1
C$376 vcp bp9 cap_cmomi w=3.31u l=4.32u A=0p P=0u m=1
C$377 bn9 vcn cap_cmomi w=3.31u l=4.32u A=0p P=0u m=1
C$378 vcp bp8 cap_cmomi w=3.31u l=4.32u A=0p P=0u m=1
C$379 bn8 vcn cap_cmomi w=3.31u l=4.32u A=0p P=0u m=1
C$380 vcp bp9 cap_cmomi w=3.31u l=4.32u A=0p P=0u m=1
C$381 bn9 vcn cap_cmomi w=3.31u l=4.32u A=0p P=0u m=1
C$382 vcp bp8 cap_cmomi w=3.31u l=4.32u A=0p P=0u m=1
C$383 bn8 vcn cap_cmomi w=3.31u l=4.32u A=0p P=0u m=1
C$384 vcp bp9 cap_cmomi w=3.31u l=4.32u A=0p P=0u m=1
C$385 bn9 vcn cap_cmomi w=3.31u l=4.32u A=0p P=0u m=1
C$386 vcp bp8 cap_cmomi w=3.31u l=4.32u A=0p P=0u m=1
C$387 bn8 vcn cap_cmomi w=3.31u l=4.32u A=0p P=0u m=1
C$388 vcp bp9 cap_cmomi w=3.31u l=4.32u A=0p P=0u m=1
C$389 bn9 vcn cap_cmomi w=3.31u l=4.32u A=0p P=0u m=1
C$390 vcp bp6 cap_cmomi w=3.31u l=4.32u A=0p P=0u m=1
C$391 bn6 vcn cap_cmomi w=3.31u l=4.32u A=0p P=0u m=1
C$392 vcp bp9 cap_cmomi w=3.31u l=4.32u A=0p P=0u m=1
C$393 bn9 vcn cap_cmomi w=3.31u l=4.32u A=0p P=0u m=1
C$394 vcp bp7 cap_cmomi w=3.31u l=4.32u A=0p P=0u m=1
C$395 bn7 vcn cap_cmomi w=3.31u l=4.32u A=0p P=0u m=1
C$396 vcp bp9 cap_cmomi w=3.31u l=4.32u A=0p P=0u m=1
C$397 bn9 vcn cap_cmomi w=3.31u l=4.32u A=0p P=0u m=1
C$398 vcp bp7 cap_cmomi w=3.31u l=4.32u A=0p P=0u m=1
C$399 bn7 vcn cap_cmomi w=3.31u l=4.32u A=0p P=0u m=1
C$400 vcp bp9 cap_cmomi w=3.31u l=4.32u A=0p P=0u m=1
C$401 bn9 vcn cap_cmomi w=3.31u l=4.32u A=0p P=0u m=1
C$402 vcp bp8 cap_cmomi w=3.31u l=4.32u A=0p P=0u m=1
C$403 bn8 vcn cap_cmomi w=3.31u l=4.32u A=0p P=0u m=1
C$404 vcp bp9 cap_cmomi w=3.31u l=4.32u A=0p P=0u m=1
C$405 bn9 vcn cap_cmomi w=3.31u l=4.32u A=0p P=0u m=1
C$406 vcp bp6 cap_cmomi w=3.31u l=4.32u A=0p P=0u m=1
C$407 bn6 vcn cap_cmomi w=3.31u l=4.32u A=0p P=0u m=1
C$408 vcp bp9 cap_cmomi w=3.31u l=4.32u A=0p P=0u m=1
C$409 bn9 vcn cap_cmomi w=3.31u l=4.32u A=0p P=0u m=1
C$410 vcp bp7 cap_cmomi w=3.31u l=4.32u A=0p P=0u m=1
C$411 bn7 vcn cap_cmomi w=3.31u l=4.32u A=0p P=0u m=1
C$412 vcp bp9 cap_cmomi w=3.31u l=4.32u A=0p P=0u m=1
C$413 bn9 vcn cap_cmomi w=3.31u l=4.32u A=0p P=0u m=1
C$414 vcp bp6 cap_cmomi w=3.31u l=4.32u A=0p P=0u m=1
C$415 bn6 vcn cap_cmomi w=3.31u l=4.32u A=0p P=0u m=1
C$416 vcp bp9 cap_cmomi w=3.31u l=4.32u A=0p P=0u m=1
C$417 bn9 vcn cap_cmomi w=3.31u l=4.32u A=0p P=0u m=1
C$418 vcp bp7 cap_cmomi w=3.31u l=4.32u A=0p P=0u m=1
C$419 bn7 vcn cap_cmomi w=3.31u l=4.32u A=0p P=0u m=1
C$420 vcp bp7 cap_cmomi w=3.31u l=4.32u A=0p P=0u m=1
C$421 bn7 vcn cap_cmomi w=3.31u l=4.32u A=0p P=0u m=1
C$422 vcp bp9 cap_cmomi w=3.31u l=4.32u A=0p P=0u m=1
C$423 bn9 vcn cap_cmomi w=3.31u l=4.32u A=0p P=0u m=1
C$424 vcp bp6 cap_cmomi w=3.31u l=4.32u A=0p P=0u m=1
C$425 bn6 vcn cap_cmomi w=3.31u l=4.32u A=0p P=0u m=1
C$426 vcp bp9 cap_cmomi w=3.31u l=4.32u A=0p P=0u m=1
C$427 bn9 vcn cap_cmomi w=3.31u l=4.32u A=0p P=0u m=1
C$428 vcp bp7 cap_cmomi w=3.31u l=4.32u A=0p P=0u m=1
C$429 bn7 vcn cap_cmomi w=3.31u l=4.32u A=0p P=0u m=1
C$430 vcp bp9 cap_cmomi w=3.31u l=4.32u A=0p P=0u m=1
C$431 bn9 vcn cap_cmomi w=3.31u l=4.32u A=0p P=0u m=1
C$432 vcp bp6 cap_cmomi w=3.31u l=4.32u A=0p P=0u m=1
C$433 bn6 vcn cap_cmomi w=3.31u l=4.32u A=0p P=0u m=1
C$434 vcp bp9 cap_cmomi w=3.31u l=4.32u A=0p P=0u m=1
C$435 bn9 vcn cap_cmomi w=3.31u l=4.32u A=0p P=0u m=1
C$436 vcp bp8 cap_cmomi w=3.31u l=4.32u A=0p P=0u m=1
C$437 bn8 vcn cap_cmomi w=3.31u l=4.32u A=0p P=0u m=1
C$438 vcp bp9 cap_cmomi w=3.31u l=4.32u A=0p P=0u m=1
C$439 bn9 vcn cap_cmomi w=3.31u l=4.32u A=0p P=0u m=1
C$440 vcp bp7 cap_cmomi w=3.31u l=4.32u A=0p P=0u m=1
C$441 bn7 vcn cap_cmomi w=3.31u l=4.32u A=0p P=0u m=1
C$442 vcp bp9 cap_cmomi w=3.31u l=4.32u A=0p P=0u m=1
C$443 bn9 vcn cap_cmomi w=3.31u l=4.32u A=0p P=0u m=1
C$444 vcp bp7 cap_cmomi w=3.31u l=4.32u A=0p P=0u m=1
C$445 bn7 vcn cap_cmomi w=3.31u l=4.32u A=0p P=0u m=1
C$446 vcp bp9 cap_cmomi w=3.31u l=4.32u A=0p P=0u m=1
C$447 bn9 vcn cap_cmomi w=3.31u l=4.32u A=0p P=0u m=1
C$448 vcp bp6 cap_cmomi w=3.31u l=4.32u A=0p P=0u m=1
C$449 bn6 vcn cap_cmomi w=3.31u l=4.32u A=0p P=0u m=1
C$450 vcp bp9 cap_cmomi w=3.31u l=4.32u A=0p P=0u m=1
C$451 bn9 vcn cap_cmomi w=3.31u l=4.32u A=0p P=0u m=1
C$452 vcp bp8 cap_cmomi w=3.31u l=4.32u A=0p P=0u m=1
C$453 bn8 vcn cap_cmomi w=3.31u l=4.32u A=0p P=0u m=1
C$454 vcp bp9 cap_cmomi w=3.31u l=4.32u A=0p P=0u m=1
C$455 bn9 vcn cap_cmomi w=3.31u l=4.32u A=0p P=0u m=1
C$456 vcp bp8 cap_cmomi w=3.31u l=4.32u A=0p P=0u m=1
C$457 bn8 vcn cap_cmomi w=3.31u l=4.32u A=0p P=0u m=1
C$458 vcp bp9 cap_cmomi w=3.31u l=4.32u A=0p P=0u m=1
C$459 bn9 vcn cap_cmomi w=3.31u l=4.32u A=0p P=0u m=1
C$460 vcp bp8 cap_cmomi w=3.31u l=4.32u A=0p P=0u m=1
C$461 bn8 vcn cap_cmomi w=3.31u l=4.32u A=0p P=0u m=1
C$462 vcp bp9 cap_cmomi w=3.31u l=4.32u A=0p P=0u m=1
C$463 bn9 vcn cap_cmomi w=3.31u l=4.32u A=0p P=0u m=1
C$464 vcp bp9 cap_cmomi w=3.31u l=4.32u A=0p P=0u m=1
C$465 bn9 vcn cap_cmomi w=3.31u l=4.32u A=0p P=0u m=1
C$466 vcp bp9 cap_cmomi w=3.31u l=4.32u A=0p P=0u m=1
C$467 bn9 vcn cap_cmomi w=3.31u l=4.32u A=0p P=0u m=1
C$468 vcp bp8 cap_cmomi w=3.31u l=4.32u A=0p P=0u m=1
C$469 bn8 vcn cap_cmomi w=3.31u l=4.32u A=0p P=0u m=1
C$470 vcp bp9 cap_cmomi w=3.31u l=4.32u A=0p P=0u m=1
C$471 bn9 vcn cap_cmomi w=3.31u l=4.32u A=0p P=0u m=1
C$472 vcp bp8 cap_cmomi w=3.31u l=4.32u A=0p P=0u m=1
C$473 bn8 vcn cap_cmomi w=3.31u l=4.32u A=0p P=0u m=1
C$474 vcp bp9 cap_cmomi w=3.31u l=4.32u A=0p P=0u m=1
C$475 bn9 vcn cap_cmomi w=3.31u l=4.32u A=0p P=0u m=1
C$476 vcp bp8 cap_cmomi w=3.31u l=4.32u A=0p P=0u m=1
C$477 bn8 vcn cap_cmomi w=3.31u l=4.32u A=0p P=0u m=1
C$478 vcp bp9 cap_cmomi w=3.31u l=4.32u A=0p P=0u m=1
C$479 bn9 vcn cap_cmomi w=3.31u l=4.32u A=0p P=0u m=1
C$480 vcp bp8 cap_cmomi w=3.31u l=4.32u A=0p P=0u m=1
C$481 bn8 vcn cap_cmomi w=3.31u l=4.32u A=0p P=0u m=1
C$482 vcp bp9 cap_cmomi w=3.31u l=4.32u A=0p P=0u m=1
C$483 bn9 vcn cap_cmomi w=3.31u l=4.32u A=0p P=0u m=1
C$484 vcp bp9 cap_cmomi w=3.31u l=4.32u A=0p P=0u m=1
C$485 bn9 vcn cap_cmomi w=3.31u l=4.32u A=0p P=0u m=1
C$486 vcp bp8 cap_cmomi w=3.31u l=4.32u A=0p P=0u m=1
C$487 bn8 vcn cap_cmomi w=3.31u l=4.32u A=0p P=0u m=1
C$488 vcp bp9 cap_cmomi w=3.31u l=4.32u A=0p P=0u m=1
C$489 bn9 vcn cap_cmomi w=3.31u l=4.32u A=0p P=0u m=1
C$490 vcp bp8 cap_cmomi w=3.31u l=4.32u A=0p P=0u m=1
C$491 bn8 vcn cap_cmomi w=3.31u l=4.32u A=0p P=0u m=1
C$492 vcp bp9 cap_cmomi w=3.31u l=4.32u A=0p P=0u m=1
C$493 bn9 vcn cap_cmomi w=3.31u l=4.32u A=0p P=0u m=1
C$494 vcp bp8 cap_cmomi w=3.31u l=4.32u A=0p P=0u m=1
C$495 bn8 vcn cap_cmomi w=3.31u l=4.32u A=0p P=0u m=1
C$496 vcp bp9 cap_cmomi w=3.31u l=4.32u A=0p P=0u m=1
C$497 bn9 vcn cap_cmomi w=3.31u l=4.32u A=0p P=0u m=1
C$498 vcp bp8 cap_cmomi w=3.31u l=4.32u A=0p P=0u m=1
C$499 bn8 vcn cap_cmomi w=3.31u l=4.32u A=0p P=0u m=1
C$500 vcp bp9 cap_cmomi w=3.31u l=4.32u A=0p P=0u m=1
C$501 bn9 vcn cap_cmomi w=3.31u l=4.32u A=0p P=0u m=1
C$502 vcp bp9 cap_cmomi w=3.31u l=4.32u A=0p P=0u m=1
C$503 bn9 vcn cap_cmomi w=3.31u l=4.32u A=0p P=0u m=1
C$504 vcp bp9 cap_cmomi w=3.31u l=4.32u A=0p P=0u m=1
C$505 bn9 vcn cap_cmomi w=3.31u l=4.32u A=0p P=0u m=1
C$506 vcp bp8 cap_cmomi w=3.31u l=4.32u A=0p P=0u m=1
C$507 bn8 vcn cap_cmomi w=3.31u l=4.32u A=0p P=0u m=1
C$508 vcp bp9 cap_cmomi w=3.31u l=4.32u A=0p P=0u m=1
C$509 bn9 vcn cap_cmomi w=3.31u l=4.32u A=0p P=0u m=1
C$510 vcp bp8 cap_cmomi w=3.31u l=4.32u A=0p P=0u m=1
C$511 bn8 vcn cap_cmomi w=3.31u l=4.32u A=0p P=0u m=1
C$512 vcp bp9 cap_cmomi w=3.31u l=4.32u A=0p P=0u m=1
C$513 bn9 vcn cap_cmomi w=3.31u l=4.32u A=0p P=0u m=1
C$514 vcp bp8 cap_cmomi w=3.31u l=4.32u A=0p P=0u m=1
C$515 bn8 vcn cap_cmomi w=3.31u l=4.32u A=0p P=0u m=1
C$516 vcp bp9 cap_cmomi w=3.31u l=4.32u A=0p P=0u m=1
C$517 bn9 vcn cap_cmomi w=3.31u l=4.32u A=0p P=0u m=1
C$518 vcp bp7 cap_cmomi w=3.31u l=4.32u A=0p P=0u m=1
C$519 bn7 vcn cap_cmomi w=3.31u l=4.32u A=0p P=0u m=1
C$520 vcp bp9 cap_cmomi w=3.31u l=4.32u A=0p P=0u m=1
C$521 bn9 vcn cap_cmomi w=3.31u l=4.32u A=0p P=0u m=1
C$522 vcp bp5 cap_cmomi w=3.31u l=4.32u A=0p P=0u m=1
C$523 bn5 vcn cap_cmomi w=3.31u l=4.32u A=0p P=0u m=1
C$524 vcp bp9 cap_cmomi w=3.31u l=4.32u A=0p P=0u m=1
C$525 bn9 vcn cap_cmomi w=3.31u l=4.32u A=0p P=0u m=1
C$526 vcp bp7 cap_cmomi w=3.31u l=4.32u A=0p P=0u m=1
C$527 bn7 vcn cap_cmomi w=3.31u l=4.32u A=0p P=0u m=1
C$528 vcp bp9 cap_cmomi w=3.31u l=4.32u A=0p P=0u m=1
C$529 bn9 vcn cap_cmomi w=3.31u l=4.32u A=0p P=0u m=1
C$530 vcp bp3 cap_cmomi w=3.31u l=4.32u A=0p P=0u m=1
C$531 bn3 vcn cap_cmomi w=3.31u l=4.32u A=0p P=0u m=1
C$532 vcp bp9 cap_cmomi w=3.31u l=4.32u A=0p P=0u m=1
C$533 bn9 vcn cap_cmomi w=3.31u l=4.32u A=0p P=0u m=1
C$534 vcp bp7 cap_cmomi w=3.31u l=4.32u A=0p P=0u m=1
C$535 bn7 vcn cap_cmomi w=3.31u l=4.32u A=0p P=0u m=1
C$536 vcp bp9 cap_cmomi w=3.31u l=4.32u A=0p P=0u m=1
C$537 bn9 vcn cap_cmomi w=3.31u l=4.32u A=0p P=0u m=1
C$538 vcp bp5 cap_cmomi w=3.31u l=4.32u A=0p P=0u m=1
C$539 bn5 vcn cap_cmomi w=3.31u l=4.32u A=0p P=0u m=1
C$540 vcp bp9 cap_cmomi w=3.31u l=4.32u A=0p P=0u m=1
C$541 bn9 vcn cap_cmomi w=3.31u l=4.32u A=0p P=0u m=1
C$542 vcp bp7 cap_cmomi w=3.31u l=4.32u A=0p P=0u m=1
C$543 bn7 vcn cap_cmomi w=3.31u l=4.32u A=0p P=0u m=1
C$544 vcp bp9 cap_cmomi w=3.31u l=4.32u A=0p P=0u m=1
C$545 bn9 vcn cap_cmomi w=3.31u l=4.32u A=0p P=0u m=1
C$546 vcp bp4 cap_cmomi w=3.31u l=4.32u A=0p P=0u m=1
C$547 bn4 vcn cap_cmomi w=3.31u l=4.32u A=0p P=0u m=1
C$548 vcp bp4 cap_cmomi w=3.31u l=4.32u A=0p P=0u m=1
C$549 bn4 vcn cap_cmomi w=3.31u l=4.32u A=0p P=0u m=1
C$550 vcp bp9 cap_cmomi w=3.31u l=4.32u A=0p P=0u m=1
C$551 bn9 vcn cap_cmomi w=3.31u l=4.32u A=0p P=0u m=1
C$552 vcp bp7 cap_cmomi w=3.31u l=4.32u A=0p P=0u m=1
C$553 bn7 vcn cap_cmomi w=3.31u l=4.32u A=0p P=0u m=1
C$554 vcp bp9 cap_cmomi w=3.31u l=4.32u A=0p P=0u m=1
C$555 bn9 vcn cap_cmomi w=3.31u l=4.32u A=0p P=0u m=1
C$556 vcp bp5 cap_cmomi w=3.31u l=4.32u A=0p P=0u m=1
C$557 bn5 vcn cap_cmomi w=3.31u l=4.32u A=0p P=0u m=1
C$558 vcp bp9 cap_cmomi w=3.31u l=4.32u A=0p P=0u m=1
C$559 bn9 vcn cap_cmomi w=3.31u l=4.32u A=0p P=0u m=1
C$560 vcp bp7 cap_cmomi w=3.31u l=4.32u A=0p P=0u m=1
C$561 bn7 vcn cap_cmomi w=3.31u l=4.32u A=0p P=0u m=1
C$562 vcp bp9 cap_cmomi w=3.31u l=4.32u A=0p P=0u m=1
C$563 bn9 vcn cap_cmomi w=3.31u l=4.32u A=0p P=0u m=1
C$564 vcp bp3 cap_cmomi w=3.31u l=4.32u A=0p P=0u m=1
C$565 bn3 vcn cap_cmomi w=3.31u l=4.32u A=0p P=0u m=1
C$566 vcp bp9 cap_cmomi w=3.31u l=4.32u A=0p P=0u m=1
C$567 bn9 vcn cap_cmomi w=3.31u l=4.32u A=0p P=0u m=1
C$568 vcp bp7 cap_cmomi w=3.31u l=4.32u A=0p P=0u m=1
C$569 bn7 vcn cap_cmomi w=3.31u l=4.32u A=0p P=0u m=1
C$570 vcp bp9 cap_cmomi w=3.31u l=4.32u A=0p P=0u m=1
C$571 bn9 vcn cap_cmomi w=3.31u l=4.32u A=0p P=0u m=1
C$572 vcp bp5 cap_cmomi w=3.31u l=4.32u A=0p P=0u m=1
C$573 bn5 vcn cap_cmomi w=3.31u l=4.32u A=0p P=0u m=1
C$574 vcp bp9 cap_cmomi w=3.31u l=4.32u A=0p P=0u m=1
C$575 bn9 vcn cap_cmomi w=3.31u l=4.32u A=0p P=0u m=1
C$576 vcp bp7 cap_cmomi w=3.31u l=4.32u A=0p P=0u m=1
C$577 bn7 vcn cap_cmomi w=3.31u l=4.32u A=0p P=0u m=1
C$578 vcp bp9 cap_cmomi w=3.31u l=4.32u A=0p P=0u m=1
C$579 bn9 vcn cap_cmomi w=3.31u l=4.32u A=0p P=0u m=1
C$580 vcp bp8 cap_cmomi w=3.31u l=4.32u A=0p P=0u m=1
C$581 bn8 vcn cap_cmomi w=3.31u l=4.32u A=0p P=0u m=1
C$582 vcp bp9 cap_cmomi w=3.31u l=4.32u A=0p P=0u m=1
C$583 bn9 vcn cap_cmomi w=3.31u l=4.32u A=0p P=0u m=1
C$584 vcp bp8 cap_cmomi w=3.31u l=4.32u A=0p P=0u m=1
C$585 bn8 vcn cap_cmomi w=3.31u l=4.32u A=0p P=0u m=1
C$586 vcp bp9 cap_cmomi w=3.31u l=4.32u A=0p P=0u m=1
C$587 bn9 vcn cap_cmomi w=3.31u l=4.32u A=0p P=0u m=1
C$588 vcp bp8 cap_cmomi w=3.31u l=4.32u A=0p P=0u m=1
C$589 bn8 vcn cap_cmomi w=3.31u l=4.32u A=0p P=0u m=1
C$590 vcp bp9 cap_cmomi w=3.31u l=4.32u A=0p P=0u m=1
C$591 bn9 vcn cap_cmomi w=3.31u l=4.32u A=0p P=0u m=1
C$592 vcp bp8 cap_cmomi w=3.31u l=4.32u A=0p P=0u m=1
C$593 bn8 vcn cap_cmomi w=3.31u l=4.32u A=0p P=0u m=1
C$594 vcp bp9 cap_cmomi w=3.31u l=4.32u A=0p P=0u m=1
C$595 bn9 vcn cap_cmomi w=3.31u l=4.32u A=0p P=0u m=1
C$596 vcp bp8 cap_cmomi w=3.31u l=4.32u A=0p P=0u m=1
C$597 bn8 vcn cap_cmomi w=3.31u l=4.32u A=0p P=0u m=1
C$598 vcp bp9 cap_cmomi w=3.31u l=4.32u A=0p P=0u m=1
C$599 bn9 vcn cap_cmomi w=3.31u l=4.32u A=0p P=0u m=1
C$600 vcp bp8 cap_cmomi w=3.31u l=4.32u A=0p P=0u m=1
C$601 bn8 vcn cap_cmomi w=3.31u l=4.32u A=0p P=0u m=1
C$602 vcp bp9 cap_cmomi w=3.31u l=4.32u A=0p P=0u m=1
C$603 bn9 vcn cap_cmomi w=3.31u l=4.32u A=0p P=0u m=1
C$604 vcp bp8 cap_cmomi w=3.31u l=4.32u A=0p P=0u m=1
C$605 bn8 vcn cap_cmomi w=3.31u l=4.32u A=0p P=0u m=1
C$606 vcp bp9 cap_cmomi w=3.31u l=4.32u A=0p P=0u m=1
C$607 bn9 vcn cap_cmomi w=3.31u l=4.32u A=0p P=0u m=1
C$608 vcp bp8 cap_cmomi w=3.31u l=4.32u A=0p P=0u m=1
C$609 bn8 vcn cap_cmomi w=3.31u l=4.32u A=0p P=0u m=1
C$610 vcp bp9 cap_cmomi w=3.31u l=4.32u A=0p P=0u m=1
C$611 bn9 vcn cap_cmomi w=3.31u l=4.32u A=0p P=0u m=1
C$612 vcp bp9 cap_cmomi w=3.31u l=4.32u A=0p P=0u m=1
C$613 bn9 vcn cap_cmomi w=3.31u l=4.32u A=0p P=0u m=1
C$614 vcp bp8 cap_cmomi w=3.31u l=4.32u A=0p P=0u m=1
C$615 bn8 vcn cap_cmomi w=3.31u l=4.32u A=0p P=0u m=1
C$616 vcp bp9 cap_cmomi w=3.31u l=4.32u A=0p P=0u m=1
C$617 bn9 vcn cap_cmomi w=3.31u l=4.32u A=0p P=0u m=1
C$618 vcp bp8 cap_cmomi w=3.31u l=4.32u A=0p P=0u m=1
C$619 bn8 vcn cap_cmomi w=3.31u l=4.32u A=0p P=0u m=1
C$620 vcp bp9 cap_cmomi w=3.31u l=4.32u A=0p P=0u m=1
C$621 bn9 vcn cap_cmomi w=3.31u l=4.32u A=0p P=0u m=1
C$622 vcp bp8 cap_cmomi w=3.31u l=4.32u A=0p P=0u m=1
C$623 bn8 vcn cap_cmomi w=3.31u l=4.32u A=0p P=0u m=1
C$624 vcp bp9 cap_cmomi w=3.31u l=4.32u A=0p P=0u m=1
C$625 bn9 vcn cap_cmomi w=3.31u l=4.32u A=0p P=0u m=1
C$626 vcp bp8 cap_cmomi w=3.31u l=4.32u A=0p P=0u m=1
C$627 bn8 vcn cap_cmomi w=3.31u l=4.32u A=0p P=0u m=1
C$628 vcp bp9 cap_cmomi w=3.31u l=4.32u A=0p P=0u m=1
C$629 bn9 vcn cap_cmomi w=3.31u l=4.32u A=0p P=0u m=1
C$630 vcp bp8 cap_cmomi w=3.31u l=4.32u A=0p P=0u m=1
C$631 bn8 vcn cap_cmomi w=3.31u l=4.32u A=0p P=0u m=1
C$632 vcp bp9 cap_cmomi w=3.31u l=4.32u A=0p P=0u m=1
C$633 bn9 vcn cap_cmomi w=3.31u l=4.32u A=0p P=0u m=1
C$634 vcp bp8 cap_cmomi w=3.31u l=4.32u A=0p P=0u m=1
C$635 bn8 vcn cap_cmomi w=3.31u l=4.32u A=0p P=0u m=1
C$636 vcp bp9 cap_cmomi w=3.31u l=4.32u A=0p P=0u m=1
C$637 bn9 vcn cap_cmomi w=3.31u l=4.32u A=0p P=0u m=1
C$638 vcp bp8 cap_cmomi w=3.31u l=4.32u A=0p P=0u m=1
C$639 bn8 vcn cap_cmomi w=3.31u l=4.32u A=0p P=0u m=1
C$640 vcp bp9 cap_cmomi w=3.31u l=4.32u A=0p P=0u m=1
C$641 bn9 vcn cap_cmomi w=3.31u l=4.32u A=0p P=0u m=1
C$642 vcp bp8 cap_cmomi w=3.31u l=4.32u A=0p P=0u m=1
C$643 bn8 vcn cap_cmomi w=3.31u l=4.32u A=0p P=0u m=1
C$644 vcp bp9 cap_cmomi w=3.31u l=4.32u A=0p P=0u m=1
C$645 bn9 vcn cap_cmomi w=3.31u l=4.32u A=0p P=0u m=1
C$646 vcp bp6 cap_cmomi w=3.31u l=4.32u A=0p P=0u m=1
C$647 bn6 vcn cap_cmomi w=3.31u l=4.32u A=0p P=0u m=1
C$648 vcp bp9 cap_cmomi w=3.31u l=4.32u A=0p P=0u m=1
C$649 bn9 vcn cap_cmomi w=3.31u l=4.32u A=0p P=0u m=1
C$650 vcp bp7 cap_cmomi w=3.31u l=4.32u A=0p P=0u m=1
C$651 bn7 vcn cap_cmomi w=3.31u l=4.32u A=0p P=0u m=1
C$652 vcp bp9 cap_cmomi w=3.31u l=4.32u A=0p P=0u m=1
C$653 bn9 vcn cap_cmomi w=3.31u l=4.32u A=0p P=0u m=1
C$654 vcp bp6 cap_cmomi w=3.31u l=4.32u A=0p P=0u m=1
C$655 bn6 vcn cap_cmomi w=3.31u l=4.32u A=0p P=0u m=1
C$656 vcp bp9 cap_cmomi w=3.31u l=4.32u A=0p P=0u m=1
C$657 bn9 vcn cap_cmomi w=3.31u l=4.32u A=0p P=0u m=1
C$658 vcp bp7 cap_cmomi w=3.31u l=4.32u A=0p P=0u m=1
C$659 bn7 vcn cap_cmomi w=3.31u l=4.32u A=0p P=0u m=1
C$660 vcp bp9 cap_cmomi w=3.31u l=4.32u A=0p P=0u m=1
C$661 bn9 vcn cap_cmomi w=3.31u l=4.32u A=0p P=0u m=1
C$662 vcp bp6 cap_cmomi w=3.31u l=4.32u A=0p P=0u m=1
C$663 bn6 vcn cap_cmomi w=3.31u l=4.32u A=0p P=0u m=1
C$664 vcp bp9 cap_cmomi w=3.31u l=4.32u A=0p P=0u m=1
C$665 bn9 vcn cap_cmomi w=3.31u l=4.32u A=0p P=0u m=1
C$666 vcp bp7 cap_cmomi w=3.31u l=4.32u A=0p P=0u m=1
C$667 bn7 vcn cap_cmomi w=3.31u l=4.32u A=0p P=0u m=1
C$668 vcp bp9 cap_cmomi w=3.31u l=4.32u A=0p P=0u m=1
C$669 bn9 vcn cap_cmomi w=3.31u l=4.32u A=0p P=0u m=1
C$670 vcp bp6 cap_cmomi w=3.31u l=4.32u A=0p P=0u m=1
C$671 bn6 vcn cap_cmomi w=3.31u l=4.32u A=0p P=0u m=1
C$672 vcp bp9 cap_cmomi w=3.31u l=4.32u A=0p P=0u m=1
C$673 bn9 vcn cap_cmomi w=3.31u l=4.32u A=0p P=0u m=1
C$674 vcp bp7 cap_cmomi w=3.31u l=4.32u A=0p P=0u m=1
C$675 bn7 vcn cap_cmomi w=3.31u l=4.32u A=0p P=0u m=1
C$676 vcp bp7 cap_cmomi w=3.31u l=4.32u A=0p P=0u m=1
C$677 bn7 vcn cap_cmomi w=3.31u l=4.32u A=0p P=0u m=1
C$678 vcp bp9 cap_cmomi w=3.31u l=4.32u A=0p P=0u m=1
C$679 bn9 vcn cap_cmomi w=3.31u l=4.32u A=0p P=0u m=1
C$680 vcp bp6 cap_cmomi w=3.31u l=4.32u A=0p P=0u m=1
C$681 bn6 vcn cap_cmomi w=3.31u l=4.32u A=0p P=0u m=1
C$682 vcp bp9 cap_cmomi w=3.31u l=4.32u A=0p P=0u m=1
C$683 bn9 vcn cap_cmomi w=3.31u l=4.32u A=0p P=0u m=1
C$684 vcp bp7 cap_cmomi w=3.31u l=4.32u A=0p P=0u m=1
C$685 bn7 vcn cap_cmomi w=3.31u l=4.32u A=0p P=0u m=1
C$686 vcp bp9 cap_cmomi w=3.31u l=4.32u A=0p P=0u m=1
C$687 bn9 vcn cap_cmomi w=3.31u l=4.32u A=0p P=0u m=1
C$688 vcp bp6 cap_cmomi w=3.31u l=4.32u A=0p P=0u m=1
C$689 bn6 vcn cap_cmomi w=3.31u l=4.32u A=0p P=0u m=1
C$690 vcp bp9 cap_cmomi w=3.31u l=4.32u A=0p P=0u m=1
C$691 bn9 vcn cap_cmomi w=3.31u l=4.32u A=0p P=0u m=1
C$692 vcp bp7 cap_cmomi w=3.31u l=4.32u A=0p P=0u m=1
C$693 bn7 vcn cap_cmomi w=3.31u l=4.32u A=0p P=0u m=1
C$694 vcp bp9 cap_cmomi w=3.31u l=4.32u A=0p P=0u m=1
C$695 bn9 vcn cap_cmomi w=3.31u l=4.32u A=0p P=0u m=1
C$696 vcp bp6 cap_cmomi w=3.31u l=4.32u A=0p P=0u m=1
C$697 bn6 vcn cap_cmomi w=3.31u l=4.32u A=0p P=0u m=1
C$698 vcp bp9 cap_cmomi w=3.31u l=4.32u A=0p P=0u m=1
C$699 bn9 vcn cap_cmomi w=3.31u l=4.32u A=0p P=0u m=1
C$700 vcp bp7 cap_cmomi w=3.31u l=4.32u A=0p P=0u m=1
C$701 bn7 vcn cap_cmomi w=3.31u l=4.32u A=0p P=0u m=1
C$702 vcp bp9 cap_cmomi w=3.31u l=4.32u A=0p P=0u m=1
C$703 bn9 vcn cap_cmomi w=3.31u l=4.32u A=0p P=0u m=1
C$704 vcp bp6 cap_cmomi w=3.31u l=4.32u A=0p P=0u m=1
C$705 bn6 vcn cap_cmomi w=3.31u l=4.32u A=0p P=0u m=1
C$706 vcp bp9 cap_cmomi w=3.31u l=4.32u A=0p P=0u m=1
C$707 bn9 vcn cap_cmomi w=3.31u l=4.32u A=0p P=0u m=1
C$708 vcp bp8 cap_cmomi w=3.31u l=4.32u A=0p P=0u m=1
C$709 bn8 vcn cap_cmomi w=3.31u l=4.32u A=0p P=0u m=1
C$710 vcp bp9 cap_cmomi w=3.31u l=4.32u A=0p P=0u m=1
C$711 bn9 vcn cap_cmomi w=3.31u l=4.32u A=0p P=0u m=1
C$712 vcp bp8 cap_cmomi w=3.31u l=4.32u A=0p P=0u m=1
C$713 bn8 vcn cap_cmomi w=3.31u l=4.32u A=0p P=0u m=1
C$714 vcp bp9 cap_cmomi w=3.31u l=4.32u A=0p P=0u m=1
C$715 bn9 vcn cap_cmomi w=3.31u l=4.32u A=0p P=0u m=1
C$716 vcp bp8 cap_cmomi w=3.31u l=4.32u A=0p P=0u m=1
C$717 bn8 vcn cap_cmomi w=3.31u l=4.32u A=0p P=0u m=1
C$718 vcp bp9 cap_cmomi w=3.31u l=4.32u A=0p P=0u m=1
C$719 bn9 vcn cap_cmomi w=3.31u l=4.32u A=0p P=0u m=1
C$720 vcp bp8 cap_cmomi w=3.31u l=4.32u A=0p P=0u m=1
C$721 bn8 vcn cap_cmomi w=3.31u l=4.32u A=0p P=0u m=1
C$722 vcp bp9 cap_cmomi w=3.31u l=4.32u A=0p P=0u m=1
C$723 bn9 vcn cap_cmomi w=3.31u l=4.32u A=0p P=0u m=1
C$724 vcp bp8 cap_cmomi w=3.31u l=4.32u A=0p P=0u m=1
C$725 bn8 vcn cap_cmomi w=3.31u l=4.32u A=0p P=0u m=1
C$726 vcp bp9 cap_cmomi w=3.31u l=4.32u A=0p P=0u m=1
C$727 bn9 vcn cap_cmomi w=3.31u l=4.32u A=0p P=0u m=1
C$728 vcp bp8 cap_cmomi w=3.31u l=4.32u A=0p P=0u m=1
C$729 bn8 vcn cap_cmomi w=3.31u l=4.32u A=0p P=0u m=1
C$730 vcp bp9 cap_cmomi w=3.31u l=4.32u A=0p P=0u m=1
C$731 bn9 vcn cap_cmomi w=3.31u l=4.32u A=0p P=0u m=1
C$732 vcp bp8 cap_cmomi w=3.31u l=4.32u A=0p P=0u m=1
C$733 bn8 vcn cap_cmomi w=3.31u l=4.32u A=0p P=0u m=1
C$734 vcp bp9 cap_cmomi w=3.31u l=4.32u A=0p P=0u m=1
C$735 bn9 vcn cap_cmomi w=3.31u l=4.32u A=0p P=0u m=1
C$736 vcp bp8 cap_cmomi w=3.31u l=4.32u A=0p P=0u m=1
C$737 bn8 vcn cap_cmomi w=3.31u l=4.32u A=0p P=0u m=1
C$738 vcp bp9 cap_cmomi w=3.31u l=4.32u A=0p P=0u m=1
C$739 bn9 vcn cap_cmomi w=3.31u l=4.32u A=0p P=0u m=1
C$740 vcp bp9 cap_cmomi w=3.31u l=4.32u A=0p P=0u m=1
C$741 bn9 vcn cap_cmomi w=3.31u l=4.32u A=0p P=0u m=1
C$742 vcp bp8 cap_cmomi w=3.31u l=4.32u A=0p P=0u m=1
C$743 bn8 vcn cap_cmomi w=3.31u l=4.32u A=0p P=0u m=1
C$744 vcp bp9 cap_cmomi w=3.31u l=4.32u A=0p P=0u m=1
C$745 bn9 vcn cap_cmomi w=3.31u l=4.32u A=0p P=0u m=1
C$746 vcp bp8 cap_cmomi w=3.31u l=4.32u A=0p P=0u m=1
C$747 bn8 vcn cap_cmomi w=3.31u l=4.32u A=0p P=0u m=1
C$748 vcp bp9 cap_cmomi w=3.31u l=4.32u A=0p P=0u m=1
C$749 bn9 vcn cap_cmomi w=3.31u l=4.32u A=0p P=0u m=1
C$750 vcp bp8 cap_cmomi w=3.31u l=4.32u A=0p P=0u m=1
C$751 bn8 vcn cap_cmomi w=3.31u l=4.32u A=0p P=0u m=1
C$752 vcp bp9 cap_cmomi w=3.31u l=4.32u A=0p P=0u m=1
C$753 bn9 vcn cap_cmomi w=3.31u l=4.32u A=0p P=0u m=1
C$754 vcp bp8 cap_cmomi w=3.31u l=4.32u A=0p P=0u m=1
C$755 bn8 vcn cap_cmomi w=3.31u l=4.32u A=0p P=0u m=1
C$756 vcp bp9 cap_cmomi w=3.31u l=4.32u A=0p P=0u m=1
C$757 bn9 vcn cap_cmomi w=3.31u l=4.32u A=0p P=0u m=1
C$758 vcp bp8 cap_cmomi w=3.31u l=4.32u A=0p P=0u m=1
C$759 bn8 vcn cap_cmomi w=3.31u l=4.32u A=0p P=0u m=1
C$760 vcp bp9 cap_cmomi w=3.31u l=4.32u A=0p P=0u m=1
C$761 bn9 vcn cap_cmomi w=3.31u l=4.32u A=0p P=0u m=1
C$762 vcp bp8 cap_cmomi w=3.31u l=4.32u A=0p P=0u m=1
C$763 bn8 vcn cap_cmomi w=3.31u l=4.32u A=0p P=0u m=1
C$764 vcp bp9 cap_cmomi w=3.31u l=4.32u A=0p P=0u m=1
C$765 bn9 vcn cap_cmomi w=3.31u l=4.32u A=0p P=0u m=1
C$766 vcp bp8 cap_cmomi w=3.31u l=4.32u A=0p P=0u m=1
C$767 bn8 vcn cap_cmomi w=3.31u l=4.32u A=0p P=0u m=1
C$768 vcp bp9 cap_cmomi w=3.31u l=4.32u A=0p P=0u m=1
C$769 bn9 vcn cap_cmomi w=3.31u l=4.32u A=0p P=0u m=1
C$770 vcp bp8 cap_cmomi w=3.31u l=4.32u A=0p P=0u m=1
C$771 bn8 vcn cap_cmomi w=3.31u l=4.32u A=0p P=0u m=1
C$772 vcp bp9 cap_cmomi w=3.31u l=4.32u A=0p P=0u m=1
C$773 bn9 vcn cap_cmomi w=3.31u l=4.32u A=0p P=0u m=1
C$774 vcp bp7 cap_cmomi w=3.31u l=4.32u A=0p P=0u m=1
C$775 bn7 vcn cap_cmomi w=3.31u l=4.32u A=0p P=0u m=1
C$776 vcp bp9 cap_cmomi w=3.31u l=4.32u A=0p P=0u m=1
C$777 bn9 vcn cap_cmomi w=3.31u l=4.32u A=0p P=0u m=1
C$778 vcp bp4 cap_cmomi w=3.31u l=4.32u A=0p P=0u m=1
C$779 bn4 vcn cap_cmomi w=3.31u l=4.32u A=0p P=0u m=1
C$780 vcp bp9 cap_cmomi w=3.31u l=4.32u A=0p P=0u m=1
C$781 bn9 vcn cap_cmomi w=3.31u l=4.32u A=0p P=0u m=1
C$782 vcp bp7 cap_cmomi w=3.31u l=4.32u A=0p P=0u m=1
C$783 bn7 vcn cap_cmomi w=3.31u l=4.32u A=0p P=0u m=1
C$784 vcp bp9 cap_cmomi w=3.31u l=4.32u A=0p P=0u m=1
C$785 bn9 vcn cap_cmomi w=3.31u l=4.32u A=0p P=0u m=1
C$786 vcp bp5 cap_cmomi w=3.31u l=4.32u A=0p P=0u m=1
C$787 bn5 vcn cap_cmomi w=3.31u l=4.32u A=0p P=0u m=1
C$788 vcp bp9 cap_cmomi w=3.31u l=4.32u A=0p P=0u m=1
C$789 bn9 vcn cap_cmomi w=3.31u l=4.32u A=0p P=0u m=1
C$790 vcp bp7 cap_cmomi w=3.31u l=4.32u A=0p P=0u m=1
C$791 bn7 vcn cap_cmomi w=3.31u l=4.32u A=0p P=0u m=1
C$792 vcp bp9 cap_cmomi w=3.31u l=4.32u A=0p P=0u m=1
C$793 bn9 vcn cap_cmomi w=3.31u l=4.32u A=0p P=0u m=1
C$794 vcp bp5 cap_cmomi w=3.31u l=4.32u A=0p P=0u m=1
C$795 bn5 vcn cap_cmomi w=3.31u l=4.32u A=0p P=0u m=1
C$796 vcp bp9 cap_cmomi w=3.31u l=4.32u A=0p P=0u m=1
C$797 bn9 vcn cap_cmomi w=3.31u l=4.32u A=0p P=0u m=1
C$798 vcp bp7 cap_cmomi w=3.31u l=4.32u A=0p P=0u m=1
C$799 bn7 vcn cap_cmomi w=3.31u l=4.32u A=0p P=0u m=1
C$800 vcp bp9 cap_cmomi w=3.31u l=4.32u A=0p P=0u m=1
C$801 bn9 vcn cap_cmomi w=3.31u l=4.32u A=0p P=0u m=1
C$802 vcp bp6 cap_cmomi w=3.31u l=4.32u A=0p P=0u m=1
C$803 bn6 vcn cap_cmomi w=3.31u l=4.32u A=0p P=0u m=1
C$804 vcp bp6 cap_cmomi w=3.31u l=4.32u A=0p P=0u m=1
C$805 bn6 vcn cap_cmomi w=3.31u l=4.32u A=0p P=0u m=1
C$806 vcp bp9 cap_cmomi w=3.31u l=4.32u A=0p P=0u m=1
C$807 bn9 vcn cap_cmomi w=3.31u l=4.32u A=0p P=0u m=1
C$808 vcp bp7 cap_cmomi w=3.31u l=4.32u A=0p P=0u m=1
C$809 bn7 vcn cap_cmomi w=3.31u l=4.32u A=0p P=0u m=1
C$810 vcp bp9 cap_cmomi w=3.31u l=4.32u A=0p P=0u m=1
C$811 bn9 vcn cap_cmomi w=3.31u l=4.32u A=0p P=0u m=1
C$812 vcp bp5 cap_cmomi w=3.31u l=4.32u A=0p P=0u m=1
C$813 bn5 vcn cap_cmomi w=3.31u l=4.32u A=0p P=0u m=1
C$814 vcp bp9 cap_cmomi w=3.31u l=4.32u A=0p P=0u m=1
C$815 bn9 vcn cap_cmomi w=3.31u l=4.32u A=0p P=0u m=1
C$816 vcp bp7 cap_cmomi w=3.31u l=4.32u A=0p P=0u m=1
C$817 bn7 vcn cap_cmomi w=3.31u l=4.32u A=0p P=0u m=1
C$818 vcp bp9 cap_cmomi w=3.31u l=4.32u A=0p P=0u m=1
C$819 bn9 vcn cap_cmomi w=3.31u l=4.32u A=0p P=0u m=1
C$820 vcp bp5 cap_cmomi w=3.31u l=4.32u A=0p P=0u m=1
C$821 bn5 vcn cap_cmomi w=3.31u l=4.32u A=0p P=0u m=1
C$822 vcp bp9 cap_cmomi w=3.31u l=4.32u A=0p P=0u m=1
C$823 bn9 vcn cap_cmomi w=3.31u l=4.32u A=0p P=0u m=1
C$824 vcp bp7 cap_cmomi w=3.31u l=4.32u A=0p P=0u m=1
C$825 bn7 vcn cap_cmomi w=3.31u l=4.32u A=0p P=0u m=1
C$826 vcp bp9 cap_cmomi w=3.31u l=4.32u A=0p P=0u m=1
C$827 bn9 vcn cap_cmomi w=3.31u l=4.32u A=0p P=0u m=1
C$828 vcp bp4 cap_cmomi w=3.31u l=4.32u A=0p P=0u m=1
C$829 bn4 vcn cap_cmomi w=3.31u l=4.32u A=0p P=0u m=1
C$830 vcp bp9 cap_cmomi w=3.31u l=4.32u A=0p P=0u m=1
C$831 bn9 vcn cap_cmomi w=3.31u l=4.32u A=0p P=0u m=1
C$832 vcp bp7 cap_cmomi w=3.31u l=4.32u A=0p P=0u m=1
C$833 bn7 vcn cap_cmomi w=3.31u l=4.32u A=0p P=0u m=1
C$834 vcp bp9 cap_cmomi w=3.31u l=4.32u A=0p P=0u m=1
C$835 bn9 vcn cap_cmomi w=3.31u l=4.32u A=0p P=0u m=1
C$836 vcp bp8 cap_cmomi w=3.31u l=4.32u A=0p P=0u m=1
C$837 bn8 vcn cap_cmomi w=3.31u l=4.32u A=0p P=0u m=1
C$838 vcp bp9 cap_cmomi w=3.31u l=4.32u A=0p P=0u m=1
C$839 bn9 vcn cap_cmomi w=3.31u l=4.32u A=0p P=0u m=1
C$840 vcp bp8 cap_cmomi w=3.31u l=4.32u A=0p P=0u m=1
C$841 bn8 vcn cap_cmomi w=3.31u l=4.32u A=0p P=0u m=1
C$842 vcp bp9 cap_cmomi w=3.31u l=4.32u A=0p P=0u m=1
C$843 bn9 vcn cap_cmomi w=3.31u l=4.32u A=0p P=0u m=1
C$844 vcp bp8 cap_cmomi w=3.31u l=4.32u A=0p P=0u m=1
C$845 bn8 vcn cap_cmomi w=3.31u l=4.32u A=0p P=0u m=1
C$846 vcp bp9 cap_cmomi w=3.31u l=4.32u A=0p P=0u m=1
C$847 bn9 vcn cap_cmomi w=3.31u l=4.32u A=0p P=0u m=1
C$848 vcp bp8 cap_cmomi w=3.31u l=4.32u A=0p P=0u m=1
C$849 bn8 vcn cap_cmomi w=3.31u l=4.32u A=0p P=0u m=1
C$850 vcp bp9 cap_cmomi w=3.31u l=4.32u A=0p P=0u m=1
C$851 bn9 vcn cap_cmomi w=3.31u l=4.32u A=0p P=0u m=1
C$852 vcp bp8 cap_cmomi w=3.31u l=4.32u A=0p P=0u m=1
C$853 bn8 vcn cap_cmomi w=3.31u l=4.32u A=0p P=0u m=1
C$854 vcp bp9 cap_cmomi w=3.31u l=4.32u A=0p P=0u m=1
C$855 bn9 vcn cap_cmomi w=3.31u l=4.32u A=0p P=0u m=1
C$856 vcp bp8 cap_cmomi w=3.31u l=4.32u A=0p P=0u m=1
C$857 bn8 vcn cap_cmomi w=3.31u l=4.32u A=0p P=0u m=1
C$858 vcp bp9 cap_cmomi w=3.31u l=4.32u A=0p P=0u m=1
C$859 bn9 vcn cap_cmomi w=3.31u l=4.32u A=0p P=0u m=1
C$860 vcp bp8 cap_cmomi w=3.31u l=4.32u A=0p P=0u m=1
C$861 bn8 vcn cap_cmomi w=3.31u l=4.32u A=0p P=0u m=1
C$862 vcp bp9 cap_cmomi w=3.31u l=4.32u A=0p P=0u m=1
C$863 bn9 vcn cap_cmomi w=3.31u l=4.32u A=0p P=0u m=1
C$864 vcp bp8 cap_cmomi w=3.31u l=4.32u A=0p P=0u m=1
C$865 bn8 vcn cap_cmomi w=3.31u l=4.32u A=0p P=0u m=1
C$866 vcp bp9 cap_cmomi w=3.31u l=4.32u A=0p P=0u m=1
C$867 bn9 vcn cap_cmomi w=3.31u l=4.32u A=0p P=0u m=1
C$868 vcp bp9 cap_cmomi w=3.31u l=4.32u A=0p P=0u m=1
C$869 bn9 vcn cap_cmomi w=3.31u l=4.32u A=0p P=0u m=1
C$870 vcp bp8 cap_cmomi w=3.31u l=4.32u A=0p P=0u m=1
C$871 bn8 vcn cap_cmomi w=3.31u l=4.32u A=0p P=0u m=1
C$872 vcp bp9 cap_cmomi w=3.31u l=4.32u A=0p P=0u m=1
C$873 bn9 vcn cap_cmomi w=3.31u l=4.32u A=0p P=0u m=1
C$874 vcp bp8 cap_cmomi w=3.31u l=4.32u A=0p P=0u m=1
C$875 bn8 vcn cap_cmomi w=3.31u l=4.32u A=0p P=0u m=1
C$876 vcp bp9 cap_cmomi w=3.31u l=4.32u A=0p P=0u m=1
C$877 bn9 vcn cap_cmomi w=3.31u l=4.32u A=0p P=0u m=1
C$878 vcp bp8 cap_cmomi w=3.31u l=4.32u A=0p P=0u m=1
C$879 bn8 vcn cap_cmomi w=3.31u l=4.32u A=0p P=0u m=1
C$880 vcp bp9 cap_cmomi w=3.31u l=4.32u A=0p P=0u m=1
C$881 bn9 vcn cap_cmomi w=3.31u l=4.32u A=0p P=0u m=1
C$882 vcp bp8 cap_cmomi w=3.31u l=4.32u A=0p P=0u m=1
C$883 bn8 vcn cap_cmomi w=3.31u l=4.32u A=0p P=0u m=1
C$884 vcp bp9 cap_cmomi w=3.31u l=4.32u A=0p P=0u m=1
C$885 bn9 vcn cap_cmomi w=3.31u l=4.32u A=0p P=0u m=1
C$886 vcp bp8 cap_cmomi w=3.31u l=4.32u A=0p P=0u m=1
C$887 bn8 vcn cap_cmomi w=3.31u l=4.32u A=0p P=0u m=1
C$888 vcp bp9 cap_cmomi w=3.31u l=4.32u A=0p P=0u m=1
C$889 bn9 vcn cap_cmomi w=3.31u l=4.32u A=0p P=0u m=1
C$890 vcp bp8 cap_cmomi w=3.31u l=4.32u A=0p P=0u m=1
C$891 bn8 vcn cap_cmomi w=3.31u l=4.32u A=0p P=0u m=1
C$892 vcp bp9 cap_cmomi w=3.31u l=4.32u A=0p P=0u m=1
C$893 bn9 vcn cap_cmomi w=3.31u l=4.32u A=0p P=0u m=1
C$894 vcp bp8 cap_cmomi w=3.31u l=4.32u A=0p P=0u m=1
C$895 bn8 vcn cap_cmomi w=3.31u l=4.32u A=0p P=0u m=1
C$896 vcp bp9 cap_cmomi w=3.31u l=4.32u A=0p P=0u m=1
C$897 bn9 vcn cap_cmomi w=3.31u l=4.32u A=0p P=0u m=1
C$898 vcp bp8 cap_cmomi w=3.31u l=4.32u A=0p P=0u m=1
C$899 bn8 vcn cap_cmomi w=3.31u l=4.32u A=0p P=0u m=1
C$900 vcp bp9 cap_cmomi w=3.31u l=4.32u A=0p P=0u m=1
C$901 bn9 vcn cap_cmomi w=3.31u l=4.32u A=0p P=0u m=1
C$902 vcp bp6 cap_cmomi w=3.31u l=4.32u A=0p P=0u m=1
C$903 bn6 vcn cap_cmomi w=3.31u l=4.32u A=0p P=0u m=1
C$904 vcp bp9 cap_cmomi w=3.31u l=4.32u A=0p P=0u m=1
C$905 bn9 vcn cap_cmomi w=3.31u l=4.32u A=0p P=0u m=1
C$906 vcp bp7 cap_cmomi w=3.31u l=4.32u A=0p P=0u m=1
C$907 bn7 vcn cap_cmomi w=3.31u l=4.32u A=0p P=0u m=1
C$908 vcp bp9 cap_cmomi w=3.31u l=4.32u A=0p P=0u m=1
C$909 bn9 vcn cap_cmomi w=3.31u l=4.32u A=0p P=0u m=1
C$910 vcp bp6 cap_cmomi w=3.31u l=4.32u A=0p P=0u m=1
C$911 bn6 vcn cap_cmomi w=3.31u l=4.32u A=0p P=0u m=1
C$912 vcp bp9 cap_cmomi w=3.31u l=4.32u A=0p P=0u m=1
C$913 bn9 vcn cap_cmomi w=3.31u l=4.32u A=0p P=0u m=1
C$914 vcp bp7 cap_cmomi w=3.31u l=4.32u A=0p P=0u m=1
C$915 bn7 vcn cap_cmomi w=3.31u l=4.32u A=0p P=0u m=1
C$916 vcp bp9 cap_cmomi w=3.31u l=4.32u A=0p P=0u m=1
C$917 bn9 vcn cap_cmomi w=3.31u l=4.32u A=0p P=0u m=1
C$918 vcp bp6 cap_cmomi w=3.31u l=4.32u A=0p P=0u m=1
C$919 bn6 vcn cap_cmomi w=3.31u l=4.32u A=0p P=0u m=1
C$920 vcp bp9 cap_cmomi w=3.31u l=4.32u A=0p P=0u m=1
C$921 bn9 vcn cap_cmomi w=3.31u l=4.32u A=0p P=0u m=1
C$922 vcp bp7 cap_cmomi w=3.31u l=4.32u A=0p P=0u m=1
C$923 bn7 vcn cap_cmomi w=3.31u l=4.32u A=0p P=0u m=1
C$924 vcp bp9 cap_cmomi w=3.31u l=4.32u A=0p P=0u m=1
C$925 bn9 vcn cap_cmomi w=3.31u l=4.32u A=0p P=0u m=1
C$926 vcp bp7 cap_cmomi w=3.31u l=4.32u A=0p P=0u m=1
C$927 bn7 vcn cap_cmomi w=3.31u l=4.32u A=0p P=0u m=1
C$928 vcp bp9 cap_cmomi w=3.31u l=4.32u A=0p P=0u m=1
C$929 bn9 vcn cap_cmomi w=3.31u l=4.32u A=0p P=0u m=1
C$930 vcp bp8 cap_cmomi w=3.31u l=4.32u A=0p P=0u m=1
C$931 bn8 vcn cap_cmomi w=3.31u l=4.32u A=0p P=0u m=1
C$932 vcp bp8 cap_cmomi w=3.31u l=4.32u A=0p P=0u m=1
C$933 bn8 vcn cap_cmomi w=3.31u l=4.32u A=0p P=0u m=1
C$934 vcp bp9 cap_cmomi w=3.31u l=4.32u A=0p P=0u m=1
C$935 bn9 vcn cap_cmomi w=3.31u l=4.32u A=0p P=0u m=1
C$936 vcp bp7 cap_cmomi w=3.31u l=4.32u A=0p P=0u m=1
C$937 bn7 vcn cap_cmomi w=3.31u l=4.32u A=0p P=0u m=1
C$938 vcp bp9 cap_cmomi w=3.31u l=4.32u A=0p P=0u m=1
C$939 bn9 vcn cap_cmomi w=3.31u l=4.32u A=0p P=0u m=1
C$940 vcp bp7 cap_cmomi w=3.31u l=4.32u A=0p P=0u m=1
C$941 bn7 vcn cap_cmomi w=3.31u l=4.32u A=0p P=0u m=1
C$942 vcp bp9 cap_cmomi w=3.31u l=4.32u A=0p P=0u m=1
C$943 bn9 vcn cap_cmomi w=3.31u l=4.32u A=0p P=0u m=1
C$944 vcp bp6 cap_cmomi w=3.31u l=4.32u A=0p P=0u m=1
C$945 bn6 vcn cap_cmomi w=3.31u l=4.32u A=0p P=0u m=1
C$946 vcp bp9 cap_cmomi w=3.31u l=4.32u A=0p P=0u m=1
C$947 bn9 vcn cap_cmomi w=3.31u l=4.32u A=0p P=0u m=1
C$948 vcp bp7 cap_cmomi w=3.31u l=4.32u A=0p P=0u m=1
C$949 bn7 vcn cap_cmomi w=3.31u l=4.32u A=0p P=0u m=1
C$950 vcp bp9 cap_cmomi w=3.31u l=4.32u A=0p P=0u m=1
C$951 bn9 vcn cap_cmomi w=3.31u l=4.32u A=0p P=0u m=1
C$952 vcp bp6 cap_cmomi w=3.31u l=4.32u A=0p P=0u m=1
C$953 bn6 vcn cap_cmomi w=3.31u l=4.32u A=0p P=0u m=1
C$954 vcp bp9 cap_cmomi w=3.31u l=4.32u A=0p P=0u m=1
C$955 bn9 vcn cap_cmomi w=3.31u l=4.32u A=0p P=0u m=1
C$956 vcp bp7 cap_cmomi w=3.31u l=4.32u A=0p P=0u m=1
C$957 bn7 vcn cap_cmomi w=3.31u l=4.32u A=0p P=0u m=1
C$958 vcp bp9 cap_cmomi w=3.31u l=4.32u A=0p P=0u m=1
C$959 bn9 vcn cap_cmomi w=3.31u l=4.32u A=0p P=0u m=1
C$960 vcp bp6 cap_cmomi w=3.31u l=4.32u A=0p P=0u m=1
C$961 bn6 vcn cap_cmomi w=3.31u l=4.32u A=0p P=0u m=1
C$962 vcp bp9 cap_cmomi w=3.31u l=4.32u A=0p P=0u m=1
C$963 bn9 vcn cap_cmomi w=3.31u l=4.32u A=0p P=0u m=1
C$964 vcp bp8 cap_cmomi w=3.31u l=4.32u A=0p P=0u m=1
C$965 bn8 vcn cap_cmomi w=3.31u l=4.32u A=0p P=0u m=1
C$966 vcp bp9 cap_cmomi w=3.31u l=4.32u A=0p P=0u m=1
C$967 bn9 vcn cap_cmomi w=3.31u l=4.32u A=0p P=0u m=1
C$968 vcp bp8 cap_cmomi w=3.31u l=4.32u A=0p P=0u m=1
C$969 bn8 vcn cap_cmomi w=3.31u l=4.32u A=0p P=0u m=1
C$970 vcp bp9 cap_cmomi w=3.31u l=4.32u A=0p P=0u m=1
C$971 bn9 vcn cap_cmomi w=3.31u l=4.32u A=0p P=0u m=1
C$972 vcp bp8 cap_cmomi w=3.31u l=4.32u A=0p P=0u m=1
C$973 bn8 vcn cap_cmomi w=3.31u l=4.32u A=0p P=0u m=1
C$974 vcp bp9 cap_cmomi w=3.31u l=4.32u A=0p P=0u m=1
C$975 bn9 vcn cap_cmomi w=3.31u l=4.32u A=0p P=0u m=1
C$976 vcp bp8 cap_cmomi w=3.31u l=4.32u A=0p P=0u m=1
C$977 bn8 vcn cap_cmomi w=3.31u l=4.32u A=0p P=0u m=1
C$978 vcp bp9 cap_cmomi w=3.31u l=4.32u A=0p P=0u m=1
C$979 bn9 vcn cap_cmomi w=3.31u l=4.32u A=0p P=0u m=1
C$980 vcp bp8 cap_cmomi w=3.31u l=4.32u A=0p P=0u m=1
C$981 bn8 vcn cap_cmomi w=3.31u l=4.32u A=0p P=0u m=1
C$982 vcp bp9 cap_cmomi w=3.31u l=4.32u A=0p P=0u m=1
C$983 bn9 vcn cap_cmomi w=3.31u l=4.32u A=0p P=0u m=1
C$984 vcp bp8 cap_cmomi w=3.31u l=4.32u A=0p P=0u m=1
C$985 bn8 vcn cap_cmomi w=3.31u l=4.32u A=0p P=0u m=1
C$986 vcp bp9 cap_cmomi w=3.31u l=4.32u A=0p P=0u m=1
C$987 bn9 vcn cap_cmomi w=3.31u l=4.32u A=0p P=0u m=1
C$988 vcp bp8 cap_cmomi w=3.31u l=4.32u A=0p P=0u m=1
C$989 bn8 vcn cap_cmomi w=3.31u l=4.32u A=0p P=0u m=1
C$990 vcp bp9 cap_cmomi w=3.31u l=4.32u A=0p P=0u m=1
C$991 bn9 vcn cap_cmomi w=3.31u l=4.32u A=0p P=0u m=1
C$992 vcp bp1 cap_cmomi w=3.31u l=4.32u A=0p P=0u m=1
C$993 bn1 vcn cap_cmomi w=3.31u l=4.32u A=0p P=0u m=1
C$994 vcp bp2 cap_cmomi w=3.31u l=4.32u A=0p P=0u m=1
C$995 bn2 vcn cap_cmomi w=3.31u l=4.32u A=0p P=0u m=1
C$996 vcp bp2 cap_cmomi w=3.31u l=4.32u A=0p P=0u m=1
C$997 bn2 vcn cap_cmomi w=3.31u l=4.32u A=0p P=0u m=1
C$998 vcp bp0 cap_cmomi w=3.31u l=4.32u A=0p P=0u m=1
C$999 bn0 vcn cap_cmomi w=3.31u l=4.32u A=0p P=0u m=1
C$1000 vcp bp9 cap_cmomi w=3.31u l=4.32u A=0p P=0u m=1
C$1001 bn9 vcn cap_cmomi w=3.31u l=4.32u A=0p P=0u m=1
C$1002 vcp bp8 cap_cmomi w=3.31u l=4.32u A=0p P=0u m=1
C$1003 bn8 vcn cap_cmomi w=3.31u l=4.32u A=0p P=0u m=1
C$1004 vcp bp9 cap_cmomi w=3.31u l=4.32u A=0p P=0u m=1
C$1005 bn9 vcn cap_cmomi w=3.31u l=4.32u A=0p P=0u m=1
C$1006 vcp bp8 cap_cmomi w=3.31u l=4.32u A=0p P=0u m=1
C$1007 bn8 vcn cap_cmomi w=3.31u l=4.32u A=0p P=0u m=1
C$1008 vcp bp9 cap_cmomi w=3.31u l=4.32u A=0p P=0u m=1
C$1009 bn9 vcn cap_cmomi w=3.31u l=4.32u A=0p P=0u m=1
C$1010 vcp bp8 cap_cmomi w=3.31u l=4.32u A=0p P=0u m=1
C$1011 bn8 vcn cap_cmomi w=3.31u l=4.32u A=0p P=0u m=1
C$1012 vcp bp9 cap_cmomi w=3.31u l=4.32u A=0p P=0u m=1
C$1013 bn9 vcn cap_cmomi w=3.31u l=4.32u A=0p P=0u m=1
C$1014 vcp bp8 cap_cmomi w=3.31u l=4.32u A=0p P=0u m=1
C$1015 bn8 vcn cap_cmomi w=3.31u l=4.32u A=0p P=0u m=1
C$1016 vcp bp9 cap_cmomi w=3.31u l=4.32u A=0p P=0u m=1
C$1017 bn9 vcn cap_cmomi w=3.31u l=4.32u A=0p P=0u m=1
C$1018 vcp bp8 cap_cmomi w=3.31u l=4.32u A=0p P=0u m=1
C$1019 bn8 vcn cap_cmomi w=3.31u l=4.32u A=0p P=0u m=1
C$1020 vcp bp9 cap_cmomi w=3.31u l=4.32u A=0p P=0u m=1
C$1021 bn9 vcn cap_cmomi w=3.31u l=4.32u A=0p P=0u m=1
C$1022 vcp bp8 cap_cmomi w=3.31u l=4.32u A=0p P=0u m=1
C$1023 bn8 vcn cap_cmomi w=3.31u l=4.32u A=0p P=0u m=1
C$1024 vcp bp9 cap_cmomi w=3.31u l=4.32u A=0p P=0u m=1
C$1025 bn9 vcn cap_cmomi w=3.31u l=4.32u A=0p P=0u m=1
C$1026 vcp bp8 cap_cmomi w=3.31u l=4.32u A=0p P=0u m=1
C$1027 bn8 vcn cap_cmomi w=3.31u l=4.32u A=0p P=0u m=1
C$1028 vcp bp8 cap_cmomi w=3.31u l=4.32u A=0p P=0u m=1
C$1029 bn8 vcn cap_cmomi w=3.31u l=4.32u A=0p P=0u m=1
C$1030 vcp bp9 cap_cmomi w=3.31u l=4.32u A=0p P=0u m=1
C$1031 bn9 vcn cap_cmomi w=3.31u l=4.32u A=0p P=0u m=1
C$1032 vcp bp8 cap_cmomi w=3.31u l=4.32u A=0p P=0u m=1
C$1033 bn8 vcn cap_cmomi w=3.31u l=4.32u A=0p P=0u m=1
C$1034 vcp bp9 cap_cmomi w=3.31u l=4.32u A=0p P=0u m=1
C$1035 bn9 vcn cap_cmomi w=3.31u l=4.32u A=0p P=0u m=1
C$1036 vcp bp8 cap_cmomi w=3.31u l=4.32u A=0p P=0u m=1
C$1037 bn8 vcn cap_cmomi w=3.31u l=4.32u A=0p P=0u m=1
C$1038 vcp bp9 cap_cmomi w=3.31u l=4.32u A=0p P=0u m=1
C$1039 bn9 vcn cap_cmomi w=3.31u l=4.32u A=0p P=0u m=1
C$1040 vcp bp8 cap_cmomi w=3.31u l=4.32u A=0p P=0u m=1
C$1041 bn8 vcn cap_cmomi w=3.31u l=4.32u A=0p P=0u m=1
C$1042 vcp bp9 cap_cmomi w=3.31u l=4.32u A=0p P=0u m=1
C$1043 bn9 vcn cap_cmomi w=3.31u l=4.32u A=0p P=0u m=1
C$1044 vcp bp8 cap_cmomi w=3.31u l=4.32u A=0p P=0u m=1
C$1045 bn8 vcn cap_cmomi w=3.31u l=4.32u A=0p P=0u m=1
C$1046 vcp bp9 cap_cmomi w=3.31u l=4.32u A=0p P=0u m=1
C$1047 bn9 vcn cap_cmomi w=3.31u l=4.32u A=0p P=0u m=1
C$1048 vcp bp8 cap_cmomi w=3.31u l=4.32u A=0p P=0u m=1
C$1049 bn8 vcn cap_cmomi w=3.31u l=4.32u A=0p P=0u m=1
C$1050 vcp bp9 cap_cmomi w=3.31u l=4.32u A=0p P=0u m=1
C$1051 bn9 vcn cap_cmomi w=3.31u l=4.32u A=0p P=0u m=1
C$1052 vcp bp8 cap_cmomi w=3.31u l=4.32u A=0p P=0u m=1
C$1053 bn8 vcn cap_cmomi w=3.31u l=4.32u A=0p P=0u m=1
C$1054 vcp bp9 cap_cmomi w=3.31u l=4.32u A=0p P=0u m=1
C$1055 bn9 vcn cap_cmomi w=3.31u l=4.32u A=0p P=0u m=1
C$1056 vcp bpd cap_cmomi w=3.31u l=4.32u A=0p P=0u m=1
C$1057 bnd vcn cap_cmomi w=3.31u l=4.32u A=0p P=0u m=1
C$1058 vcp bp2 cap_cmomi w=3.31u l=4.32u A=0p P=0u m=1
C$1059 bn2 vcn cap_cmomi w=3.31u l=4.32u A=0p P=0u m=1
C$1060 vcp bp2 cap_cmomi w=3.31u l=4.32u A=0p P=0u m=1
C$1061 bn2 vcn cap_cmomi w=3.31u l=4.32u A=0p P=0u m=1
C$1062 vcp bp1 cap_cmomi w=3.31u l=4.32u A=0p P=0u m=1
C$1063 bn1 vcn cap_cmomi w=3.31u l=4.32u A=0p P=0u m=1
C$1064 vcp bp9 cap_cmomi w=3.31u l=4.32u A=0p P=0u m=1
C$1065 bn9 vcn cap_cmomi w=3.31u l=4.32u A=0p P=0u m=1
C$1066 vcp bp8 cap_cmomi w=3.31u l=4.32u A=0p P=0u m=1
C$1067 bn8 vcn cap_cmomi w=3.31u l=4.32u A=0p P=0u m=1
C$1068 vcp bp9 cap_cmomi w=3.31u l=4.32u A=0p P=0u m=1
C$1069 bn9 vcn cap_cmomi w=3.31u l=4.32u A=0p P=0u m=1
C$1070 vcp bp8 cap_cmomi w=3.31u l=4.32u A=0p P=0u m=1
C$1071 bn8 vcn cap_cmomi w=3.31u l=4.32u A=0p P=0u m=1
C$1072 vcp bp9 cap_cmomi w=3.31u l=4.32u A=0p P=0u m=1
C$1073 bn9 vcn cap_cmomi w=3.31u l=4.32u A=0p P=0u m=1
C$1074 vcp bp8 cap_cmomi w=3.31u l=4.32u A=0p P=0u m=1
C$1075 bn8 vcn cap_cmomi w=3.31u l=4.32u A=0p P=0u m=1
C$1076 vcp bp9 cap_cmomi w=3.31u l=4.32u A=0p P=0u m=1
C$1077 bn9 vcn cap_cmomi w=3.31u l=4.32u A=0p P=0u m=1
C$1078 vcp bp8 cap_cmomi w=3.31u l=4.32u A=0p P=0u m=1
C$1079 bn8 vcn cap_cmomi w=3.31u l=4.32u A=0p P=0u m=1
C$1080 vcp bp9 cap_cmomi w=3.31u l=4.32u A=0p P=0u m=1
C$1081 bn9 vcn cap_cmomi w=3.31u l=4.32u A=0p P=0u m=1
C$1082 vcp bp8 cap_cmomi w=3.31u l=4.32u A=0p P=0u m=1
C$1083 bn8 vcn cap_cmomi w=3.31u l=4.32u A=0p P=0u m=1
C$1084 vcp bp9 cap_cmomi w=3.31u l=4.32u A=0p P=0u m=1
C$1085 bn9 vcn cap_cmomi w=3.31u l=4.32u A=0p P=0u m=1
C$1086 vcp bp8 cap_cmomi w=3.31u l=4.32u A=0p P=0u m=1
C$1087 bn8 vcn cap_cmomi w=3.31u l=4.32u A=0p P=0u m=1
C$1088 vcp bp9 cap_cmomi w=3.31u l=4.32u A=0p P=0u m=1
C$1089 bn9 vcn cap_cmomi w=3.31u l=4.32u A=0p P=0u m=1
C$1090 vcp bp8 cap_cmomi w=3.31u l=4.32u A=0p P=0u m=1
C$1091 bn8 vcn cap_cmomi w=3.31u l=4.32u A=0p P=0u m=1
C$1092 vcp bp9 cap_cmomi w=3.31u l=4.32u A=0p P=0u m=1
C$1093 bn9 vcn cap_cmomi w=3.31u l=4.32u A=0p P=0u m=1
C$1094 vcp bp6 cap_cmomi w=3.31u l=4.32u A=0p P=0u m=1
C$1095 bn6 vcn cap_cmomi w=3.31u l=4.32u A=0p P=0u m=1
C$1096 vcp bp9 cap_cmomi w=3.31u l=4.32u A=0p P=0u m=1
C$1097 bn9 vcn cap_cmomi w=3.31u l=4.32u A=0p P=0u m=1
C$1098 vcp bp7 cap_cmomi w=3.31u l=4.32u A=0p P=0u m=1
C$1099 bn7 vcn cap_cmomi w=3.31u l=4.32u A=0p P=0u m=1
C$1100 vcp bp9 cap_cmomi w=3.31u l=4.32u A=0p P=0u m=1
C$1101 bn9 vcn cap_cmomi w=3.31u l=4.32u A=0p P=0u m=1
C$1102 vcp bp6 cap_cmomi w=3.31u l=4.32u A=0p P=0u m=1
C$1103 bn6 vcn cap_cmomi w=3.31u l=4.32u A=0p P=0u m=1
C$1104 vcp bp9 cap_cmomi w=3.31u l=4.32u A=0p P=0u m=1
C$1105 bn9 vcn cap_cmomi w=3.31u l=4.32u A=0p P=0u m=1
C$1106 vcp bp7 cap_cmomi w=3.31u l=4.32u A=0p P=0u m=1
C$1107 bn7 vcn cap_cmomi w=3.31u l=4.32u A=0p P=0u m=1
C$1108 vcp bp9 cap_cmomi w=3.31u l=4.32u A=0p P=0u m=1
C$1109 bn9 vcn cap_cmomi w=3.31u l=4.32u A=0p P=0u m=1
C$1110 vcp bp6 cap_cmomi w=3.31u l=4.32u A=0p P=0u m=1
C$1111 bn6 vcn cap_cmomi w=3.31u l=4.32u A=0p P=0u m=1
C$1112 vcp bp9 cap_cmomi w=3.31u l=4.32u A=0p P=0u m=1
C$1113 bn9 vcn cap_cmomi w=3.31u l=4.32u A=0p P=0u m=1
C$1114 vcp bp7 cap_cmomi w=3.31u l=4.32u A=0p P=0u m=1
C$1115 bn7 vcn cap_cmomi w=3.31u l=4.32u A=0p P=0u m=1
C$1116 vcp bp9 cap_cmomi w=3.31u l=4.32u A=0p P=0u m=1
C$1117 bn9 vcn cap_cmomi w=3.31u l=4.32u A=0p P=0u m=1
C$1118 vcp bp7 cap_cmomi w=3.31u l=4.32u A=0p P=0u m=1
C$1119 bn7 vcn cap_cmomi w=3.31u l=4.32u A=0p P=0u m=1
C$1120 vcp bp9 cap_cmomi w=3.31u l=4.32u A=0p P=0u m=1
C$1121 bn9 vcn cap_cmomi w=3.31u l=4.32u A=0p P=0u m=1
C$1122 vcp bp8 cap_cmomi w=3.31u l=4.32u A=0p P=0u m=1
C$1123 bn8 vcn cap_cmomi w=3.31u l=4.32u A=0p P=0u m=1
C$1124 vcp bp8 cap_cmomi w=3.31u l=4.32u A=0p P=0u m=1
C$1125 bn8 vcn cap_cmomi w=3.31u l=4.32u A=0p P=0u m=1
C$1126 vcp bp9 cap_cmomi w=3.31u l=4.32u A=0p P=0u m=1
C$1127 bn9 vcn cap_cmomi w=3.31u l=4.32u A=0p P=0u m=1
C$1128 vcp bp7 cap_cmomi w=3.31u l=4.32u A=0p P=0u m=1
C$1129 bn7 vcn cap_cmomi w=3.31u l=4.32u A=0p P=0u m=1
C$1130 vcp bp9 cap_cmomi w=3.31u l=4.32u A=0p P=0u m=1
C$1131 bn9 vcn cap_cmomi w=3.31u l=4.32u A=0p P=0u m=1
C$1132 vcp bp7 cap_cmomi w=3.31u l=4.32u A=0p P=0u m=1
C$1133 bn7 vcn cap_cmomi w=3.31u l=4.32u A=0p P=0u m=1
C$1134 vcp bp9 cap_cmomi w=3.31u l=4.32u A=0p P=0u m=1
C$1135 bn9 vcn cap_cmomi w=3.31u l=4.32u A=0p P=0u m=1
C$1136 vcp bp6 cap_cmomi w=3.31u l=4.32u A=0p P=0u m=1
C$1137 bn6 vcn cap_cmomi w=3.31u l=4.32u A=0p P=0u m=1
C$1138 vcp bp9 cap_cmomi w=3.31u l=4.32u A=0p P=0u m=1
C$1139 bn9 vcn cap_cmomi w=3.31u l=4.32u A=0p P=0u m=1
C$1140 vcp bp7 cap_cmomi w=3.31u l=4.32u A=0p P=0u m=1
C$1141 bn7 vcn cap_cmomi w=3.31u l=4.32u A=0p P=0u m=1
C$1142 vcp bp9 cap_cmomi w=3.31u l=4.32u A=0p P=0u m=1
C$1143 bn9 vcn cap_cmomi w=3.31u l=4.32u A=0p P=0u m=1
C$1144 vcp bp6 cap_cmomi w=3.31u l=4.32u A=0p P=0u m=1
C$1145 bn6 vcn cap_cmomi w=3.31u l=4.32u A=0p P=0u m=1
C$1146 vcp bp9 cap_cmomi w=3.31u l=4.32u A=0p P=0u m=1
C$1147 bn9 vcn cap_cmomi w=3.31u l=4.32u A=0p P=0u m=1
C$1148 vcp bp7 cap_cmomi w=3.31u l=4.32u A=0p P=0u m=1
C$1149 bn7 vcn cap_cmomi w=3.31u l=4.32u A=0p P=0u m=1
C$1150 vcp bp9 cap_cmomi w=3.31u l=4.32u A=0p P=0u m=1
C$1151 bn9 vcn cap_cmomi w=3.31u l=4.32u A=0p P=0u m=1
C$1152 vcp bp6 cap_cmomi w=3.31u l=4.32u A=0p P=0u m=1
C$1153 bn6 vcn cap_cmomi w=3.31u l=4.32u A=0p P=0u m=1
C$1154 vcp bp9 cap_cmomi w=3.31u l=4.32u A=0p P=0u m=1
C$1155 bn9 vcn cap_cmomi w=3.31u l=4.32u A=0p P=0u m=1
C$1156 vcp bp8 cap_cmomi w=3.31u l=4.32u A=0p P=0u m=1
C$1157 bn8 vcn cap_cmomi w=3.31u l=4.32u A=0p P=0u m=1
C$1158 vcp bp9 cap_cmomi w=3.31u l=4.32u A=0p P=0u m=1
C$1159 bn9 vcn cap_cmomi w=3.31u l=4.32u A=0p P=0u m=1
C$1160 vcp bp8 cap_cmomi w=3.31u l=4.32u A=0p P=0u m=1
C$1161 bn8 vcn cap_cmomi w=3.31u l=4.32u A=0p P=0u m=1
C$1162 vcp bp9 cap_cmomi w=3.31u l=4.32u A=0p P=0u m=1
C$1163 bn9 vcn cap_cmomi w=3.31u l=4.32u A=0p P=0u m=1
C$1164 vcp bp8 cap_cmomi w=3.31u l=4.32u A=0p P=0u m=1
C$1165 bn8 vcn cap_cmomi w=3.31u l=4.32u A=0p P=0u m=1
C$1166 vcp bp9 cap_cmomi w=3.31u l=4.32u A=0p P=0u m=1
C$1167 bn9 vcn cap_cmomi w=3.31u l=4.32u A=0p P=0u m=1
C$1168 vcp bp8 cap_cmomi w=3.31u l=4.32u A=0p P=0u m=1
C$1169 bn8 vcn cap_cmomi w=3.31u l=4.32u A=0p P=0u m=1
C$1170 vcp bp9 cap_cmomi w=3.31u l=4.32u A=0p P=0u m=1
C$1171 bn9 vcn cap_cmomi w=3.31u l=4.32u A=0p P=0u m=1
C$1172 vcp bp8 cap_cmomi w=3.31u l=4.32u A=0p P=0u m=1
C$1173 bn8 vcn cap_cmomi w=3.31u l=4.32u A=0p P=0u m=1
C$1174 vcp bp9 cap_cmomi w=3.31u l=4.32u A=0p P=0u m=1
C$1175 bn9 vcn cap_cmomi w=3.31u l=4.32u A=0p P=0u m=1
C$1176 vcp bp8 cap_cmomi w=3.31u l=4.32u A=0p P=0u m=1
C$1177 bn8 vcn cap_cmomi w=3.31u l=4.32u A=0p P=0u m=1
C$1178 vcp bp9 cap_cmomi w=3.31u l=4.32u A=0p P=0u m=1
C$1179 bn9 vcn cap_cmomi w=3.31u l=4.32u A=0p P=0u m=1
C$1180 vcp bp8 cap_cmomi w=3.31u l=4.32u A=0p P=0u m=1
C$1181 bn8 vcn cap_cmomi w=3.31u l=4.32u A=0p P=0u m=1
C$1182 vcp bp9 cap_cmomi w=3.31u l=4.32u A=0p P=0u m=1
C$1183 bn9 vcn cap_cmomi w=3.31u l=4.32u A=0p P=0u m=1
C$1184 vcp bp8 cap_cmomi w=3.31u l=4.32u A=0p P=0u m=1
C$1185 bn8 vcn cap_cmomi w=3.31u l=4.32u A=0p P=0u m=1
C$1186 vcp bp9 cap_cmomi w=3.31u l=4.32u A=0p P=0u m=1
C$1187 bn9 vcn cap_cmomi w=3.31u l=4.32u A=0p P=0u m=1
C$1188 vcp bp9 cap_cmomi w=3.31u l=4.32u A=0p P=0u m=1
C$1189 bn9 vcn cap_cmomi w=3.31u l=4.32u A=0p P=0u m=1
C$1190 vcp bp8 cap_cmomi w=3.31u l=4.32u A=0p P=0u m=1
C$1191 bn8 vcn cap_cmomi w=3.31u l=4.32u A=0p P=0u m=1
C$1192 vcp bp9 cap_cmomi w=3.31u l=4.32u A=0p P=0u m=1
C$1193 bn9 vcn cap_cmomi w=3.31u l=4.32u A=0p P=0u m=1
C$1194 vcp bp8 cap_cmomi w=3.31u l=4.32u A=0p P=0u m=1
C$1195 bn8 vcn cap_cmomi w=3.31u l=4.32u A=0p P=0u m=1
C$1196 vcp bp9 cap_cmomi w=3.31u l=4.32u A=0p P=0u m=1
C$1197 bn9 vcn cap_cmomi w=3.31u l=4.32u A=0p P=0u m=1
C$1198 vcp bp8 cap_cmomi w=3.31u l=4.32u A=0p P=0u m=1
C$1199 bn8 vcn cap_cmomi w=3.31u l=4.32u A=0p P=0u m=1
C$1200 vcp bp9 cap_cmomi w=3.31u l=4.32u A=0p P=0u m=1
C$1201 bn9 vcn cap_cmomi w=3.31u l=4.32u A=0p P=0u m=1
C$1202 vcp bp8 cap_cmomi w=3.31u l=4.32u A=0p P=0u m=1
C$1203 bn8 vcn cap_cmomi w=3.31u l=4.32u A=0p P=0u m=1
C$1204 vcp bp9 cap_cmomi w=3.31u l=4.32u A=0p P=0u m=1
C$1205 bn9 vcn cap_cmomi w=3.31u l=4.32u A=0p P=0u m=1
C$1206 vcp bp8 cap_cmomi w=3.31u l=4.32u A=0p P=0u m=1
C$1207 bn8 vcn cap_cmomi w=3.31u l=4.32u A=0p P=0u m=1
C$1208 vcp bp9 cap_cmomi w=3.31u l=4.32u A=0p P=0u m=1
C$1209 bn9 vcn cap_cmomi w=3.31u l=4.32u A=0p P=0u m=1
C$1210 vcp bp8 cap_cmomi w=3.31u l=4.32u A=0p P=0u m=1
C$1211 bn8 vcn cap_cmomi w=3.31u l=4.32u A=0p P=0u m=1
C$1212 vcp bp9 cap_cmomi w=3.31u l=4.32u A=0p P=0u m=1
C$1213 bn9 vcn cap_cmomi w=3.31u l=4.32u A=0p P=0u m=1
C$1214 vcp bp8 cap_cmomi w=3.31u l=4.32u A=0p P=0u m=1
C$1215 bn8 vcn cap_cmomi w=3.31u l=4.32u A=0p P=0u m=1
C$1216 vcp bp9 cap_cmomi w=3.31u l=4.32u A=0p P=0u m=1
C$1217 bn9 vcn cap_cmomi w=3.31u l=4.32u A=0p P=0u m=1
C$1218 vcp bp8 cap_cmomi w=3.31u l=4.32u A=0p P=0u m=1
C$1219 bn8 vcn cap_cmomi w=3.31u l=4.32u A=0p P=0u m=1
C$1220 vcp bp9 cap_cmomi w=3.31u l=4.32u A=0p P=0u m=1
C$1221 bn9 vcn cap_cmomi w=3.31u l=4.32u A=0p P=0u m=1
C$1222 vcp bp7 cap_cmomi w=3.31u l=4.32u A=0p P=0u m=1
C$1223 bn7 vcn cap_cmomi w=3.31u l=4.32u A=0p P=0u m=1
C$1224 vcp bp9 cap_cmomi w=3.31u l=4.32u A=0p P=0u m=1
C$1225 bn9 vcn cap_cmomi w=3.31u l=4.32u A=0p P=0u m=1
C$1226 vcp bp4 cap_cmomi w=3.31u l=4.32u A=0p P=0u m=1
C$1227 bn4 vcn cap_cmomi w=3.31u l=4.32u A=0p P=0u m=1
C$1228 vcp bp9 cap_cmomi w=3.31u l=4.32u A=0p P=0u m=1
C$1229 bn9 vcn cap_cmomi w=3.31u l=4.32u A=0p P=0u m=1
C$1230 vcp bp7 cap_cmomi w=3.31u l=4.32u A=0p P=0u m=1
C$1231 bn7 vcn cap_cmomi w=3.31u l=4.32u A=0p P=0u m=1
C$1232 vcp bp9 cap_cmomi w=3.31u l=4.32u A=0p P=0u m=1
C$1233 bn9 vcn cap_cmomi w=3.31u l=4.32u A=0p P=0u m=1
C$1234 vcp bp5 cap_cmomi w=3.31u l=4.32u A=0p P=0u m=1
C$1235 bn5 vcn cap_cmomi w=3.31u l=4.32u A=0p P=0u m=1
C$1236 vcp bp9 cap_cmomi w=3.31u l=4.32u A=0p P=0u m=1
C$1237 bn9 vcn cap_cmomi w=3.31u l=4.32u A=0p P=0u m=1
C$1238 vcp bp7 cap_cmomi w=3.31u l=4.32u A=0p P=0u m=1
C$1239 bn7 vcn cap_cmomi w=3.31u l=4.32u A=0p P=0u m=1
C$1240 vcp bp9 cap_cmomi w=3.31u l=4.32u A=0p P=0u m=1
C$1241 bn9 vcn cap_cmomi w=3.31u l=4.32u A=0p P=0u m=1
C$1242 vcp bp5 cap_cmomi w=3.31u l=4.32u A=0p P=0u m=1
C$1243 bn5 vcn cap_cmomi w=3.31u l=4.32u A=0p P=0u m=1
C$1244 vcp bp9 cap_cmomi w=3.31u l=4.32u A=0p P=0u m=1
C$1245 bn9 vcn cap_cmomi w=3.31u l=4.32u A=0p P=0u m=1
C$1246 vcp bp7 cap_cmomi w=3.31u l=4.32u A=0p P=0u m=1
C$1247 bn7 vcn cap_cmomi w=3.31u l=4.32u A=0p P=0u m=1
C$1248 vcp bp9 cap_cmomi w=3.31u l=4.32u A=0p P=0u m=1
C$1249 bn9 vcn cap_cmomi w=3.31u l=4.32u A=0p P=0u m=1
C$1250 vcp bp6 cap_cmomi w=3.31u l=4.32u A=0p P=0u m=1
C$1251 bn6 vcn cap_cmomi w=3.31u l=4.32u A=0p P=0u m=1
C$1252 vcp bp6 cap_cmomi w=3.31u l=4.32u A=0p P=0u m=1
C$1253 bn6 vcn cap_cmomi w=3.31u l=4.32u A=0p P=0u m=1
C$1254 vcp bp9 cap_cmomi w=3.31u l=4.32u A=0p P=0u m=1
C$1255 bn9 vcn cap_cmomi w=3.31u l=4.32u A=0p P=0u m=1
C$1256 vcp bp7 cap_cmomi w=3.31u l=4.32u A=0p P=0u m=1
C$1257 bn7 vcn cap_cmomi w=3.31u l=4.32u A=0p P=0u m=1
C$1258 vcp bp9 cap_cmomi w=3.31u l=4.32u A=0p P=0u m=1
C$1259 bn9 vcn cap_cmomi w=3.31u l=4.32u A=0p P=0u m=1
C$1260 vcp bp5 cap_cmomi w=3.31u l=4.32u A=0p P=0u m=1
C$1261 bn5 vcn cap_cmomi w=3.31u l=4.32u A=0p P=0u m=1
C$1262 vcp bp9 cap_cmomi w=3.31u l=4.32u A=0p P=0u m=1
C$1263 bn9 vcn cap_cmomi w=3.31u l=4.32u A=0p P=0u m=1
C$1264 vcp bp7 cap_cmomi w=3.31u l=4.32u A=0p P=0u m=1
C$1265 bn7 vcn cap_cmomi w=3.31u l=4.32u A=0p P=0u m=1
C$1266 vcp bp9 cap_cmomi w=3.31u l=4.32u A=0p P=0u m=1
C$1267 bn9 vcn cap_cmomi w=3.31u l=4.32u A=0p P=0u m=1
C$1268 vcp bp5 cap_cmomi w=3.31u l=4.32u A=0p P=0u m=1
C$1269 bn5 vcn cap_cmomi w=3.31u l=4.32u A=0p P=0u m=1
C$1270 vcp bp9 cap_cmomi w=3.31u l=4.32u A=0p P=0u m=1
C$1271 bn9 vcn cap_cmomi w=3.31u l=4.32u A=0p P=0u m=1
C$1272 vcp bp7 cap_cmomi w=3.31u l=4.32u A=0p P=0u m=1
C$1273 bn7 vcn cap_cmomi w=3.31u l=4.32u A=0p P=0u m=1
C$1274 vcp bp9 cap_cmomi w=3.31u l=4.32u A=0p P=0u m=1
C$1275 bn9 vcn cap_cmomi w=3.31u l=4.32u A=0p P=0u m=1
C$1276 vcp bp4 cap_cmomi w=3.31u l=4.32u A=0p P=0u m=1
C$1277 bn4 vcn cap_cmomi w=3.31u l=4.32u A=0p P=0u m=1
C$1278 vcp bp9 cap_cmomi w=3.31u l=4.32u A=0p P=0u m=1
C$1279 bn9 vcn cap_cmomi w=3.31u l=4.32u A=0p P=0u m=1
C$1280 vcp bp7 cap_cmomi w=3.31u l=4.32u A=0p P=0u m=1
C$1281 bn7 vcn cap_cmomi w=3.31u l=4.32u A=0p P=0u m=1
C$1282 vcp bp9 cap_cmomi w=3.31u l=4.32u A=0p P=0u m=1
C$1283 bn9 vcn cap_cmomi w=3.31u l=4.32u A=0p P=0u m=1
C$1284 vcp bp8 cap_cmomi w=3.31u l=4.32u A=0p P=0u m=1
C$1285 bn8 vcn cap_cmomi w=3.31u l=4.32u A=0p P=0u m=1
C$1286 vcp bp9 cap_cmomi w=3.31u l=4.32u A=0p P=0u m=1
C$1287 bn9 vcn cap_cmomi w=3.31u l=4.32u A=0p P=0u m=1
C$1288 vcp bp8 cap_cmomi w=3.31u l=4.32u A=0p P=0u m=1
C$1289 bn8 vcn cap_cmomi w=3.31u l=4.32u A=0p P=0u m=1
C$1290 vcp bp9 cap_cmomi w=3.31u l=4.32u A=0p P=0u m=1
C$1291 bn9 vcn cap_cmomi w=3.31u l=4.32u A=0p P=0u m=1
C$1292 vcp bp8 cap_cmomi w=3.31u l=4.32u A=0p P=0u m=1
C$1293 bn8 vcn cap_cmomi w=3.31u l=4.32u A=0p P=0u m=1
C$1294 vcp bp9 cap_cmomi w=3.31u l=4.32u A=0p P=0u m=1
C$1295 bn9 vcn cap_cmomi w=3.31u l=4.32u A=0p P=0u m=1
C$1296 vcp bp8 cap_cmomi w=3.31u l=4.32u A=0p P=0u m=1
C$1297 bn8 vcn cap_cmomi w=3.31u l=4.32u A=0p P=0u m=1
C$1298 vcp bp9 cap_cmomi w=3.31u l=4.32u A=0p P=0u m=1
C$1299 bn9 vcn cap_cmomi w=3.31u l=4.32u A=0p P=0u m=1
C$1300 vcp bp8 cap_cmomi w=3.31u l=4.32u A=0p P=0u m=1
C$1301 bn8 vcn cap_cmomi w=3.31u l=4.32u A=0p P=0u m=1
C$1302 vcp bp9 cap_cmomi w=3.31u l=4.32u A=0p P=0u m=1
C$1303 bn9 vcn cap_cmomi w=3.31u l=4.32u A=0p P=0u m=1
C$1304 vcp bp8 cap_cmomi w=3.31u l=4.32u A=0p P=0u m=1
C$1305 bn8 vcn cap_cmomi w=3.31u l=4.32u A=0p P=0u m=1
C$1306 vcp bp9 cap_cmomi w=3.31u l=4.32u A=0p P=0u m=1
C$1307 bn9 vcn cap_cmomi w=3.31u l=4.32u A=0p P=0u m=1
C$1308 vcp bp8 cap_cmomi w=3.31u l=4.32u A=0p P=0u m=1
C$1309 bn8 vcn cap_cmomi w=3.31u l=4.32u A=0p P=0u m=1
C$1310 vcp bp9 cap_cmomi w=3.31u l=4.32u A=0p P=0u m=1
C$1311 bn9 vcn cap_cmomi w=3.31u l=4.32u A=0p P=0u m=1
C$1312 vcp bp8 cap_cmomi w=3.31u l=4.32u A=0p P=0u m=1
C$1313 bn8 vcn cap_cmomi w=3.31u l=4.32u A=0p P=0u m=1
C$1314 vcp bp9 cap_cmomi w=3.31u l=4.32u A=0p P=0u m=1
C$1315 bn9 vcn cap_cmomi w=3.31u l=4.32u A=0p P=0u m=1
C$1316 vcp bp9 cap_cmomi w=3.31u l=4.32u A=0p P=0u m=1
C$1317 bn9 vcn cap_cmomi w=3.31u l=4.32u A=0p P=0u m=1
C$1318 vcp bp8 cap_cmomi w=3.31u l=4.32u A=0p P=0u m=1
C$1319 bn8 vcn cap_cmomi w=3.31u l=4.32u A=0p P=0u m=1
C$1320 vcp bp9 cap_cmomi w=3.31u l=4.32u A=0p P=0u m=1
C$1321 bn9 vcn cap_cmomi w=3.31u l=4.32u A=0p P=0u m=1
C$1322 vcp bp8 cap_cmomi w=3.31u l=4.32u A=0p P=0u m=1
C$1323 bn8 vcn cap_cmomi w=3.31u l=4.32u A=0p P=0u m=1
C$1324 vcp bp9 cap_cmomi w=3.31u l=4.32u A=0p P=0u m=1
C$1325 bn9 vcn cap_cmomi w=3.31u l=4.32u A=0p P=0u m=1
C$1326 vcp bp8 cap_cmomi w=3.31u l=4.32u A=0p P=0u m=1
C$1327 bn8 vcn cap_cmomi w=3.31u l=4.32u A=0p P=0u m=1
C$1328 vcp bp9 cap_cmomi w=3.31u l=4.32u A=0p P=0u m=1
C$1329 bn9 vcn cap_cmomi w=3.31u l=4.32u A=0p P=0u m=1
C$1330 vcp bp8 cap_cmomi w=3.31u l=4.32u A=0p P=0u m=1
C$1331 bn8 vcn cap_cmomi w=3.31u l=4.32u A=0p P=0u m=1
C$1332 vcp bp9 cap_cmomi w=3.31u l=4.32u A=0p P=0u m=1
C$1333 bn9 vcn cap_cmomi w=3.31u l=4.32u A=0p P=0u m=1
C$1334 vcp bp8 cap_cmomi w=3.31u l=4.32u A=0p P=0u m=1
C$1335 bn8 vcn cap_cmomi w=3.31u l=4.32u A=0p P=0u m=1
C$1336 vcp bp9 cap_cmomi w=3.31u l=4.32u A=0p P=0u m=1
C$1337 bn9 vcn cap_cmomi w=3.31u l=4.32u A=0p P=0u m=1
C$1338 vcp bp8 cap_cmomi w=3.31u l=4.32u A=0p P=0u m=1
C$1339 bn8 vcn cap_cmomi w=3.31u l=4.32u A=0p P=0u m=1
C$1340 vcp bp9 cap_cmomi w=3.31u l=4.32u A=0p P=0u m=1
C$1341 bn9 vcn cap_cmomi w=3.31u l=4.32u A=0p P=0u m=1
C$1342 vcp bp8 cap_cmomi w=3.31u l=4.32u A=0p P=0u m=1
C$1343 bn8 vcn cap_cmomi w=3.31u l=4.32u A=0p P=0u m=1
C$1344 vcp bp9 cap_cmomi w=3.31u l=4.32u A=0p P=0u m=1
C$1345 bn9 vcn cap_cmomi w=3.31u l=4.32u A=0p P=0u m=1
C$1346 vcp bp8 cap_cmomi w=3.31u l=4.32u A=0p P=0u m=1
C$1347 bn8 vcn cap_cmomi w=3.31u l=4.32u A=0p P=0u m=1
C$1348 vcp bp9 cap_cmomi w=3.31u l=4.32u A=0p P=0u m=1
C$1349 bn9 vcn cap_cmomi w=3.31u l=4.32u A=0p P=0u m=1
C$1350 vcp bp6 cap_cmomi w=3.31u l=4.32u A=0p P=0u m=1
C$1351 bn6 vcn cap_cmomi w=3.31u l=4.32u A=0p P=0u m=1
C$1352 vcp bp9 cap_cmomi w=3.31u l=4.32u A=0p P=0u m=1
C$1353 bn9 vcn cap_cmomi w=3.31u l=4.32u A=0p P=0u m=1
C$1354 vcp bp7 cap_cmomi w=3.31u l=4.32u A=0p P=0u m=1
C$1355 bn7 vcn cap_cmomi w=3.31u l=4.32u A=0p P=0u m=1
C$1356 vcp bp9 cap_cmomi w=3.31u l=4.32u A=0p P=0u m=1
C$1357 bn9 vcn cap_cmomi w=3.31u l=4.32u A=0p P=0u m=1
C$1358 vcp bp6 cap_cmomi w=3.31u l=4.32u A=0p P=0u m=1
C$1359 bn6 vcn cap_cmomi w=3.31u l=4.32u A=0p P=0u m=1
C$1360 vcp bp9 cap_cmomi w=3.31u l=4.32u A=0p P=0u m=1
C$1361 bn9 vcn cap_cmomi w=3.31u l=4.32u A=0p P=0u m=1
C$1362 vcp bp7 cap_cmomi w=3.31u l=4.32u A=0p P=0u m=1
C$1363 bn7 vcn cap_cmomi w=3.31u l=4.32u A=0p P=0u m=1
C$1364 vcp bp9 cap_cmomi w=3.31u l=4.32u A=0p P=0u m=1
C$1365 bn9 vcn cap_cmomi w=3.31u l=4.32u A=0p P=0u m=1
C$1366 vcp bp6 cap_cmomi w=3.31u l=4.32u A=0p P=0u m=1
C$1367 bn6 vcn cap_cmomi w=3.31u l=4.32u A=0p P=0u m=1
C$1368 vcp bp9 cap_cmomi w=3.31u l=4.32u A=0p P=0u m=1
C$1369 bn9 vcn cap_cmomi w=3.31u l=4.32u A=0p P=0u m=1
C$1370 vcp bp7 cap_cmomi w=3.31u l=4.32u A=0p P=0u m=1
C$1371 bn7 vcn cap_cmomi w=3.31u l=4.32u A=0p P=0u m=1
C$1372 vcp bp9 cap_cmomi w=3.31u l=4.32u A=0p P=0u m=1
C$1373 bn9 vcn cap_cmomi w=3.31u l=4.32u A=0p P=0u m=1
C$1374 vcp bp6 cap_cmomi w=3.31u l=4.32u A=0p P=0u m=1
C$1375 bn6 vcn cap_cmomi w=3.31u l=4.32u A=0p P=0u m=1
C$1376 vcp bp9 cap_cmomi w=3.31u l=4.32u A=0p P=0u m=1
C$1377 bn9 vcn cap_cmomi w=3.31u l=4.32u A=0p P=0u m=1
C$1378 vcp bp7 cap_cmomi w=3.31u l=4.32u A=0p P=0u m=1
C$1379 bn7 vcn cap_cmomi w=3.31u l=4.32u A=0p P=0u m=1
C$1380 vcp bp7 cap_cmomi w=3.31u l=4.32u A=0p P=0u m=1
C$1381 bn7 vcn cap_cmomi w=3.31u l=4.32u A=0p P=0u m=1
C$1382 vcp bp9 cap_cmomi w=3.31u l=4.32u A=0p P=0u m=1
C$1383 bn9 vcn cap_cmomi w=3.31u l=4.32u A=0p P=0u m=1
C$1384 vcp bp6 cap_cmomi w=3.31u l=4.32u A=0p P=0u m=1
C$1385 bn6 vcn cap_cmomi w=3.31u l=4.32u A=0p P=0u m=1
C$1386 vcp bp9 cap_cmomi w=3.31u l=4.32u A=0p P=0u m=1
C$1387 bn9 vcn cap_cmomi w=3.31u l=4.32u A=0p P=0u m=1
C$1388 vcp bp7 cap_cmomi w=3.31u l=4.32u A=0p P=0u m=1
C$1389 bn7 vcn cap_cmomi w=3.31u l=4.32u A=0p P=0u m=1
C$1390 vcp bp9 cap_cmomi w=3.31u l=4.32u A=0p P=0u m=1
C$1391 bn9 vcn cap_cmomi w=3.31u l=4.32u A=0p P=0u m=1
C$1392 vcp bp6 cap_cmomi w=3.31u l=4.32u A=0p P=0u m=1
C$1393 bn6 vcn cap_cmomi w=3.31u l=4.32u A=0p P=0u m=1
C$1394 vcp bp9 cap_cmomi w=3.31u l=4.32u A=0p P=0u m=1
C$1395 bn9 vcn cap_cmomi w=3.31u l=4.32u A=0p P=0u m=1
C$1396 vcp bp7 cap_cmomi w=3.31u l=4.32u A=0p P=0u m=1
C$1397 bn7 vcn cap_cmomi w=3.31u l=4.32u A=0p P=0u m=1
C$1398 vcp bp9 cap_cmomi w=3.31u l=4.32u A=0p P=0u m=1
C$1399 bn9 vcn cap_cmomi w=3.31u l=4.32u A=0p P=0u m=1
C$1400 vcp bp6 cap_cmomi w=3.31u l=4.32u A=0p P=0u m=1
C$1401 bn6 vcn cap_cmomi w=3.31u l=4.32u A=0p P=0u m=1
C$1402 vcp bp9 cap_cmomi w=3.31u l=4.32u A=0p P=0u m=1
C$1403 bn9 vcn cap_cmomi w=3.31u l=4.32u A=0p P=0u m=1
C$1404 vcp bp7 cap_cmomi w=3.31u l=4.32u A=0p P=0u m=1
C$1405 bn7 vcn cap_cmomi w=3.31u l=4.32u A=0p P=0u m=1
C$1406 vcp bp9 cap_cmomi w=3.31u l=4.32u A=0p P=0u m=1
C$1407 bn9 vcn cap_cmomi w=3.31u l=4.32u A=0p P=0u m=1
C$1408 vcp bp6 cap_cmomi w=3.31u l=4.32u A=0p P=0u m=1
C$1409 bn6 vcn cap_cmomi w=3.31u l=4.32u A=0p P=0u m=1
C$1410 vcp bp9 cap_cmomi w=3.31u l=4.32u A=0p P=0u m=1
C$1411 bn9 vcn cap_cmomi w=3.31u l=4.32u A=0p P=0u m=1
C$1412 vcp bp8 cap_cmomi w=3.31u l=4.32u A=0p P=0u m=1
C$1413 bn8 vcn cap_cmomi w=3.31u l=4.32u A=0p P=0u m=1
C$1414 vcp bp9 cap_cmomi w=3.31u l=4.32u A=0p P=0u m=1
C$1415 bn9 vcn cap_cmomi w=3.31u l=4.32u A=0p P=0u m=1
C$1416 vcp bp8 cap_cmomi w=3.31u l=4.32u A=0p P=0u m=1
C$1417 bn8 vcn cap_cmomi w=3.31u l=4.32u A=0p P=0u m=1
C$1418 vcp bp9 cap_cmomi w=3.31u l=4.32u A=0p P=0u m=1
C$1419 bn9 vcn cap_cmomi w=3.31u l=4.32u A=0p P=0u m=1
C$1420 vcp bp8 cap_cmomi w=3.31u l=4.32u A=0p P=0u m=1
C$1421 bn8 vcn cap_cmomi w=3.31u l=4.32u A=0p P=0u m=1
C$1422 vcp bp9 cap_cmomi w=3.31u l=4.32u A=0p P=0u m=1
C$1423 bn9 vcn cap_cmomi w=3.31u l=4.32u A=0p P=0u m=1
C$1424 vcp bp8 cap_cmomi w=3.31u l=4.32u A=0p P=0u m=1
C$1425 bn8 vcn cap_cmomi w=3.31u l=4.32u A=0p P=0u m=1
C$1426 vcp bp9 cap_cmomi w=3.31u l=4.32u A=0p P=0u m=1
C$1427 bn9 vcn cap_cmomi w=3.31u l=4.32u A=0p P=0u m=1
C$1428 vcp bp8 cap_cmomi w=3.31u l=4.32u A=0p P=0u m=1
C$1429 bn8 vcn cap_cmomi w=3.31u l=4.32u A=0p P=0u m=1
C$1430 vcp bp9 cap_cmomi w=3.31u l=4.32u A=0p P=0u m=1
C$1431 bn9 vcn cap_cmomi w=3.31u l=4.32u A=0p P=0u m=1
C$1432 vcp bp8 cap_cmomi w=3.31u l=4.32u A=0p P=0u m=1
C$1433 bn8 vcn cap_cmomi w=3.31u l=4.32u A=0p P=0u m=1
C$1434 vcp bp9 cap_cmomi w=3.31u l=4.32u A=0p P=0u m=1
C$1435 bn9 vcn cap_cmomi w=3.31u l=4.32u A=0p P=0u m=1
C$1436 vcp bp8 cap_cmomi w=3.31u l=4.32u A=0p P=0u m=1
C$1437 bn8 vcn cap_cmomi w=3.31u l=4.32u A=0p P=0u m=1
C$1438 vcp bp9 cap_cmomi w=3.31u l=4.32u A=0p P=0u m=1
C$1439 bn9 vcn cap_cmomi w=3.31u l=4.32u A=0p P=0u m=1
C$1440 vcp bp8 cap_cmomi w=3.31u l=4.32u A=0p P=0u m=1
C$1441 bn8 vcn cap_cmomi w=3.31u l=4.32u A=0p P=0u m=1
C$1442 vcp bp9 cap_cmomi w=3.31u l=4.32u A=0p P=0u m=1
C$1443 bn9 vcn cap_cmomi w=3.31u l=4.32u A=0p P=0u m=1
C$1444 vcp bp9 cap_cmomi w=3.31u l=4.32u A=0p P=0u m=1
C$1445 bn9 vcn cap_cmomi w=3.31u l=4.32u A=0p P=0u m=1
C$1446 vcp bp8 cap_cmomi w=3.31u l=4.32u A=0p P=0u m=1
C$1447 bn8 vcn cap_cmomi w=3.31u l=4.32u A=0p P=0u m=1
C$1448 vcp bp9 cap_cmomi w=3.31u l=4.32u A=0p P=0u m=1
C$1449 bn9 vcn cap_cmomi w=3.31u l=4.32u A=0p P=0u m=1
C$1450 vcp bp8 cap_cmomi w=3.31u l=4.32u A=0p P=0u m=1
C$1451 bn8 vcn cap_cmomi w=3.31u l=4.32u A=0p P=0u m=1
C$1452 vcp bp9 cap_cmomi w=3.31u l=4.32u A=0p P=0u m=1
C$1453 bn9 vcn cap_cmomi w=3.31u l=4.32u A=0p P=0u m=1
C$1454 vcp bp8 cap_cmomi w=3.31u l=4.32u A=0p P=0u m=1
C$1455 bn8 vcn cap_cmomi w=3.31u l=4.32u A=0p P=0u m=1
C$1456 vcp bp9 cap_cmomi w=3.31u l=4.32u A=0p P=0u m=1
C$1457 bn9 vcn cap_cmomi w=3.31u l=4.32u A=0p P=0u m=1
C$1458 vcp bp8 cap_cmomi w=3.31u l=4.32u A=0p P=0u m=1
C$1459 bn8 vcn cap_cmomi w=3.31u l=4.32u A=0p P=0u m=1
C$1460 vcp bp9 cap_cmomi w=3.31u l=4.32u A=0p P=0u m=1
C$1461 bn9 vcn cap_cmomi w=3.31u l=4.32u A=0p P=0u m=1
C$1462 vcp bp8 cap_cmomi w=3.31u l=4.32u A=0p P=0u m=1
C$1463 bn8 vcn cap_cmomi w=3.31u l=4.32u A=0p P=0u m=1
C$1464 vcp bp9 cap_cmomi w=3.31u l=4.32u A=0p P=0u m=1
C$1465 bn9 vcn cap_cmomi w=3.31u l=4.32u A=0p P=0u m=1
C$1466 vcp bp8 cap_cmomi w=3.31u l=4.32u A=0p P=0u m=1
C$1467 bn8 vcn cap_cmomi w=3.31u l=4.32u A=0p P=0u m=1
C$1468 vcp bp9 cap_cmomi w=3.31u l=4.32u A=0p P=0u m=1
C$1469 bn9 vcn cap_cmomi w=3.31u l=4.32u A=0p P=0u m=1
C$1470 vcp bp8 cap_cmomi w=3.31u l=4.32u A=0p P=0u m=1
C$1471 bn8 vcn cap_cmomi w=3.31u l=4.32u A=0p P=0u m=1
C$1472 vcp bp9 cap_cmomi w=3.31u l=4.32u A=0p P=0u m=1
C$1473 bn9 vcn cap_cmomi w=3.31u l=4.32u A=0p P=0u m=1
C$1474 vcp bp8 cap_cmomi w=3.31u l=4.32u A=0p P=0u m=1
C$1475 bn8 vcn cap_cmomi w=3.31u l=4.32u A=0p P=0u m=1
C$1476 vcp bp9 cap_cmomi w=3.31u l=4.32u A=0p P=0u m=1
C$1477 bn9 vcn cap_cmomi w=3.31u l=4.32u A=0p P=0u m=1
C$1478 vcp bp7 cap_cmomi w=3.31u l=4.32u A=0p P=0u m=1
C$1479 bn7 vcn cap_cmomi w=3.31u l=4.32u A=0p P=0u m=1
C$1480 vcp bp9 cap_cmomi w=3.31u l=4.32u A=0p P=0u m=1
C$1481 bn9 vcn cap_cmomi w=3.31u l=4.32u A=0p P=0u m=1
C$1482 vcp bp5 cap_cmomi w=3.31u l=4.32u A=0p P=0u m=1
C$1483 bn5 vcn cap_cmomi w=3.31u l=4.32u A=0p P=0u m=1
C$1484 vcp bp9 cap_cmomi w=3.31u l=4.32u A=0p P=0u m=1
C$1485 bn9 vcn cap_cmomi w=3.31u l=4.32u A=0p P=0u m=1
C$1486 vcp bp7 cap_cmomi w=3.31u l=4.32u A=0p P=0u m=1
C$1487 bn7 vcn cap_cmomi w=3.31u l=4.32u A=0p P=0u m=1
C$1488 vcp bp9 cap_cmomi w=3.31u l=4.32u A=0p P=0u m=1
C$1489 bn9 vcn cap_cmomi w=3.31u l=4.32u A=0p P=0u m=1
C$1490 vcp bp3 cap_cmomi w=3.31u l=4.32u A=0p P=0u m=1
C$1491 bn3 vcn cap_cmomi w=3.31u l=4.32u A=0p P=0u m=1
C$1492 vcp bp9 cap_cmomi w=3.31u l=4.32u A=0p P=0u m=1
C$1493 bn9 vcn cap_cmomi w=3.31u l=4.32u A=0p P=0u m=1
C$1494 vcp bp7 cap_cmomi w=3.31u l=4.32u A=0p P=0u m=1
C$1495 bn7 vcn cap_cmomi w=3.31u l=4.32u A=0p P=0u m=1
C$1496 vcp bp9 cap_cmomi w=3.31u l=4.32u A=0p P=0u m=1
C$1497 bn9 vcn cap_cmomi w=3.31u l=4.32u A=0p P=0u m=1
C$1498 vcp bp5 cap_cmomi w=3.31u l=4.32u A=0p P=0u m=1
C$1499 bn5 vcn cap_cmomi w=3.31u l=4.32u A=0p P=0u m=1
C$1500 vcp bp9 cap_cmomi w=3.31u l=4.32u A=0p P=0u m=1
C$1501 bn9 vcn cap_cmomi w=3.31u l=4.32u A=0p P=0u m=1
C$1502 vcp bp7 cap_cmomi w=3.31u l=4.32u A=0p P=0u m=1
C$1503 bn7 vcn cap_cmomi w=3.31u l=4.32u A=0p P=0u m=1
C$1504 vcp bp9 cap_cmomi w=3.31u l=4.32u A=0p P=0u m=1
C$1505 bn9 vcn cap_cmomi w=3.31u l=4.32u A=0p P=0u m=1
C$1506 vcp bp4 cap_cmomi w=3.31u l=4.32u A=0p P=0u m=1
C$1507 bn4 vcn cap_cmomi w=3.31u l=4.32u A=0p P=0u m=1
C$1508 vcp bp4 cap_cmomi w=3.31u l=4.32u A=0p P=0u m=1
C$1509 bn4 vcn cap_cmomi w=3.31u l=4.32u A=0p P=0u m=1
C$1510 vcp bp9 cap_cmomi w=3.31u l=4.32u A=0p P=0u m=1
C$1511 bn9 vcn cap_cmomi w=3.31u l=4.32u A=0p P=0u m=1
C$1512 vcp bp7 cap_cmomi w=3.31u l=4.32u A=0p P=0u m=1
C$1513 bn7 vcn cap_cmomi w=3.31u l=4.32u A=0p P=0u m=1
C$1514 vcp bp9 cap_cmomi w=3.31u l=4.32u A=0p P=0u m=1
C$1515 bn9 vcn cap_cmomi w=3.31u l=4.32u A=0p P=0u m=1
C$1516 vcp bp5 cap_cmomi w=3.31u l=4.32u A=0p P=0u m=1
C$1517 bn5 vcn cap_cmomi w=3.31u l=4.32u A=0p P=0u m=1
C$1518 vcp bp9 cap_cmomi w=3.31u l=4.32u A=0p P=0u m=1
C$1519 bn9 vcn cap_cmomi w=3.31u l=4.32u A=0p P=0u m=1
C$1520 vcp bp7 cap_cmomi w=3.31u l=4.32u A=0p P=0u m=1
C$1521 bn7 vcn cap_cmomi w=3.31u l=4.32u A=0p P=0u m=1
C$1522 vcp bp9 cap_cmomi w=3.31u l=4.32u A=0p P=0u m=1
C$1523 bn9 vcn cap_cmomi w=3.31u l=4.32u A=0p P=0u m=1
C$1524 vcp bp3 cap_cmomi w=3.31u l=4.32u A=0p P=0u m=1
C$1525 bn3 vcn cap_cmomi w=3.31u l=4.32u A=0p P=0u m=1
C$1526 vcp bp9 cap_cmomi w=3.31u l=4.32u A=0p P=0u m=1
C$1527 bn9 vcn cap_cmomi w=3.31u l=4.32u A=0p P=0u m=1
C$1528 vcp bp7 cap_cmomi w=3.31u l=4.32u A=0p P=0u m=1
C$1529 bn7 vcn cap_cmomi w=3.31u l=4.32u A=0p P=0u m=1
C$1530 vcp bp9 cap_cmomi w=3.31u l=4.32u A=0p P=0u m=1
C$1531 bn9 vcn cap_cmomi w=3.31u l=4.32u A=0p P=0u m=1
C$1532 vcp bp5 cap_cmomi w=3.31u l=4.32u A=0p P=0u m=1
C$1533 bn5 vcn cap_cmomi w=3.31u l=4.32u A=0p P=0u m=1
C$1534 vcp bp9 cap_cmomi w=3.31u l=4.32u A=0p P=0u m=1
C$1535 bn9 vcn cap_cmomi w=3.31u l=4.32u A=0p P=0u m=1
C$1536 vcp bp7 cap_cmomi w=3.31u l=4.32u A=0p P=0u m=1
C$1537 bn7 vcn cap_cmomi w=3.31u l=4.32u A=0p P=0u m=1
C$1538 vcp bp9 cap_cmomi w=3.31u l=4.32u A=0p P=0u m=1
C$1539 bn9 vcn cap_cmomi w=3.31u l=4.32u A=0p P=0u m=1
C$1540 vcp bp8 cap_cmomi w=3.31u l=4.32u A=0p P=0u m=1
C$1541 bn8 vcn cap_cmomi w=3.31u l=4.32u A=0p P=0u m=1
C$1542 vcp bp9 cap_cmomi w=3.31u l=4.32u A=0p P=0u m=1
C$1543 bn9 vcn cap_cmomi w=3.31u l=4.32u A=0p P=0u m=1
C$1544 vcp bp8 cap_cmomi w=3.31u l=4.32u A=0p P=0u m=1
C$1545 bn8 vcn cap_cmomi w=3.31u l=4.32u A=0p P=0u m=1
C$1546 vcp bp9 cap_cmomi w=3.31u l=4.32u A=0p P=0u m=1
C$1547 bn9 vcn cap_cmomi w=3.31u l=4.32u A=0p P=0u m=1
C$1548 vcp bp8 cap_cmomi w=3.31u l=4.32u A=0p P=0u m=1
C$1549 bn8 vcn cap_cmomi w=3.31u l=4.32u A=0p P=0u m=1
C$1550 vcp bp9 cap_cmomi w=3.31u l=4.32u A=0p P=0u m=1
C$1551 bn9 vcn cap_cmomi w=3.31u l=4.32u A=0p P=0u m=1
C$1552 vcp bp9 cap_cmomi w=3.31u l=4.32u A=0p P=0u m=1
C$1553 bn9 vcn cap_cmomi w=3.31u l=4.32u A=0p P=0u m=1
C$1554 vcp bp9 cap_cmomi w=3.31u l=4.32u A=0p P=0u m=1
C$1555 bn9 vcn cap_cmomi w=3.31u l=4.32u A=0p P=0u m=1
C$1556 vcp bp8 cap_cmomi w=3.31u l=4.32u A=0p P=0u m=1
C$1557 bn8 vcn cap_cmomi w=3.31u l=4.32u A=0p P=0u m=1
C$1558 vcp bp9 cap_cmomi w=3.31u l=4.32u A=0p P=0u m=1
C$1559 bn9 vcn cap_cmomi w=3.31u l=4.32u A=0p P=0u m=1
C$1560 vcp bp8 cap_cmomi w=3.31u l=4.32u A=0p P=0u m=1
C$1561 bn8 vcn cap_cmomi w=3.31u l=4.32u A=0p P=0u m=1
C$1562 vcp bp9 cap_cmomi w=3.31u l=4.32u A=0p P=0u m=1
C$1563 bn9 vcn cap_cmomi w=3.31u l=4.32u A=0p P=0u m=1
C$1564 vcp bp8 cap_cmomi w=3.31u l=4.32u A=0p P=0u m=1
C$1565 bn8 vcn cap_cmomi w=3.31u l=4.32u A=0p P=0u m=1
C$1566 vcp bp9 cap_cmomi w=3.31u l=4.32u A=0p P=0u m=1
C$1567 bn9 vcn cap_cmomi w=3.31u l=4.32u A=0p P=0u m=1
C$1568 vcp bp8 cap_cmomi w=3.31u l=4.32u A=0p P=0u m=1
C$1569 bn8 vcn cap_cmomi w=3.31u l=4.32u A=0p P=0u m=1
C$1570 vcp bp9 cap_cmomi w=3.31u l=4.32u A=0p P=0u m=1
C$1571 bn9 vcn cap_cmomi w=3.31u l=4.32u A=0p P=0u m=1
C$1572 vcp bp9 cap_cmomi w=3.31u l=4.32u A=0p P=0u m=1
C$1573 bn9 vcn cap_cmomi w=3.31u l=4.32u A=0p P=0u m=1
C$1574 vcp bp8 cap_cmomi w=3.31u l=4.32u A=0p P=0u m=1
C$1575 bn8 vcn cap_cmomi w=3.31u l=4.32u A=0p P=0u m=1
C$1576 vcp bp9 cap_cmomi w=3.31u l=4.32u A=0p P=0u m=1
C$1577 bn9 vcn cap_cmomi w=3.31u l=4.32u A=0p P=0u m=1
C$1578 vcp bp8 cap_cmomi w=3.31u l=4.32u A=0p P=0u m=1
C$1579 bn8 vcn cap_cmomi w=3.31u l=4.32u A=0p P=0u m=1
C$1580 vcp bp9 cap_cmomi w=3.31u l=4.32u A=0p P=0u m=1
C$1581 bn9 vcn cap_cmomi w=3.31u l=4.32u A=0p P=0u m=1
C$1582 vcp bp8 cap_cmomi w=3.31u l=4.32u A=0p P=0u m=1
C$1583 bn8 vcn cap_cmomi w=3.31u l=4.32u A=0p P=0u m=1
C$1584 vcp bp9 cap_cmomi w=3.31u l=4.32u A=0p P=0u m=1
C$1585 bn9 vcn cap_cmomi w=3.31u l=4.32u A=0p P=0u m=1
C$1586 vcp bp8 cap_cmomi w=3.31u l=4.32u A=0p P=0u m=1
C$1587 bn8 vcn cap_cmomi w=3.31u l=4.32u A=0p P=0u m=1
C$1588 vcp bp9 cap_cmomi w=3.31u l=4.32u A=0p P=0u m=1
C$1589 bn9 vcn cap_cmomi w=3.31u l=4.32u A=0p P=0u m=1
C$1590 vcp bp9 cap_cmomi w=3.31u l=4.32u A=0p P=0u m=1
C$1591 bn9 vcn cap_cmomi w=3.31u l=4.32u A=0p P=0u m=1
C$1592 vcp bp9 cap_cmomi w=3.31u l=4.32u A=0p P=0u m=1
C$1593 bn9 vcn cap_cmomi w=3.31u l=4.32u A=0p P=0u m=1
C$1594 vcp bp8 cap_cmomi w=3.31u l=4.32u A=0p P=0u m=1
C$1595 bn8 vcn cap_cmomi w=3.31u l=4.32u A=0p P=0u m=1
C$1596 vcp bp9 cap_cmomi w=3.31u l=4.32u A=0p P=0u m=1
C$1597 bn9 vcn cap_cmomi w=3.31u l=4.32u A=0p P=0u m=1
C$1598 vcp bp8 cap_cmomi w=3.31u l=4.32u A=0p P=0u m=1
C$1599 bn8 vcn cap_cmomi w=3.31u l=4.32u A=0p P=0u m=1
C$1600 vcp bp9 cap_cmomi w=3.31u l=4.32u A=0p P=0u m=1
C$1601 bn9 vcn cap_cmomi w=3.31u l=4.32u A=0p P=0u m=1
C$1602 vcp bp8 cap_cmomi w=3.31u l=4.32u A=0p P=0u m=1
C$1603 bn8 vcn cap_cmomi w=3.31u l=4.32u A=0p P=0u m=1
C$1604 vcp bp9 cap_cmomi w=3.31u l=4.32u A=0p P=0u m=1
C$1605 bn9 vcn cap_cmomi w=3.31u l=4.32u A=0p P=0u m=1
C$1606 vcp bp6 cap_cmomi w=3.31u l=4.32u A=0p P=0u m=1
C$1607 bn6 vcn cap_cmomi w=3.31u l=4.32u A=0p P=0u m=1
C$1608 vcp bp9 cap_cmomi w=3.31u l=4.32u A=0p P=0u m=1
C$1609 bn9 vcn cap_cmomi w=3.31u l=4.32u A=0p P=0u m=1
C$1610 vcp bp7 cap_cmomi w=3.31u l=4.32u A=0p P=0u m=1
C$1611 bn7 vcn cap_cmomi w=3.31u l=4.32u A=0p P=0u m=1
C$1612 vcp bp9 cap_cmomi w=3.31u l=4.32u A=0p P=0u m=1
C$1613 bn9 vcn cap_cmomi w=3.31u l=4.32u A=0p P=0u m=1
C$1614 vcp bp7 cap_cmomi w=3.31u l=4.32u A=0p P=0u m=1
C$1615 bn7 vcn cap_cmomi w=3.31u l=4.32u A=0p P=0u m=1
C$1616 vcp bp9 cap_cmomi w=3.31u l=4.32u A=0p P=0u m=1
C$1617 bn9 vcn cap_cmomi w=3.31u l=4.32u A=0p P=0u m=1
C$1618 vcp bp8 cap_cmomi w=3.31u l=4.32u A=0p P=0u m=1
C$1619 bn8 vcn cap_cmomi w=3.31u l=4.32u A=0p P=0u m=1
C$1620 vcp bp9 cap_cmomi w=3.31u l=4.32u A=0p P=0u m=1
C$1621 bn9 vcn cap_cmomi w=3.31u l=4.32u A=0p P=0u m=1
C$1622 vcp bp6 cap_cmomi w=3.31u l=4.32u A=0p P=0u m=1
C$1623 bn6 vcn cap_cmomi w=3.31u l=4.32u A=0p P=0u m=1
C$1624 vcp bp9 cap_cmomi w=3.31u l=4.32u A=0p P=0u m=1
C$1625 bn9 vcn cap_cmomi w=3.31u l=4.32u A=0p P=0u m=1
C$1626 vcp bp7 cap_cmomi w=3.31u l=4.32u A=0p P=0u m=1
C$1627 bn7 vcn cap_cmomi w=3.31u l=4.32u A=0p P=0u m=1
C$1628 vcp bp9 cap_cmomi w=3.31u l=4.32u A=0p P=0u m=1
C$1629 bn9 vcn cap_cmomi w=3.31u l=4.32u A=0p P=0u m=1
C$1630 vcp bp6 cap_cmomi w=3.31u l=4.32u A=0p P=0u m=1
C$1631 bn6 vcn cap_cmomi w=3.31u l=4.32u A=0p P=0u m=1
C$1632 vcp bp9 cap_cmomi w=3.31u l=4.32u A=0p P=0u m=1
C$1633 bn9 vcn cap_cmomi w=3.31u l=4.32u A=0p P=0u m=1
C$1634 vcp bp7 cap_cmomi w=3.31u l=4.32u A=0p P=0u m=1
C$1635 bn7 vcn cap_cmomi w=3.31u l=4.32u A=0p P=0u m=1
C$1636 vcp bp7 cap_cmomi w=3.31u l=4.32u A=0p P=0u m=1
C$1637 bn7 vcn cap_cmomi w=3.31u l=4.32u A=0p P=0u m=1
C$1638 vcp bp9 cap_cmomi w=3.31u l=4.32u A=0p P=0u m=1
C$1639 bn9 vcn cap_cmomi w=3.31u l=4.32u A=0p P=0u m=1
C$1640 vcp bp6 cap_cmomi w=3.31u l=4.32u A=0p P=0u m=1
C$1641 bn6 vcn cap_cmomi w=3.31u l=4.32u A=0p P=0u m=1
C$1642 vcp bp9 cap_cmomi w=3.31u l=4.32u A=0p P=0u m=1
C$1643 bn9 vcn cap_cmomi w=3.31u l=4.32u A=0p P=0u m=1
C$1644 vcp bp7 cap_cmomi w=3.31u l=4.32u A=0p P=0u m=1
C$1645 bn7 vcn cap_cmomi w=3.31u l=4.32u A=0p P=0u m=1
C$1646 vcp bp9 cap_cmomi w=3.31u l=4.32u A=0p P=0u m=1
C$1647 bn9 vcn cap_cmomi w=3.31u l=4.32u A=0p P=0u m=1
C$1648 vcp bp6 cap_cmomi w=3.31u l=4.32u A=0p P=0u m=1
C$1649 bn6 vcn cap_cmomi w=3.31u l=4.32u A=0p P=0u m=1
C$1650 vcp bp9 cap_cmomi w=3.31u l=4.32u A=0p P=0u m=1
C$1651 bn9 vcn cap_cmomi w=3.31u l=4.32u A=0p P=0u m=1
C$1652 vcp bp8 cap_cmomi w=3.31u l=4.32u A=0p P=0u m=1
C$1653 bn8 vcn cap_cmomi w=3.31u l=4.32u A=0p P=0u m=1
C$1654 vcp bp9 cap_cmomi w=3.31u l=4.32u A=0p P=0u m=1
C$1655 bn9 vcn cap_cmomi w=3.31u l=4.32u A=0p P=0u m=1
C$1656 vcp bp7 cap_cmomi w=3.31u l=4.32u A=0p P=0u m=1
C$1657 bn7 vcn cap_cmomi w=3.31u l=4.32u A=0p P=0u m=1
C$1658 vcp bp9 cap_cmomi w=3.31u l=4.32u A=0p P=0u m=1
C$1659 bn9 vcn cap_cmomi w=3.31u l=4.32u A=0p P=0u m=1
C$1660 vcp bp7 cap_cmomi w=3.31u l=4.32u A=0p P=0u m=1
C$1661 bn7 vcn cap_cmomi w=3.31u l=4.32u A=0p P=0u m=1
C$1662 vcp bp9 cap_cmomi w=3.31u l=4.32u A=0p P=0u m=1
C$1663 bn9 vcn cap_cmomi w=3.31u l=4.32u A=0p P=0u m=1
C$1664 vcp bp6 cap_cmomi w=3.31u l=4.32u A=0p P=0u m=1
C$1665 bn6 vcn cap_cmomi w=3.31u l=4.32u A=0p P=0u m=1
C$1666 vcp bp9 cap_cmomi w=3.31u l=4.32u A=0p P=0u m=1
C$1667 bn9 vcn cap_cmomi w=3.31u l=4.32u A=0p P=0u m=1
C$1668 vcp bp8 cap_cmomi w=3.31u l=4.32u A=0p P=0u m=1
C$1669 bn8 vcn cap_cmomi w=3.31u l=4.32u A=0p P=0u m=1
C$1670 vcp bp9 cap_cmomi w=3.31u l=4.32u A=0p P=0u m=1
C$1671 bn9 vcn cap_cmomi w=3.31u l=4.32u A=0p P=0u m=1
C$1672 vcp bp8 cap_cmomi w=3.31u l=4.32u A=0p P=0u m=1
C$1673 bn8 vcn cap_cmomi w=3.31u l=4.32u A=0p P=0u m=1
C$1674 vcp bp9 cap_cmomi w=3.31u l=4.32u A=0p P=0u m=1
C$1675 bn9 vcn cap_cmomi w=3.31u l=4.32u A=0p P=0u m=1
C$1676 vcp bp8 cap_cmomi w=3.31u l=4.32u A=0p P=0u m=1
C$1677 bn8 vcn cap_cmomi w=3.31u l=4.32u A=0p P=0u m=1
C$1678 vcp bp9 cap_cmomi w=3.31u l=4.32u A=0p P=0u m=1
C$1679 bn9 vcn cap_cmomi w=3.31u l=4.32u A=0p P=0u m=1
C$1680 vcp bp8 cap_cmomi w=3.31u l=4.32u A=0p P=0u m=1
C$1681 bn8 vcn cap_cmomi w=3.31u l=4.32u A=0p P=0u m=1
C$1682 vcp bp9 cap_cmomi w=3.31u l=4.32u A=0p P=0u m=1
C$1683 bn9 vcn cap_cmomi w=3.31u l=4.32u A=0p P=0u m=1
C$1684 vcp bp8 cap_cmomi w=3.31u l=4.32u A=0p P=0u m=1
C$1685 bn8 vcn cap_cmomi w=3.31u l=4.32u A=0p P=0u m=1
C$1686 vcp bp9 cap_cmomi w=3.31u l=4.32u A=0p P=0u m=1
C$1687 bn9 vcn cap_cmomi w=3.31u l=4.32u A=0p P=0u m=1
C$1688 vcp bp8 cap_cmomi w=3.31u l=4.32u A=0p P=0u m=1
C$1689 bn8 vcn cap_cmomi w=3.31u l=4.32u A=0p P=0u m=1
C$1690 vcp bp9 cap_cmomi w=3.31u l=4.32u A=0p P=0u m=1
C$1691 bn9 vcn cap_cmomi w=3.31u l=4.32u A=0p P=0u m=1
C$1692 vcp bp8 cap_cmomi w=3.31u l=4.32u A=0p P=0u m=1
C$1693 bn8 vcn cap_cmomi w=3.31u l=4.32u A=0p P=0u m=1
C$1694 vcp bp9 cap_cmomi w=3.31u l=4.32u A=0p P=0u m=1
C$1695 bn9 vcn cap_cmomi w=3.31u l=4.32u A=0p P=0u m=1
C$1696 vcp bp8 cap_cmomi w=3.31u l=4.32u A=0p P=0u m=1
C$1697 bn8 vcn cap_cmomi w=3.31u l=4.32u A=0p P=0u m=1
C$1698 vcp bp9 cap_cmomi w=3.31u l=4.32u A=0p P=0u m=1
C$1699 bn9 vcn cap_cmomi w=3.31u l=4.32u A=0p P=0u m=1
C$1700 vcp bp9 cap_cmomi w=3.31u l=4.32u A=0p P=0u m=1
C$1701 bn9 vcn cap_cmomi w=3.31u l=4.32u A=0p P=0u m=1
C$1702 vcp bp8 cap_cmomi w=3.31u l=4.32u A=0p P=0u m=1
C$1703 bn8 vcn cap_cmomi w=3.31u l=4.32u A=0p P=0u m=1
C$1704 vcp bp9 cap_cmomi w=3.31u l=4.32u A=0p P=0u m=1
C$1705 bn9 vcn cap_cmomi w=3.31u l=4.32u A=0p P=0u m=1
C$1706 vcp bp8 cap_cmomi w=3.31u l=4.32u A=0p P=0u m=1
C$1707 bn8 vcn cap_cmomi w=3.31u l=4.32u A=0p P=0u m=1
C$1708 vcp bp9 cap_cmomi w=3.31u l=4.32u A=0p P=0u m=1
C$1709 bn9 vcn cap_cmomi w=3.31u l=4.32u A=0p P=0u m=1
C$1710 vcp bp8 cap_cmomi w=3.31u l=4.32u A=0p P=0u m=1
C$1711 bn8 vcn cap_cmomi w=3.31u l=4.32u A=0p P=0u m=1
C$1712 vcp bp9 cap_cmomi w=3.31u l=4.32u A=0p P=0u m=1
C$1713 bn9 vcn cap_cmomi w=3.31u l=4.32u A=0p P=0u m=1
C$1714 vcp bp8 cap_cmomi w=3.31u l=4.32u A=0p P=0u m=1
C$1715 bn8 vcn cap_cmomi w=3.31u l=4.32u A=0p P=0u m=1
C$1716 vcp bp9 cap_cmomi w=3.31u l=4.32u A=0p P=0u m=1
C$1717 bn9 vcn cap_cmomi w=3.31u l=4.32u A=0p P=0u m=1
C$1718 vcp bp8 cap_cmomi w=3.31u l=4.32u A=0p P=0u m=1
C$1719 bn8 vcn cap_cmomi w=3.31u l=4.32u A=0p P=0u m=1
C$1720 vcp bp9 cap_cmomi w=3.31u l=4.32u A=0p P=0u m=1
C$1721 bn9 vcn cap_cmomi w=3.31u l=4.32u A=0p P=0u m=1
C$1722 vcp bp8 cap_cmomi w=3.31u l=4.32u A=0p P=0u m=1
C$1723 bn8 vcn cap_cmomi w=3.31u l=4.32u A=0p P=0u m=1
C$1724 vcp bp9 cap_cmomi w=3.31u l=4.32u A=0p P=0u m=1
C$1725 bn9 vcn cap_cmomi w=3.31u l=4.32u A=0p P=0u m=1
C$1726 vcp bp8 cap_cmomi w=3.31u l=4.32u A=0p P=0u m=1
C$1727 bn8 vcn cap_cmomi w=3.31u l=4.32u A=0p P=0u m=1
C$1728 vcp bp9 cap_cmomi w=3.31u l=4.32u A=0p P=0u m=1
C$1729 bn9 vcn cap_cmomi w=3.31u l=4.32u A=0p P=0u m=1
C$1730 vcp bp8 cap_cmomi w=3.31u l=4.32u A=0p P=0u m=1
C$1731 bn8 vcn cap_cmomi w=3.31u l=4.32u A=0p P=0u m=1
C$1732 vcp bp9 cap_cmomi w=3.31u l=4.32u A=0p P=0u m=1
C$1733 bn9 vcn cap_cmomi w=3.31u l=4.32u A=0p P=0u m=1
C$1734 vcp bp7 cap_cmomi w=3.31u l=4.32u A=0p P=0u m=1
C$1735 bn7 vcn cap_cmomi w=3.31u l=4.32u A=0p P=0u m=1
C$1736 vcp bp9 cap_cmomi w=3.31u l=4.32u A=0p P=0u m=1
C$1737 bn9 vcn cap_cmomi w=3.31u l=4.32u A=0p P=0u m=1
C$1738 vcp bp5 cap_cmomi w=3.31u l=4.32u A=0p P=0u m=1
C$1739 bn5 vcn cap_cmomi w=3.31u l=4.32u A=0p P=0u m=1
C$1740 vcp bp9 cap_cmomi w=3.31u l=4.32u A=0p P=0u m=1
C$1741 bn9 vcn cap_cmomi w=3.31u l=4.32u A=0p P=0u m=1
C$1742 vcp bp7 cap_cmomi w=3.31u l=4.32u A=0p P=0u m=1
C$1743 bn7 vcn cap_cmomi w=3.31u l=4.32u A=0p P=0u m=1
C$1744 vcp bp9 cap_cmomi w=3.31u l=4.32u A=0p P=0u m=1
C$1745 bn9 vcn cap_cmomi w=3.31u l=4.32u A=0p P=0u m=1
C$1746 vcp bp6 cap_cmomi w=3.31u l=4.32u A=0p P=0u m=1
C$1747 bn6 vcn cap_cmomi w=3.31u l=4.32u A=0p P=0u m=1
C$1748 vcp bp9 cap_cmomi w=3.31u l=4.32u A=0p P=0u m=1
C$1749 bn9 vcn cap_cmomi w=3.31u l=4.32u A=0p P=0u m=1
C$1750 vcp bp7 cap_cmomi w=3.31u l=4.32u A=0p P=0u m=1
C$1751 bn7 vcn cap_cmomi w=3.31u l=4.32u A=0p P=0u m=1
C$1752 vcp bp9 cap_cmomi w=3.31u l=4.32u A=0p P=0u m=1
C$1753 bn9 vcn cap_cmomi w=3.31u l=4.32u A=0p P=0u m=1
C$1754 vcp bp4 cap_cmomi w=3.31u l=4.32u A=0p P=0u m=1
C$1755 bn4 vcn cap_cmomi w=3.31u l=4.32u A=0p P=0u m=1
C$1756 vcp bp9 cap_cmomi w=3.31u l=4.32u A=0p P=0u m=1
C$1757 bn9 vcn cap_cmomi w=3.31u l=4.32u A=0p P=0u m=1
C$1758 vcp bp7 cap_cmomi w=3.31u l=4.32u A=0p P=0u m=1
C$1759 bn7 vcn cap_cmomi w=3.31u l=4.32u A=0p P=0u m=1
C$1760 vcp bp9 cap_cmomi w=3.31u l=4.32u A=0p P=0u m=1
C$1761 bn9 vcn cap_cmomi w=3.31u l=4.32u A=0p P=0u m=1
C$1762 vcp bp5 cap_cmomi w=3.31u l=4.32u A=0p P=0u m=1
C$1763 bn5 vcn cap_cmomi w=3.31u l=4.32u A=0p P=0u m=1
C$1764 vcp bp5 cap_cmomi w=3.31u l=4.32u A=0p P=0u m=1
C$1765 bn5 vcn cap_cmomi w=3.31u l=4.32u A=0p P=0u m=1
C$1766 vcp bp9 cap_cmomi w=3.31u l=4.32u A=0p P=0u m=1
C$1767 bn9 vcn cap_cmomi w=3.31u l=4.32u A=0p P=0u m=1
C$1768 vcp bp7 cap_cmomi w=3.31u l=4.32u A=0p P=0u m=1
C$1769 bn7 vcn cap_cmomi w=3.31u l=4.32u A=0p P=0u m=1
C$1770 vcp bp9 cap_cmomi w=3.31u l=4.32u A=0p P=0u m=1
C$1771 bn9 vcn cap_cmomi w=3.31u l=4.32u A=0p P=0u m=1
C$1772 vcp bp4 cap_cmomi w=3.31u l=4.32u A=0p P=0u m=1
C$1773 bn4 vcn cap_cmomi w=3.31u l=4.32u A=0p P=0u m=1
C$1774 vcp bp9 cap_cmomi w=3.31u l=4.32u A=0p P=0u m=1
C$1775 bn9 vcn cap_cmomi w=3.31u l=4.32u A=0p P=0u m=1
C$1776 vcp bp7 cap_cmomi w=3.31u l=4.32u A=0p P=0u m=1
C$1777 bn7 vcn cap_cmomi w=3.31u l=4.32u A=0p P=0u m=1
C$1778 vcp bp9 cap_cmomi w=3.31u l=4.32u A=0p P=0u m=1
C$1779 bn9 vcn cap_cmomi w=3.31u l=4.32u A=0p P=0u m=1
C$1780 vcp bp6 cap_cmomi w=3.31u l=4.32u A=0p P=0u m=1
C$1781 bn6 vcn cap_cmomi w=3.31u l=4.32u A=0p P=0u m=1
C$1782 vcp bp9 cap_cmomi w=3.31u l=4.32u A=0p P=0u m=1
C$1783 bn9 vcn cap_cmomi w=3.31u l=4.32u A=0p P=0u m=1
C$1784 vcp bp7 cap_cmomi w=3.31u l=4.32u A=0p P=0u m=1
C$1785 bn7 vcn cap_cmomi w=3.31u l=4.32u A=0p P=0u m=1
C$1786 vcp bp9 cap_cmomi w=3.31u l=4.32u A=0p P=0u m=1
C$1787 bn9 vcn cap_cmomi w=3.31u l=4.32u A=0p P=0u m=1
C$1788 vcp bp5 cap_cmomi w=3.31u l=4.32u A=0p P=0u m=1
C$1789 bn5 vcn cap_cmomi w=3.31u l=4.32u A=0p P=0u m=1
C$1790 vcp bp9 cap_cmomi w=3.31u l=4.32u A=0p P=0u m=1
C$1791 bn9 vcn cap_cmomi w=3.31u l=4.32u A=0p P=0u m=1
C$1792 vcp bp7 cap_cmomi w=3.31u l=4.32u A=0p P=0u m=1
C$1793 bn7 vcn cap_cmomi w=3.31u l=4.32u A=0p P=0u m=1
C$1794 vcp bp9 cap_cmomi w=3.31u l=4.32u A=0p P=0u m=1
C$1795 bn9 vcn cap_cmomi w=3.31u l=4.32u A=0p P=0u m=1
C$1796 vcp bp8 cap_cmomi w=3.31u l=4.32u A=0p P=0u m=1
C$1797 bn8 vcn cap_cmomi w=3.31u l=4.32u A=0p P=0u m=1
C$1798 vcp bp9 cap_cmomi w=3.31u l=4.32u A=0p P=0u m=1
C$1799 bn9 vcn cap_cmomi w=3.31u l=4.32u A=0p P=0u m=1
C$1800 vcp bp8 cap_cmomi w=3.31u l=4.32u A=0p P=0u m=1
C$1801 bn8 vcn cap_cmomi w=3.31u l=4.32u A=0p P=0u m=1
C$1802 vcp bp9 cap_cmomi w=3.31u l=4.32u A=0p P=0u m=1
C$1803 bn9 vcn cap_cmomi w=3.31u l=4.32u A=0p P=0u m=1
C$1804 vcp bp8 cap_cmomi w=3.31u l=4.32u A=0p P=0u m=1
C$1805 bn8 vcn cap_cmomi w=3.31u l=4.32u A=0p P=0u m=1
C$1806 vcp bp9 cap_cmomi w=3.31u l=4.32u A=0p P=0u m=1
C$1807 bn9 vcn cap_cmomi w=3.31u l=4.32u A=0p P=0u m=1
C$1808 vcp bp8 cap_cmomi w=3.31u l=4.32u A=0p P=0u m=1
C$1809 bn8 vcn cap_cmomi w=3.31u l=4.32u A=0p P=0u m=1
C$1810 vcp bp9 cap_cmomi w=3.31u l=4.32u A=0p P=0u m=1
C$1811 bn9 vcn cap_cmomi w=3.31u l=4.32u A=0p P=0u m=1
C$1812 vcp bp8 cap_cmomi w=3.31u l=4.32u A=0p P=0u m=1
C$1813 bn8 vcn cap_cmomi w=3.31u l=4.32u A=0p P=0u m=1
C$1814 vcp bp9 cap_cmomi w=3.31u l=4.32u A=0p P=0u m=1
C$1815 bn9 vcn cap_cmomi w=3.31u l=4.32u A=0p P=0u m=1
C$1816 vcp bp8 cap_cmomi w=3.31u l=4.32u A=0p P=0u m=1
C$1817 bn8 vcn cap_cmomi w=3.31u l=4.32u A=0p P=0u m=1
C$1818 vcp bp9 cap_cmomi w=3.31u l=4.32u A=0p P=0u m=1
C$1819 bn9 vcn cap_cmomi w=3.31u l=4.32u A=0p P=0u m=1
C$1820 vcp bp8 cap_cmomi w=3.31u l=4.32u A=0p P=0u m=1
C$1821 bn8 vcn cap_cmomi w=3.31u l=4.32u A=0p P=0u m=1
C$1822 vcp bp9 cap_cmomi w=3.31u l=4.32u A=0p P=0u m=1
C$1823 bn9 vcn cap_cmomi w=3.31u l=4.32u A=0p P=0u m=1
C$1824 vcp bp8 cap_cmomi w=3.31u l=4.32u A=0p P=0u m=1
C$1825 bn8 vcn cap_cmomi w=3.31u l=4.32u A=0p P=0u m=1
C$1826 vcp bp9 cap_cmomi w=3.31u l=4.32u A=0p P=0u m=1
C$1827 bn9 vcn cap_cmomi w=3.31u l=4.32u A=0p P=0u m=1
C$1828 vcp bp9 cap_cmomi w=3.31u l=4.32u A=0p P=0u m=1
C$1829 bn9 vcn cap_cmomi w=3.31u l=4.32u A=0p P=0u m=1
C$1830 vcp bp8 cap_cmomi w=3.31u l=4.32u A=0p P=0u m=1
C$1831 bn8 vcn cap_cmomi w=3.31u l=4.32u A=0p P=0u m=1
C$1832 vcp bp9 cap_cmomi w=3.31u l=4.32u A=0p P=0u m=1
C$1833 bn9 vcn cap_cmomi w=3.31u l=4.32u A=0p P=0u m=1
C$1834 vcp bp8 cap_cmomi w=3.31u l=4.32u A=0p P=0u m=1
C$1835 bn8 vcn cap_cmomi w=3.31u l=4.32u A=0p P=0u m=1
C$1836 vcp bp9 cap_cmomi w=3.31u l=4.32u A=0p P=0u m=1
C$1837 bn9 vcn cap_cmomi w=3.31u l=4.32u A=0p P=0u m=1
C$1838 vcp bp8 cap_cmomi w=3.31u l=4.32u A=0p P=0u m=1
C$1839 bn8 vcn cap_cmomi w=3.31u l=4.32u A=0p P=0u m=1
C$1840 vcp bp9 cap_cmomi w=3.31u l=4.32u A=0p P=0u m=1
C$1841 bn9 vcn cap_cmomi w=3.31u l=4.32u A=0p P=0u m=1
C$1842 vcp bp8 cap_cmomi w=3.31u l=4.32u A=0p P=0u m=1
C$1843 bn8 vcn cap_cmomi w=3.31u l=4.32u A=0p P=0u m=1
C$1844 vcp bp9 cap_cmomi w=3.31u l=4.32u A=0p P=0u m=1
C$1845 bn9 vcn cap_cmomi w=3.31u l=4.32u A=0p P=0u m=1
C$1846 vcp bp8 cap_cmomi w=3.31u l=4.32u A=0p P=0u m=1
C$1847 bn8 vcn cap_cmomi w=3.31u l=4.32u A=0p P=0u m=1
C$1848 vcp bp9 cap_cmomi w=3.31u l=4.32u A=0p P=0u m=1
C$1849 bn9 vcn cap_cmomi w=3.31u l=4.32u A=0p P=0u m=1
C$1850 vcp bp8 cap_cmomi w=3.31u l=4.32u A=0p P=0u m=1
C$1851 bn8 vcn cap_cmomi w=3.31u l=4.32u A=0p P=0u m=1
C$1852 vcp bp9 cap_cmomi w=3.31u l=4.32u A=0p P=0u m=1
C$1853 bn9 vcn cap_cmomi w=3.31u l=4.32u A=0p P=0u m=1
C$1854 vcp bp8 cap_cmomi w=3.31u l=4.32u A=0p P=0u m=1
C$1855 bn8 vcn cap_cmomi w=3.31u l=4.32u A=0p P=0u m=1
C$1856 vcp bp9 cap_cmomi w=3.31u l=4.32u A=0p P=0u m=1
C$1857 bn9 vcn cap_cmomi w=3.31u l=4.32u A=0p P=0u m=1
C$1858 vcp bp8 cap_cmomi w=3.31u l=4.32u A=0p P=0u m=1
C$1859 bn8 vcn cap_cmomi w=3.31u l=4.32u A=0p P=0u m=1
C$1860 vcp bp9 cap_cmomi w=3.31u l=4.32u A=0p P=0u m=1
C$1861 bn9 vcn cap_cmomi w=3.31u l=4.32u A=0p P=0u m=1
C$1862 vcp bp6 cap_cmomi w=3.31u l=4.32u A=0p P=0u m=1
C$1863 bn6 vcn cap_cmomi w=3.31u l=4.32u A=0p P=0u m=1
C$1864 vcp bp9 cap_cmomi w=3.31u l=4.32u A=0p P=0u m=1
C$1865 bn9 vcn cap_cmomi w=3.31u l=4.32u A=0p P=0u m=1
C$1866 vcp bp7 cap_cmomi w=3.31u l=4.32u A=0p P=0u m=1
C$1867 bn7 vcn cap_cmomi w=3.31u l=4.32u A=0p P=0u m=1
C$1868 vcp bp9 cap_cmomi w=3.31u l=4.32u A=0p P=0u m=1
C$1869 bn9 vcn cap_cmomi w=3.31u l=4.32u A=0p P=0u m=1
C$1870 vcp bp6 cap_cmomi w=3.31u l=4.32u A=0p P=0u m=1
C$1871 bn6 vcn cap_cmomi w=3.31u l=4.32u A=0p P=0u m=1
C$1872 vcp bp9 cap_cmomi w=3.31u l=4.32u A=0p P=0u m=1
C$1873 bn9 vcn cap_cmomi w=3.31u l=4.32u A=0p P=0u m=1
C$1874 vcp bp7 cap_cmomi w=3.31u l=4.32u A=0p P=0u m=1
C$1875 bn7 vcn cap_cmomi w=3.31u l=4.32u A=0p P=0u m=1
C$1876 vcp bp9 cap_cmomi w=3.31u l=4.32u A=0p P=0u m=1
C$1877 bn9 vcn cap_cmomi w=3.31u l=4.32u A=0p P=0u m=1
C$1878 vcp bp6 cap_cmomi w=3.31u l=4.32u A=0p P=0u m=1
C$1879 bn6 vcn cap_cmomi w=3.31u l=4.32u A=0p P=0u m=1
C$1880 vcp bp9 cap_cmomi w=3.31u l=4.32u A=0p P=0u m=1
C$1881 bn9 vcn cap_cmomi w=3.31u l=4.32u A=0p P=0u m=1
C$1882 vcp bp7 cap_cmomi w=3.31u l=4.32u A=0p P=0u m=1
C$1883 bn7 vcn cap_cmomi w=3.31u l=4.32u A=0p P=0u m=1
C$1884 vcp bp9 cap_cmomi w=3.31u l=4.32u A=0p P=0u m=1
C$1885 bn9 vcn cap_cmomi w=3.31u l=4.32u A=0p P=0u m=1
C$1886 vcp bp6 cap_cmomi w=3.31u l=4.32u A=0p P=0u m=1
C$1887 bn6 vcn cap_cmomi w=3.31u l=4.32u A=0p P=0u m=1
C$1888 vcp bp9 cap_cmomi w=3.31u l=4.32u A=0p P=0u m=1
C$1889 bn9 vcn cap_cmomi w=3.31u l=4.32u A=0p P=0u m=1
C$1890 vcp bp7 cap_cmomi w=3.31u l=4.32u A=0p P=0u m=1
C$1891 bn7 vcn cap_cmomi w=3.31u l=4.32u A=0p P=0u m=1
C$1892 vcp bp7 cap_cmomi w=3.31u l=4.32u A=0p P=0u m=1
C$1893 bn7 vcn cap_cmomi w=3.31u l=4.32u A=0p P=0u m=1
C$1894 vcp bp9 cap_cmomi w=3.31u l=4.32u A=0p P=0u m=1
C$1895 bn9 vcn cap_cmomi w=3.31u l=4.32u A=0p P=0u m=1
C$1896 vcp bp6 cap_cmomi w=3.31u l=4.32u A=0p P=0u m=1
C$1897 bn6 vcn cap_cmomi w=3.31u l=4.32u A=0p P=0u m=1
C$1898 vcp bp9 cap_cmomi w=3.31u l=4.32u A=0p P=0u m=1
C$1899 bn9 vcn cap_cmomi w=3.31u l=4.32u A=0p P=0u m=1
C$1900 vcp bp7 cap_cmomi w=3.31u l=4.32u A=0p P=0u m=1
C$1901 bn7 vcn cap_cmomi w=3.31u l=4.32u A=0p P=0u m=1
C$1902 vcp bp9 cap_cmomi w=3.31u l=4.32u A=0p P=0u m=1
C$1903 bn9 vcn cap_cmomi w=3.31u l=4.32u A=0p P=0u m=1
C$1904 vcp bp6 cap_cmomi w=3.31u l=4.32u A=0p P=0u m=1
C$1905 bn6 vcn cap_cmomi w=3.31u l=4.32u A=0p P=0u m=1
C$1906 vcp bp9 cap_cmomi w=3.31u l=4.32u A=0p P=0u m=1
C$1907 bn9 vcn cap_cmomi w=3.31u l=4.32u A=0p P=0u m=1
C$1908 vcp bp7 cap_cmomi w=3.31u l=4.32u A=0p P=0u m=1
C$1909 bn7 vcn cap_cmomi w=3.31u l=4.32u A=0p P=0u m=1
C$1910 vcp bp9 cap_cmomi w=3.31u l=4.32u A=0p P=0u m=1
C$1911 bn9 vcn cap_cmomi w=3.31u l=4.32u A=0p P=0u m=1
C$1912 vcp bp6 cap_cmomi w=3.31u l=4.32u A=0p P=0u m=1
C$1913 bn6 vcn cap_cmomi w=3.31u l=4.32u A=0p P=0u m=1
C$1914 vcp bp9 cap_cmomi w=3.31u l=4.32u A=0p P=0u m=1
C$1915 bn9 vcn cap_cmomi w=3.31u l=4.32u A=0p P=0u m=1
C$1916 vcp bp7 cap_cmomi w=3.31u l=4.32u A=0p P=0u m=1
C$1917 bn7 vcn cap_cmomi w=3.31u l=4.32u A=0p P=0u m=1
C$1918 vcp bp9 cap_cmomi w=3.31u l=4.32u A=0p P=0u m=1
C$1919 bn9 vcn cap_cmomi w=3.31u l=4.32u A=0p P=0u m=1
C$1920 vcp bp6 cap_cmomi w=3.31u l=4.32u A=0p P=0u m=1
C$1921 bn6 vcn cap_cmomi w=3.31u l=4.32u A=0p P=0u m=1
C$1922 vcp bp9 cap_cmomi w=3.31u l=4.32u A=0p P=0u m=1
C$1923 bn9 vcn cap_cmomi w=3.31u l=4.32u A=0p P=0u m=1
C$1924 vcp bp8 cap_cmomi w=3.31u l=4.32u A=0p P=0u m=1
C$1925 bn8 vcn cap_cmomi w=3.31u l=4.32u A=0p P=0u m=1
C$1926 vcp bp9 cap_cmomi w=3.31u l=4.32u A=0p P=0u m=1
C$1927 bn9 vcn cap_cmomi w=3.31u l=4.32u A=0p P=0u m=1
C$1928 vcp bp8 cap_cmomi w=3.31u l=4.32u A=0p P=0u m=1
C$1929 bn8 vcn cap_cmomi w=3.31u l=4.32u A=0p P=0u m=1
C$1930 vcp bp9 cap_cmomi w=3.31u l=4.32u A=0p P=0u m=1
C$1931 bn9 vcn cap_cmomi w=3.31u l=4.32u A=0p P=0u m=1
C$1932 vcp bp8 cap_cmomi w=3.31u l=4.32u A=0p P=0u m=1
C$1933 bn8 vcn cap_cmomi w=3.31u l=4.32u A=0p P=0u m=1
C$1934 vcp bp9 cap_cmomi w=3.31u l=4.32u A=0p P=0u m=1
C$1935 bn9 vcn cap_cmomi w=3.31u l=4.32u A=0p P=0u m=1
C$1936 vcp bp8 cap_cmomi w=3.31u l=4.32u A=0p P=0u m=1
C$1937 bn8 vcn cap_cmomi w=3.31u l=4.32u A=0p P=0u m=1
C$1938 vcp bp9 cap_cmomi w=3.31u l=4.32u A=0p P=0u m=1
C$1939 bn9 vcn cap_cmomi w=3.31u l=4.32u A=0p P=0u m=1
C$1940 vcp bp8 cap_cmomi w=3.31u l=4.32u A=0p P=0u m=1
C$1941 bn8 vcn cap_cmomi w=3.31u l=4.32u A=0p P=0u m=1
C$1942 vcp bp9 cap_cmomi w=3.31u l=4.32u A=0p P=0u m=1
C$1943 bn9 vcn cap_cmomi w=3.31u l=4.32u A=0p P=0u m=1
C$1944 vcp bp8 cap_cmomi w=3.31u l=4.32u A=0p P=0u m=1
C$1945 bn8 vcn cap_cmomi w=3.31u l=4.32u A=0p P=0u m=1
C$1946 vcp bp9 cap_cmomi w=3.31u l=4.32u A=0p P=0u m=1
C$1947 bn9 vcn cap_cmomi w=3.31u l=4.32u A=0p P=0u m=1
C$1948 vcp bp8 cap_cmomi w=3.31u l=4.32u A=0p P=0u m=1
C$1949 bn8 vcn cap_cmomi w=3.31u l=4.32u A=0p P=0u m=1
C$1950 vcp bp9 cap_cmomi w=3.31u l=4.32u A=0p P=0u m=1
C$1951 bn9 vcn cap_cmomi w=3.31u l=4.32u A=0p P=0u m=1
C$1952 vcp bp8 cap_cmomi w=3.31u l=4.32u A=0p P=0u m=1
C$1953 bn8 vcn cap_cmomi w=3.31u l=4.32u A=0p P=0u m=1
C$1954 vcp bp9 cap_cmomi w=3.31u l=4.32u A=0p P=0u m=1
C$1955 bn9 vcn cap_cmomi w=3.31u l=4.32u A=0p P=0u m=1
C$1956 vcp bp9 cap_cmomi w=3.31u l=4.32u A=0p P=0u m=1
C$1957 bn9 vcn cap_cmomi w=3.31u l=4.32u A=0p P=0u m=1
C$1958 vcp bp8 cap_cmomi w=3.31u l=4.32u A=0p P=0u m=1
C$1959 bn8 vcn cap_cmomi w=3.31u l=4.32u A=0p P=0u m=1
C$1960 vcp bp9 cap_cmomi w=3.31u l=4.32u A=0p P=0u m=1
C$1961 bn9 vcn cap_cmomi w=3.31u l=4.32u A=0p P=0u m=1
C$1962 vcp bp8 cap_cmomi w=3.31u l=4.32u A=0p P=0u m=1
C$1963 bn8 vcn cap_cmomi w=3.31u l=4.32u A=0p P=0u m=1
C$1964 vcp bp9 cap_cmomi w=3.31u l=4.32u A=0p P=0u m=1
C$1965 bn9 vcn cap_cmomi w=3.31u l=4.32u A=0p P=0u m=1
C$1966 vcp bp8 cap_cmomi w=3.31u l=4.32u A=0p P=0u m=1
C$1967 bn8 vcn cap_cmomi w=3.31u l=4.32u A=0p P=0u m=1
C$1968 vcp bp9 cap_cmomi w=3.31u l=4.32u A=0p P=0u m=1
C$1969 bn9 vcn cap_cmomi w=3.31u l=4.32u A=0p P=0u m=1
C$1970 vcp bp8 cap_cmomi w=3.31u l=4.32u A=0p P=0u m=1
C$1971 bn8 vcn cap_cmomi w=3.31u l=4.32u A=0p P=0u m=1
C$1972 vcp bp9 cap_cmomi w=3.31u l=4.32u A=0p P=0u m=1
C$1973 bn9 vcn cap_cmomi w=3.31u l=4.32u A=0p P=0u m=1
C$1974 vcp bp8 cap_cmomi w=3.31u l=4.32u A=0p P=0u m=1
C$1975 bn8 vcn cap_cmomi w=3.31u l=4.32u A=0p P=0u m=1
C$1976 vcp bp9 cap_cmomi w=3.31u l=4.32u A=0p P=0u m=1
C$1977 bn9 vcn cap_cmomi w=3.31u l=4.32u A=0p P=0u m=1
C$1978 vcp bp8 cap_cmomi w=3.31u l=4.32u A=0p P=0u m=1
C$1979 bn8 vcn cap_cmomi w=3.31u l=4.32u A=0p P=0u m=1
C$1980 vcp bp9 cap_cmomi w=3.31u l=4.32u A=0p P=0u m=1
C$1981 bn9 vcn cap_cmomi w=3.31u l=4.32u A=0p P=0u m=1
C$1982 vcp bp8 cap_cmomi w=3.31u l=4.32u A=0p P=0u m=1
C$1983 bn8 vcn cap_cmomi w=3.31u l=4.32u A=0p P=0u m=1
C$1984 vcp bp9 cap_cmomi w=3.31u l=4.32u A=0p P=0u m=1
C$1985 bn9 vcn cap_cmomi w=3.31u l=4.32u A=0p P=0u m=1
C$1986 vcp bp8 cap_cmomi w=3.31u l=4.32u A=0p P=0u m=1
C$1987 bn8 vcn cap_cmomi w=3.31u l=4.32u A=0p P=0u m=1
C$1988 vcp bp9 cap_cmomi w=3.31u l=4.32u A=0p P=0u m=1
C$1989 bn9 vcn cap_cmomi w=3.31u l=4.32u A=0p P=0u m=1
C$1990 vcp bp7 cap_cmomi w=3.31u l=4.32u A=0p P=0u m=1
C$1991 bn7 vcn cap_cmomi w=3.31u l=4.32u A=0p P=0u m=1
C$1992 vcp bp9 cap_cmomi w=3.31u l=4.32u A=0p P=0u m=1
C$1993 bn9 vcn cap_cmomi w=3.31u l=4.32u A=0p P=0u m=1
C$1994 vcp bp5 cap_cmomi w=3.31u l=4.32u A=0p P=0u m=1
C$1995 bn5 vcn cap_cmomi w=3.31u l=4.32u A=0p P=0u m=1
C$1996 vcp bp9 cap_cmomi w=3.31u l=4.32u A=0p P=0u m=1
C$1997 bn9 vcn cap_cmomi w=3.31u l=4.32u A=0p P=0u m=1
C$1998 vcp bp7 cap_cmomi w=3.31u l=4.32u A=0p P=0u m=1
C$1999 bn7 vcn cap_cmomi w=3.31u l=4.32u A=0p P=0u m=1
C$2000 vcp bp9 cap_cmomi w=3.31u l=4.32u A=0p P=0u m=1
C$2001 bn9 vcn cap_cmomi w=3.31u l=4.32u A=0p P=0u m=1
C$2002 vcp bp4 cap_cmomi w=3.31u l=4.32u A=0p P=0u m=1
C$2003 bn4 vcn cap_cmomi w=3.31u l=4.32u A=0p P=0u m=1
C$2004 vcp bp9 cap_cmomi w=3.31u l=4.32u A=0p P=0u m=1
C$2005 bn9 vcn cap_cmomi w=3.31u l=4.32u A=0p P=0u m=1
C$2006 vcp bp7 cap_cmomi w=3.31u l=4.32u A=0p P=0u m=1
C$2007 bn7 vcn cap_cmomi w=3.31u l=4.32u A=0p P=0u m=1
C$2008 vcp bp9 cap_cmomi w=3.31u l=4.32u A=0p P=0u m=1
C$2009 bn9 vcn cap_cmomi w=3.31u l=4.32u A=0p P=0u m=1
C$2010 vcp bp5 cap_cmomi w=3.31u l=4.32u A=0p P=0u m=1
C$2011 bn5 vcn cap_cmomi w=3.31u l=4.32u A=0p P=0u m=1
C$2012 vcp bp9 cap_cmomi w=3.31u l=4.32u A=0p P=0u m=1
C$2013 bn9 vcn cap_cmomi w=3.31u l=4.32u A=0p P=0u m=1
C$2014 vcp bp7 cap_cmomi w=3.31u l=4.32u A=0p P=0u m=1
C$2015 bn7 vcn cap_cmomi w=3.31u l=4.32u A=0p P=0u m=1
C$2016 vcp bp9 cap_cmomi w=3.31u l=4.32u A=0p P=0u m=1
C$2017 bn9 vcn cap_cmomi w=3.31u l=4.32u A=0p P=0u m=1
C$2018 vcp bp3 cap_cmomi w=3.31u l=4.32u A=0p P=0u m=1
C$2019 bn3 vcn cap_cmomi w=3.31u l=4.32u A=0p P=0u m=1
C$2020 vcp bp3 cap_cmomi w=3.31u l=4.32u A=0p P=0u m=1
C$2021 bn3 vcn cap_cmomi w=3.31u l=4.32u A=0p P=0u m=1
C$2022 vcp bp9 cap_cmomi w=3.31u l=4.32u A=0p P=0u m=1
C$2023 bn9 vcn cap_cmomi w=3.31u l=4.32u A=0p P=0u m=1
C$2024 vcp bp7 cap_cmomi w=3.31u l=4.32u A=0p P=0u m=1
C$2025 bn7 vcn cap_cmomi w=3.31u l=4.32u A=0p P=0u m=1
C$2026 vcp bp9 cap_cmomi w=3.31u l=4.32u A=0p P=0u m=1
C$2027 bn9 vcn cap_cmomi w=3.31u l=4.32u A=0p P=0u m=1
C$2028 vcp bp5 cap_cmomi w=3.31u l=4.32u A=0p P=0u m=1
C$2029 bn5 vcn cap_cmomi w=3.31u l=4.32u A=0p P=0u m=1
C$2030 vcp bp9 cap_cmomi w=3.31u l=4.32u A=0p P=0u m=1
C$2031 bn9 vcn cap_cmomi w=3.31u l=4.32u A=0p P=0u m=1
C$2032 vcp bp7 cap_cmomi w=3.31u l=4.32u A=0p P=0u m=1
C$2033 bn7 vcn cap_cmomi w=3.31u l=4.32u A=0p P=0u m=1
C$2034 vcp bp9 cap_cmomi w=3.31u l=4.32u A=0p P=0u m=1
C$2035 bn9 vcn cap_cmomi w=3.31u l=4.32u A=0p P=0u m=1
C$2036 vcp bp4 cap_cmomi w=3.31u l=4.32u A=0p P=0u m=1
C$2037 bn4 vcn cap_cmomi w=3.31u l=4.32u A=0p P=0u m=1
C$2038 vcp bp9 cap_cmomi w=3.31u l=4.32u A=0p P=0u m=1
C$2039 bn9 vcn cap_cmomi w=3.31u l=4.32u A=0p P=0u m=1
C$2040 vcp bp7 cap_cmomi w=3.31u l=4.32u A=0p P=0u m=1
C$2041 bn7 vcn cap_cmomi w=3.31u l=4.32u A=0p P=0u m=1
C$2042 vcp bp9 cap_cmomi w=3.31u l=4.32u A=0p P=0u m=1
C$2043 bn9 vcn cap_cmomi w=3.31u l=4.32u A=0p P=0u m=1
C$2044 vcp bp5 cap_cmomi w=3.31u l=4.32u A=0p P=0u m=1
C$2045 bn5 vcn cap_cmomi w=3.31u l=4.32u A=0p P=0u m=1
C$2046 vcp bp9 cap_cmomi w=3.31u l=4.32u A=0p P=0u m=1
C$2047 bn9 vcn cap_cmomi w=3.31u l=4.32u A=0p P=0u m=1
C$2048 vcp bp7 cap_cmomi w=3.31u l=4.32u A=0p P=0u m=1
C$2049 bn7 vcn cap_cmomi w=3.31u l=4.32u A=0p P=0u m=1
C$2050 vcp bp9 cap_cmomi w=3.31u l=4.32u A=0p P=0u m=1
C$2051 bn9 vcn cap_cmomi w=3.31u l=4.32u A=0p P=0u m=1
C$2052 vcp bp9 cap_cmomi w=3.31u l=4.32u A=0p P=0u m=1
C$2053 vcp bp9 cap_cmomi w=3.31u l=4.32u A=0p P=0u m=1
C$2054 vcp bp9 cap_cmomi w=3.31u l=4.32u A=0p P=0u m=1
.ENDS cdac_array_10b_diff
