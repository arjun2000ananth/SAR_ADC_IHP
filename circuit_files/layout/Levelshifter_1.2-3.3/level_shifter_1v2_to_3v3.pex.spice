* PEX produced on Fri Oct  2 09:24:28 AM CEST 2026 using /foss/tools/sak/sak-pex.sh with m=3 and s=1 (extresist threshold=10000 mOhm, minres=1000 mOhm, mindelay=1 ps)
* NGSPICE file created from level_shifter_1v2_to_3v3_pex.ext - technology: ihp-sg13cmos5l

.subckt level_shifter_1v2_to_3v3_pex vss vddl in out vddh well_uq0
X0 a_n469_3854# a_n1521_734# vss.t3 vss.t10 sg13_hv_nmos ad=0.68p pd=4.68u as=0.68p ps=4.68u w=2u l=0.45u
X1 vss a_n469_3854# vddh vddh sg13_hv_pmos ad=0.68p pd=4.68u as=0.68p ps=4.68u w=2u l=0.4u
X2 a_n469_3854# a_n1521_734# vss.t6 vss.t11 sg13_hv_nmos ad=0.68p pd=4.68u as=0.68p ps=4.68u w=2u l=0.45u
X3 a_n469_3854# vss vddh vddh sg13_hv_pmos ad=0.68p pd=4.68u as=0.68p ps=4.68u w=2u l=0.4u
X4 vss in vss.t6 vss.t5 sg13_hv_nmos ad=0.68p pd=4.68u as=0.68p ps=4.68u w=2u l=0.45u
X5 out vss vddh vddh sg13_hv_pmos ad=0.68p pd=4.68u as=0.68p ps=4.68u w=2u l=0.4u
X6 a_n469_3854# a_n1521_734# vss.t6 vss.t7 sg13_hv_nmos ad=0.68p pd=4.68u as=0.68p ps=4.68u w=2u l=0.45u
X7 out vss vddh vddh sg13_hv_pmos ad=0.68p pd=4.68u as=0.68p ps=4.68u w=2u l=0.4u
X8 out vss vss.t3 vss.t13 sg13_hv_nmos ad=0.68p pd=4.68u as=0.68p ps=4.68u w=2u l=0.45u
X9 vss in vss.t3 vss.t4 sg13_hv_nmos ad=0.68p pd=4.68u as=0.68p ps=4.68u w=2u l=0.45u
X10 a_n1521_734# in well_uq0 well_uq0 sg13_lv_pmos ad=0.408p pd=3.08u as=0.408p ps=3.08u w=1.2u l=0.13u
X11 vss in vss.t8 vss.t7 sg13_hv_nmos ad=0.68p pd=4.68u as=0.68p ps=4.68u w=2u l=0.45u
X12 a_n469_3854# a_n1521_734# vss.t3 vss.t9 sg13_hv_nmos ad=0.68p pd=4.68u as=0.68p ps=4.68u w=2u l=0.45u
X13 a_n1521_734# in vss.t1 vss.t0 sg13_lv_nmos ad=0.204p pd=1.88u as=0.204p ps=1.88u w=0.6u l=0.13u
X14 vss in vss.t3 vss.t2 sg13_hv_nmos ad=0.68p pd=4.68u as=0.68p ps=4.68u w=2u l=0.45u
R0 vss.t0 vss.t13 25593.9
R1 vss.t11 vss.t5 1315.79
R2 vss.t5 vss.t0 1271.93
R3 vss.t13 vss.t9 799.289
R4 vss.t4 vss.t10 799.289
R5 vss.t9 vss.n0 753.996
R6 vss.t7 vss.t4 686.058
R7 vss.t10 vss.t8 385.353
R8 vss.t7 vss.t11 186.405
R9 vss.n1 vss.t7 67.9401
R10 vss.t2 vss.n0 45.2936
R11 vss.n1 vss.t2 45.2936
R12 vss.t6 vss.n2 23.1744
R13 vss vss.t3 10.8782
R14 vss.t3 vss.t1 9.2964
R15 vss.n2 vss.n1 8.5005
R16 vss.n2 vss.n0 8.5005
R17 vss.t8 vss.t6 1.3205
R18 vss.t1 vss.t6 1.2633
C0 in out 0.01051f
C1 a_n1521_734# out 0.25278f
C2 in a_n469_3854# 0.11672f
C3 a_n1521_734# a_n469_3854# 0.41239f
C4 in well_uq0 0.17832f
C5 well_uq0 a_n1521_734# 0.43103f
C6 out a_n469_3854# 1.49657f
C7 vddh a_n1521_734# 0.0185f
C8 vddh out 1.77106f
C9 in a_n1521_734# 3.00476f
C10 vddh a_n469_3854# 1.47116f
C11 out vss 4.16075f
C12 well_uq0 vss 0.95782f
C13 vddh vss 16.34648f
C14 a_n469_3854# vss 5.68078f
C15 vss.t6 vss 2.01985f
C16 vss.t3 vss 3.39124f
.ends
