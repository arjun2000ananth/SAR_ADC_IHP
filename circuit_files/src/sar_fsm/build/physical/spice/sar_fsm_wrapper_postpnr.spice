* =============================================================
* SAR FSM - POST-P&R TRANSISTOR-LEVEL SPICE
* Generated from final OpenROAD ODB
* Includes SG13CMOS5L standard-cell transistor definitions
*
* Logical equivalence:
*   1032 / 1032 equivalence cells proven
*
* NOTE:
*   This is post-P&R functional transistor-level SPICE.
*   It does NOT yet contain extracted routing RC parasitics.
* =============================================================

* -------------------------------------------------------------
* SG13CMOS5L STANDARD CELL DEFINITIONS
* -------------------------------------------------------------
************************************************************************
*
* Copyright 2023 IHP PDK Authors
*
* Licensed under the Apache License, Version 2.0 (the "License");
* you may not use this file except in compliance with the License.
* You may obtain a copy of the License at
*
*    https://www.apache.org/licenses/LICENSE-2.0
*
* Unless required by applicable law or agreed to in writing, software
* distributed under the License is distributed on an "AS IS" BASIS,
* WITHOUT WARRANTIES OR CONDITIONS OF ANY KIND, either express or implied.
* See the License for the specific language governing permissions and
* limitations under the License.
*
************************************************************************

************************************************************************
* Library Name: sg13cmos5l_stdcell
* Cell Name:    sg13cmos5l_a21o_1
* View Name:    schematic
************************************************************************

.SUBCKT sg13cmos5l_a21o_1 X A1 A2 B1 VDD VSS
*.PININFO A1:I A2:I B1:I X:O VDD:B VSS:B
MN0 net1 A1 net2 VSS sg13_lv_nmos m=1 w=640.00n l=130.00n ng=1
MN1 net2 A2 VSS VSS sg13_lv_nmos m=1 w=640.00n l=130.00n ng=1
MN2 net1 B1 VSS VSS sg13_lv_nmos m=1 w=640.00n l=130.00n ng=1
MN3 X net1 VSS VSS sg13_lv_nmos m=1 w=740.00n l=130.00n ng=1
MP2 net1 B1 net3 VDD sg13_lv_pmos m=1 w=1.000u l=130.00n ng=1
MP0 net3 A1 VDD VDD sg13_lv_pmos m=1 w=1.000u l=130.00n ng=1
MP1 net3 A2 VDD VDD sg13_lv_pmos m=1 w=1.000u l=130.00n ng=1
MP3 X net1 VDD VDD sg13_lv_pmos m=1 w=1.12u l=130.00n ng=1
.ENDS

************************************************************************
* Library Name: sg13cmos5l_stdcell
* Cell Name:    sg13cmos5l_a21o_2
* View Name:    schematic
************************************************************************

.SUBCKT sg13cmos5l_a21o_2 X A1 A2 B1 VDD VSS
*.PININFO A1:I A2:I B1:I X:O VDD:B VSS:B
MN0 net1 A1 net2 VSS sg13_lv_nmos m=1 w=740.00n l=130.00n ng=1
MN1 net2 A2 VSS VSS sg13_lv_nmos m=1 w=740.00n l=130.00n ng=1
MN2 net1 B1 VSS VSS sg13_lv_nmos m=1 w=740.00n l=130.00n ng=1
MN3 X net1 VSS VSS sg13_lv_nmos m=1 w=1.48u l=130.00n ng=2
MP2 net1 B1 net3 VDD sg13_lv_pmos m=1 w=1.000u l=130.00n ng=1
MP0 net3 A1 VDD VDD sg13_lv_pmos m=1 w=1.000u l=130.00n ng=1
MP1 net3 A2 VDD VDD sg13_lv_pmos m=1 w=1.000u l=130.00n ng=1
MP3 X net1 VDD VDD sg13_lv_pmos m=1 w=2.24u l=130.00n ng=2
.ENDS

************************************************************************
* Library Name: sg13cmos5l_stdcell
* Cell Name:    sg13cmos5l_a21oi_1
* View Name:    schematic
************************************************************************

.SUBCKT sg13cmos5l_a21oi_1 Y A1 A2 B1 VDD VSS
*.PININFO A1:I A2:I B1:I Y:O VDD:B VSS:B
MN0 Y B1 VSS VSS sg13_lv_nmos m=1 w=740.00n l=130.00n ng=1
MN2 net1 A2 VSS VSS sg13_lv_nmos m=1 w=740.00n l=130.00n ng=1
MN1 Y A1 net1 VSS sg13_lv_nmos m=1 w=740.00n l=130.00n ng=1
MP2 Y B1 net2 VDD sg13_lv_pmos m=1 w=1.12u l=130.00n ng=1
MP1 net2 A2 VDD VDD sg13_lv_pmos m=1 w=1.12u l=130.00n ng=1
MP0 net2 A1 VDD VDD sg13_lv_pmos m=1 w=1.12u l=130.00n ng=1
.ENDS

************************************************************************
* Library Name: sg13cmos5l_stdcell
* Cell Name:    sg13cmos5l_a21oi_2
* View Name:    schematic
************************************************************************

.SUBCKT sg13cmos5l_a21oi_2 Y A1 A2 B1 VDD VSS
*.PININFO A1:I A2:I B1:I Y:O VDD:B VSS:B
MN0 Y B1 VSS VSS sg13_lv_nmos m=1 w=1.48u l=130.00n ng=2
MN2 net2 A2 VSS VSS sg13_lv_nmos m=1 w=1.48u l=130.00n ng=2
MN1 Y A1 net2 VSS sg13_lv_nmos m=1 w=1.48u l=130.00n ng=2
MP2 Y B1 net1 VDD sg13_lv_pmos m=1 w=2.24u l=130.00n ng=2
MP1 net1 A2 VDD VDD sg13_lv_pmos m=1 w=2.24u l=130.00n ng=2
MP0 net1 A1 VDD VDD sg13_lv_pmos m=1 w=2.24u l=130.00n ng=2
.ENDS

************************************************************************
* Library Name: sg13cmos5l_stdcell
* Cell Name:    sg13cmos5l_a221oi_1
* View Name:    schematic
************************************************************************

.SUBCKT sg13cmos5l_a221oi_1 Y A1 A2 B1 B2 C1 VDD VSS
*.PININFO A1:I A2:I B1:I B2:I C1:I Y:O VDD:B VSS:B
MP2 Y C1 net3 VDD sg13_lv_pmos m=1 w=1.12u l=130.00n ng=1
MP4 net3 B2 net1 VDD sg13_lv_pmos m=1 w=1.12u l=130.00n ng=1
MP1 net3 B1 net1 VDD sg13_lv_pmos m=1 w=1.12u l=130.00n ng=1
MP3 net1 A2 VDD VDD sg13_lv_pmos m=1 w=1.12u l=130.00n ng=1
MP0 net1 A1 VDD VDD sg13_lv_pmos m=1 w=1.12u l=130.00n ng=1
MN4 Y C1 VSS VSS sg13_lv_nmos m=1 w=740.00n l=130.00n ng=1
MN3 net4 B2 VSS VSS sg13_lv_nmos m=1 w=740.00n l=130.00n ng=1
MN2 Y B1 net4 VSS sg13_lv_nmos m=1 w=740.00n l=130.00n ng=1
MN1 net2 A2 VSS VSS sg13_lv_nmos m=1 w=740.00n l=130.00n ng=1
MN0 Y A1 net2 VSS sg13_lv_nmos m=1 w=740.00n l=130.00n ng=1
.ENDS

************************************************************************
* Library Name: sg13cmos5l_stdcell
* Cell Name:    sg13cmos5l_and2_1
* View Name:    schematic
************************************************************************

.SUBCKT sg13cmos5l_and2_1 X A B VDD VSS
*.PININFO A:I B:I X:O VDD:B VSS:B
MN0 net4 A net2 VSS sg13_lv_nmos m=1 w=640.00n l=130.00n ng=1
MN2 X net4 VSS VSS sg13_lv_nmos m=1 w=740.00n l=130.00n ng=1
MN1 net2 B VSS VSS sg13_lv_nmos m=1 w=640.00n l=130.00n ng=1
MP0 net4 B VDD VDD sg13_lv_pmos m=1 w=840.00n l=130.00n ng=1
MP2 X net4 VDD VDD sg13_lv_pmos m=1 w=1.12u l=130.00n ng=1
MP1 net4 A VDD VDD sg13_lv_pmos m=1 w=840.00n l=130.00n ng=1
.ENDS

************************************************************************
* Library Name: sg13cmos5l_stdcell
* Cell Name:    sg13cmos5l_and2_2
* View Name:    schematic
************************************************************************

.SUBCKT sg13cmos5l_and2_2 X A B VDD VSS
*.PININFO A:I B:I X:O VDD:B VSS:B
MN0 net1 A net2 VSS sg13_lv_nmos m=1 w=640.00n l=130.00n ng=1
MN2 X net1 VSS VSS sg13_lv_nmos m=1 w=1.48u l=130.00n ng=2
MN1 net2 B VSS VSS sg13_lv_nmos m=1 w=640.00n l=130.00n ng=1
MP0 net1 B VDD VDD sg13_lv_pmos m=1 w=840.00n l=130.00n ng=1
MP2 X net1 VDD VDD sg13_lv_pmos m=1 w=2.24u l=130.00n ng=2
MP1 net1 A VDD VDD sg13_lv_pmos m=1 w=840.00n l=130.00n ng=1
.ENDS

************************************************************************
* Library Name: sg13cmos5l_stdcell
* Cell Name:    sg13cmos5l_and3_1
* View Name:    schematic
************************************************************************

.SUBCKT sg13cmos5l_and3_1 X A B C VDD VSS
*.PININFO A:I B:I C:I X:O VDD:B VSS:B
MN2 net3 C VSS VSS sg13_lv_nmos m=1 w=640.00n l=130.00n ng=1
MN3 X net2 VSS VSS sg13_lv_nmos m=1 w=740.00n l=130.00n ng=1
MN0 net2 A net1 VSS sg13_lv_nmos m=1 w=640.00n l=130.00n ng=1
MN1 net1 B net3 VSS sg13_lv_nmos m=1 w=640.00n l=130.00n ng=1
MP3 X net2 VDD VDD sg13_lv_pmos m=1 w=1.12u l=130.00n ng=1
MP1 net2 B VDD VDD sg13_lv_pmos m=1 w=840.00n l=130.00n ng=1
MP2 net2 A VDD VDD sg13_lv_pmos m=1 w=840.00n l=130.00n ng=1
MP0 net2 C VDD VDD sg13_lv_pmos m=1 w=840.00n l=130.00n ng=1
.ENDS

************************************************************************
* Library Name: sg13cmos5l_stdcell
* Cell Name:    sg13cmos5l_and3_2
* View Name:    schematic
************************************************************************

.SUBCKT sg13cmos5l_and3_2 X A B C VDD VSS
*.PININFO A:I B:I C:I X:O VDD:B VSS:B
MN2 net3 C VSS VSS sg13_lv_nmos m=1 w=640.00n l=130.00n ng=1
MN3 X net2 VSS VSS sg13_lv_nmos m=1 w=1.48u l=130.00n ng=2
MN0 net2 A net1 VSS sg13_lv_nmos m=1 w=640.00n l=130.00n ng=1
MN1 net1 B net3 VSS sg13_lv_nmos m=1 w=640.00n l=130.00n ng=1
MP3 X net2 VDD VDD sg13_lv_pmos m=1 w=2.24u l=130.00n ng=2
MP1 net2 B VDD VDD sg13_lv_pmos m=1 w=840.00n l=130.00n ng=1
MP2 net2 A VDD VDD sg13_lv_pmos m=1 w=840.00n l=130.00n ng=1
MP0 net2 C VDD VDD sg13_lv_pmos m=1 w=840.00n l=130.00n ng=1
.ENDS

************************************************************************
* Library Name: sg13cmos5l_stdcell
* Cell Name:    sg13cmos5l_and4_1
* View Name:    schematic
************************************************************************

.SUBCKT sg13cmos5l_and4_1 X A B C D VDD VSS
*.PININFO A:I B:I C:I D:I X:O VDD:B VSS:B
MN3 net17 D VSS VSS sg13_lv_nmos m=1 w=640.00n l=130.00n ng=1
MN2 net16 C net17 VSS sg13_lv_nmos m=1 w=640.00n l=130.00n ng=1
MN1 net15 B net16 VSS sg13_lv_nmos m=1 w=640.00n l=130.00n ng=1
MN0 net1 A net15 VSS sg13_lv_nmos m=1 w=640.00n l=130.00n ng=1
MN4 X net1 VSS VSS sg13_lv_nmos m=1 w=740.00n l=130.00n ng=1
MP3 net1 A VDD VDD sg13_lv_pmos m=1 w=840.00n l=130.00n ng=1
MP4 X net1 VDD VDD sg13_lv_pmos m=1 w=1.12u l=130.00n ng=1
MP0 net1 D VDD VDD sg13_lv_pmos m=1 w=840.00n l=130.00n ng=1
MP1 net1 C VDD VDD sg13_lv_pmos m=1 w=840.00n l=130.00n ng=1
MP2 net1 B VDD VDD sg13_lv_pmos m=1 w=840.00n l=130.00n ng=1
.ENDS

************************************************************************
* Library Name: sg13cmos5l_stdcell
* Cell Name:    sg13cmos5l_and4_2
* View Name:    schematic
************************************************************************

.SUBCKT sg13cmos5l_and4_2 X A B C D VDD VSS
*.PININFO A:I B:I C:I D:I X:O VDD:B VSS:B
MN3 net17 D VSS VSS sg13_lv_nmos m=1 w=640.00n l=130.00n ng=1
MN2 net16 C net17 VSS sg13_lv_nmos m=1 w=640.00n l=130.00n ng=1
MN1 net15 B net16 VSS sg13_lv_nmos m=1 w=640.00n l=130.00n ng=1
MN0 net1 A net15 VSS sg13_lv_nmos m=1 w=640.00n l=130.00n ng=1
MN4 X net1 VSS VSS sg13_lv_nmos m=1 w=1.48u l=130.00n ng=2
MP3 net1 A VDD VDD sg13_lv_pmos m=1 w=840.00n l=130.00n ng=1
MP4 X net1 VDD VDD sg13_lv_pmos m=1 w=2.24u l=130.00n ng=2
MP0 net1 D VDD VDD sg13_lv_pmos m=1 w=840.00n l=130.00n ng=1
MP1 net1 C VDD VDD sg13_lv_pmos m=1 w=840.00n l=130.00n ng=1
MP2 net1 B VDD VDD sg13_lv_pmos m=1 w=840.00n l=130.00n ng=1
.ENDS

************************************************************************
* Library Name: sg13cmos5l_stdcell
* Cell Name:    sg13cmos5l_antennanp
* View Name:    schematic
************************************************************************

.SUBCKT sg13cmos5l_antennanp A VDD VSS
*.PININFO A:I VDD:B VSS:B
DD1 VSS A dantenna m=1 w=780n l=780n a=608.4f p=3.12u
DD0 A VDD dpantenna m=1 w=1.05u l=1.34u a=1.407p p=4.78u
.ENDS

************************************************************************
* Library Name: sg13cmos5l_stdcell
* Cell Name:    sg13cmos5l_buf_1
* View Name:    schematic
************************************************************************

.SUBCKT sg13cmos5l_buf_1 X A VDD VSS
*.PININFO A:I X:O VDD:B VSS:B
MN0 net1 A VSS VSS sg13_lv_nmos m=1 w=550.00n l=130.00n ng=1
MN1 X net1 VSS VSS sg13_lv_nmos m=1 w=740.00n l=130.00n ng=1
MP1 X net1 VDD VDD sg13_lv_pmos m=1 w=1.12u l=130.00n ng=1
MP0 net1 A VDD VDD sg13_lv_pmos m=1 w=840.00n l=130.00n ng=1
.ENDS

************************************************************************
* Library Name: sg13cmos5l_stdcell
* Cell Name:    sg13cmos5l_buf_16
* View Name:    schematic
************************************************************************

.SUBCKT sg13cmos5l_buf_16 X A VDD VSS
*.PININFO A:I X:O VDD:B VSS:B
MN0 net1 A VSS VSS sg13_lv_nmos m=1 w=4.44u l=130.00n ng=6
MN1 X net1 VSS VSS sg13_lv_nmos m=1 w=11.84u l=130.00n ng=16
MP1 X net1 VDD VDD sg13_lv_pmos m=1 w=17.92u l=130.00n ng=16
MP0 net1 A VDD VDD sg13_lv_pmos m=1 w=6.72u l=130.00n ng=6
.ENDS

************************************************************************
* Library Name: sg13cmos5l_stdcell
* Cell Name:    sg13cmos5l_buf_2
* View Name:    schematic
************************************************************************

.SUBCKT sg13cmos5l_buf_2 X A VDD VSS
*.PININFO A:I X:O VDD:B VSS:B
MN0 net1 A VSS VSS sg13_lv_nmos m=1 w=640.00n l=130.00n ng=1
MN1 X net1 VSS VSS sg13_lv_nmos m=1 w=1.48u l=130.00n ng=2
MP1 X net1 VDD VDD sg13_lv_pmos m=1 w=2.24u l=130.00n ng=2
MP0 net1 A VDD VDD sg13_lv_pmos m=1 w=1.000u l=130.00n ng=1
.ENDS

************************************************************************
* Library Name: sg13cmos5l_stdcell
* Cell Name:    sg13cmos5l_buf_4
* View Name:    schematic
************************************************************************

.SUBCKT sg13cmos5l_buf_4 X A VDD VSS
*.PININFO A:I X:O VDD:B VSS:B
MN0 net1 A VSS VSS sg13_lv_nmos m=1 w=740.00n l=130.00n ng=1
MN1 X net1 VSS VSS sg13_lv_nmos m=1 w=2.96u l=130.00n ng=4
MP1 X net1 VDD VDD sg13_lv_pmos m=1 w=4.48u l=130.00n ng=4
MP0 net1 A VDD VDD sg13_lv_pmos m=1 w=1.68u l=130.00n ng=2
.ENDS

************************************************************************
* Library Name: sg13cmos5l_stdcell
* Cell Name:    sg13cmos5l_buf_8
* View Name:    schematic
************************************************************************

.SUBCKT sg13cmos5l_buf_8 X A VDD VSS
*.PININFO A:I X:O VDD:B VSS:B
MN0 net1 A VSS VSS sg13_lv_nmos m=1 w=2.22u l=130.00n ng=3
MN1 X net1 VSS VSS sg13_lv_nmos m=1 w=5.92u l=130.00n ng=8
MP1 X net1 VDD VDD sg13_lv_pmos m=1 w=8.96u l=130.00n ng=8
MP0 net1 A VDD VDD sg13_lv_pmos m=1 w=3.36u l=130.00n ng=3
.ENDS

************************************************************************
* Library Name: sg13cmos5l_stdcell
* Cell Name:    sg13cmos5l_decap_4
* View Name:    schematic
************************************************************************

.SUBCKT sg13cmos5l_decap_4 VDD VSS
*.PININFO VDD:B VSS:B
MN0 VSS VDD VSS VSS sg13_lv_nmos m=1 w=420.00n l=1.000u ng=1
MP0 VDD VSS VDD VDD sg13_lv_pmos m=1 w=1.000u l=1.000u ng=1
.ENDS

************************************************************************
* Library Name: sg13cmos5l_stdcell
* Cell Name:    sg13cmos5l_decap_8
* View Name:    schematic
************************************************************************

.SUBCKT sg13cmos5l_decap_8 VDD VSS
*.PININFO VDD:B VSS:B
MN0 VSS VDD VSS VSS sg13_lv_nmos m=1 w=840.00n l=1.000u ng=2
MP0 VDD VSS VDD VDD sg13_lv_pmos m=1 w=2.000u l=1.000u ng=2
.ENDS

************************************************************************
* Library Name: sg13cmos5l_stdcell
* Cell Name:    sg13cmos5l_dfrbp_1
* View Name:    schematic
************************************************************************

.SUBCKT sg13cmos5l_dfrbp_1 Q Q_N CLK D RESET_B VDD VSS
*.PININFO CLK:I D:I RESET_B:I Q:O Q_N:O VDD:B VSS:B
MN11 net12 net2 VSS VSS sg13_lv_nmos m=1 w=420.00n l=130.00n ng=1
MN10 net5 clkneg net12 VSS sg13_lv_nmos m=1 w=420.00n l=130.00n ng=1
MN12 net2 net5 net11 VSS sg13_lv_nmos m=1 w=420.00n l=130.00n ng=1
MN13 net11 RESET_B VSS VSS sg13_lv_nmos m=1 w=420.00n l=130.00n ng=1
MN14 Q_N net5 VSS VSS sg13_lv_nmos m=1 w=740.00n l=130.00n ng=1
MN0 Db D net10 VSS sg13_lv_nmos m=1 w=420.00n l=130.00n ng=1
MN1 net10 RESET_B VSS VSS sg13_lv_nmos m=1 w=420.00n l=130.00n ng=1
MN4 Db clkneg net6 VSS sg13_lv_nmos m=1 w=420.00n l=130.00n ng=1
MN5 net6 clkpos net9 VSS sg13_lv_nmos m=1 w=420.00n l=130.00n ng=1
MN6 net9 net4 net8 VSS sg13_lv_nmos m=1 w=420.00n l=130.00n ng=1
MN7 net8 RESET_B VSS VSS sg13_lv_nmos m=1 w=420.00n l=130.00n ng=1
MN8 net4 net6 VSS VSS sg13_lv_nmos m=1 w=740.00n l=130.00n ng=1
MN2 clkneg CLK VSS VSS sg13_lv_nmos m=1 w=740.00n l=130.00n ng=1
MN9 net4 clkpos net5 VSS sg13_lv_nmos m=1 w=740.00n l=130.00n ng=1
MN3 clkpos clkneg VSS VSS sg13_lv_nmos m=1 w=740.00n l=130.00n ng=1
MN16 Q net1 VSS VSS sg13_lv_nmos m=1 w=740.00n l=130.00n ng=1
MN15 net1 net5 VSS VSS sg13_lv_nmos m=1 w=740.00n l=130.00n ng=1
MP11 net5 clkpos net3 VDD sg13_lv_pmos m=1 w=420.00n l=130.00n ng=1
MP12 net2 net5 VDD VDD sg13_lv_pmos m=1 w=420.00n l=130.00n ng=1
MP13 net2 RESET_B VDD VDD sg13_lv_pmos m=1 w=420.00n l=130.00n ng=1
MP14 Q_N net5 VDD VDD sg13_lv_pmos m=1 w=1.12u l=130.00n ng=1
MP4 Db clkpos net6 VDD sg13_lv_pmos m=1 w=420.00n l=130.00n ng=1
MP0 Db RESET_B VDD VDD sg13_lv_pmos m=1 w=420.00n l=130.00n ng=1
MP1 Db D VDD VDD sg13_lv_pmos m=1 w=420.00n l=130.00n ng=1
MP5 net7 net4 VDD VDD sg13_lv_pmos m=1 w=420.00n l=130.00n ng=1
MP6 net6 clkneg net7 VDD sg13_lv_pmos m=1 w=420.00n l=130.00n ng=1
MP7 net6 RESET_B VDD VDD sg13_lv_pmos m=1 w=420.00n l=130.00n ng=1
MP2 clkneg CLK VDD VDD sg13_lv_pmos m=1 w=1.12u l=130.00n ng=1
MP3 clkpos clkneg VDD VDD sg13_lv_pmos m=1 w=1.12u l=130.00n ng=1
MP8 net4 net6 VDD VDD sg13_lv_pmos m=1 w=1.000u l=130.00n ng=1
MP9 net4 clkneg net5 VDD sg13_lv_pmos m=1 w=1.000u l=130.00n ng=1
MP16 Q net1 VDD VDD sg13_lv_pmos m=1 w=1.12u l=130.00n ng=1
MP10 net3 net2 VDD VDD sg13_lv_pmos m=1 w=420.00n l=130.00n ng=1
MP15 net1 net5 VDD VDD sg13_lv_pmos m=1 w=1.12u l=130.00n ng=1
.ENDS

************************************************************************
* Library Name: sg13cmos5l_stdcell
* Cell Name:    sg13cmos5l_dfrbp_2
* View Name:    schematic
************************************************************************

.SUBCKT sg13cmos5l_dfrbp_2 Q Q_N CLK D RESET_B VDD VSS
*.PININFO CLK:I D:I RESET_B:I Q:O Q_N:O VDD:B VSS:B
MN11 net12 net2 VSS VSS sg13_lv_nmos m=1 w=420.00n l=130.00n ng=1
MN10 net5 clkneg net12 VSS sg13_lv_nmos m=1 w=420.00n l=130.00n ng=1
MN12 net2 net5 net11 VSS sg13_lv_nmos m=1 w=420.00n l=130.00n ng=1
MN13 net11 RESET_B VSS VSS sg13_lv_nmos m=1 w=420.00n l=130.00n ng=1
MN14 Q_N net5 VSS VSS sg13_lv_nmos m=1 w=1.48u l=130.00n ng=2
MN0 Db D net10 VSS sg13_lv_nmos m=1 w=420.00n l=130.00n ng=1
MN1 net10 RESET_B VSS VSS sg13_lv_nmos m=1 w=420.00n l=130.00n ng=1
MN4 Db clkneg net6 VSS sg13_lv_nmos m=1 w=420.00n l=130.00n ng=1
MN5 net6 clkpos net9 VSS sg13_lv_nmos m=1 w=420.00n l=130.00n ng=1
MN6 net9 net4 net8 VSS sg13_lv_nmos m=1 w=420.00n l=130.00n ng=1
MN7 net8 RESET_B VSS VSS sg13_lv_nmos m=1 w=420.00n l=130.00n ng=1
MN8 net4 net6 VSS VSS sg13_lv_nmos m=1 w=740.00n l=130.00n ng=1
MN2 clkneg CLK VSS VSS sg13_lv_nmos m=1 w=740.00n l=130.00n ng=1
MN9 net4 clkpos net5 VSS sg13_lv_nmos m=1 w=740.00n l=130.00n ng=1
MN3 clkpos clkneg VSS VSS sg13_lv_nmos m=1 w=740.00n l=130.00n ng=1
MN16 Q net1 VSS VSS sg13_lv_nmos m=1 w=1.48u l=130.00n ng=2
MN15 net1 net5 VSS VSS sg13_lv_nmos m=1 w=640.00n l=130.00n ng=1
MP11 net5 clkpos net3 VDD sg13_lv_pmos m=1 w=420.00n l=130.00n ng=1
MP12 net2 net5 VDD VDD sg13_lv_pmos m=1 w=420.00n l=130.00n ng=1
MP13 net2 RESET_B VDD VDD sg13_lv_pmos m=1 w=420.00n l=130.00n ng=1
MP14 Q_N net5 VDD VDD sg13_lv_pmos m=1 w=2.24u l=130.00n ng=2
MP4 Db clkpos net6 VDD sg13_lv_pmos m=1 w=420.00n l=130.00n ng=1
MP0 Db RESET_B VDD VDD sg13_lv_pmos m=1 w=420.00n l=130.00n ng=1
MP1 Db D VDD VDD sg13_lv_pmos m=1 w=420.00n l=130.00n ng=1
MP5 net7 net4 VDD VDD sg13_lv_pmos m=1 w=420.00n l=130.00n ng=1
MP6 net6 clkneg net7 VDD sg13_lv_pmos m=1 w=420.00n l=130.00n ng=1
MP7 net6 RESET_B VDD VDD sg13_lv_pmos m=1 w=420.00n l=130.00n ng=1
MP2 clkneg CLK VDD VDD sg13_lv_pmos m=1 w=1.12u l=130.00n ng=1
MP3 clkpos clkneg VDD VDD sg13_lv_pmos m=1 w=1.12u l=130.00n ng=1
MP8 net4 net6 VDD VDD sg13_lv_pmos m=1 w=1.000u l=130.00n ng=1
MP9 net4 clkneg net5 VDD sg13_lv_pmos m=1 w=1.000u l=130.00n ng=1
MP16 Q net1 VDD VDD sg13_lv_pmos m=1 w=2.24u l=130.00n ng=2
MP10 net3 net2 VDD VDD sg13_lv_pmos m=1 w=420.00n l=130.00n ng=1
MP15 net1 net5 VDD VDD sg13_lv_pmos m=1 w=1.000u l=130.00n ng=1
.ENDS

************************************************************************
* Library Name: sg13cmos5l_stdcell
* Cell Name:    sg13cmos5l_dlhq_1
* View Name:    schematic
************************************************************************

.SUBCKT sg13cmos5l_dlhq_1 Q D GATE VDD VSS
*.PININFO D:I GATE:I Q:O VDD:B VSS:B
MP8 Q qint_b VDD VDD sg13_lv_pmos m=1 w=1.12u l=130.00n ng=1
MP6 qint GATE_BB net8 VDD sg13_lv_pmos m=1 w=420.00n l=130.00n ng=1
MP7 qint_b qint VDD VDD sg13_lv_pmos m=1 w=1.12u l=130.00n ng=1
MP2 Db D VDD VDD sg13_lv_pmos m=1 w=840.00n l=130.00n ng=1
MP0 GATE_B GATE VDD VDD sg13_lv_pmos m=1 w=840.00n l=130.00n ng=1
MP1 GATE_BB GATE_B VDD VDD sg13_lv_pmos m=1 w=840.00n l=130.00n ng=1
MP5 net8 qint_b VDD VDD sg13_lv_pmos m=1 w=420.00n l=130.00n ng=1
MP4 net4 GATE_B qint VDD sg13_lv_pmos m=1 w=1.000u l=130.00n ng=1
MP3 net4 Db VDD VDD sg13_lv_pmos m=1 w=1.000u l=130.00n ng=1
MN0 GATE_B GATE VSS VSS sg13_lv_nmos m=1 w=740.00n l=130.00n ng=1
MN1 GATE_BB GATE_B VSS VSS sg13_lv_nmos m=1 w=740.00n l=130.00n ng=1
MN5 qint GATE_B net9 VSS sg13_lv_nmos m=1 w=420.00n l=130.00n ng=1
MN8 Q qint_b VSS VSS sg13_lv_nmos m=1 w=740.00n l=130.00n ng=1
MN4 net7 Db VSS VSS sg13_lv_nmos m=1 w=740.00n l=130.00n ng=1
MN6 net9 qint_b VSS VSS sg13_lv_nmos m=1 w=420.00n l=130.00n ng=1
MN7 qint_b qint VSS VSS sg13_lv_nmos m=1 w=740.00n l=130.00n ng=1
MN3 qint GATE_BB net7 VSS sg13_lv_nmos m=1 w=740.00n l=130.00n ng=1
MN2 Db D VSS VSS sg13_lv_nmos m=1 w=550.00n l=130.00n ng=1
.ENDS

************************************************************************
* Library Name: sg13cmos5l_stdcell
* Cell Name:    sg13cmos5l_dlhr_1
* View Name:    schematic
************************************************************************

.SUBCKT sg13cmos5l_dlhr_1 Q Q_N D GATE RESET_B VDD VSS
*.PININFO D:I GATE:I RESET_B:I Q:O Q_N:O VDD:B VSS:B
MP8 qint_b RESET_B VDD VDD sg13_lv_pmos m=1 w=1.12u l=130.00n ng=1
MP9 Q qint_b VDD VDD sg13_lv_pmos m=1 w=1.12u l=130.00n ng=1
MP6 qint GATE_BB net11 VDD sg13_lv_pmos m=1 w=420.00n l=130.00n ng=1
MP5 net11 qint_b VDD VDD sg13_lv_pmos m=1 w=420.00n l=130.00n ng=1
MP4 qint GATE_B net2 VDD sg13_lv_pmos m=1 w=1.000u l=130.00n ng=1
MP3 net2 Db VDD VDD sg13_lv_pmos m=1 w=1.000u l=130.00n ng=1
MP2 Db D VDD VDD sg13_lv_pmos m=1 w=840.00n l=130.00n ng=1
MP0 GATE_B GATE VDD VDD sg13_lv_pmos m=1 w=840.00n l=130.00n ng=1
MP11 Q_N qintn_b VDD VDD sg13_lv_pmos m=1 w=1.12u l=130.00n ng=1
MP7 qint_b qint VDD VDD sg13_lv_pmos m=1 w=1.12u l=130.00n ng=1
MP1 GATE_BB GATE_B VDD VDD sg13_lv_pmos m=1 w=840.00n l=130.00n ng=1
MP10 qintn_b qint_b VDD VDD sg13_lv_pmos m=1 w=840.00n l=130.00n ng=1
MN7 qint_b qint net9 VSS sg13_lv_nmos m=1 w=740.00n l=130.00n ng=1
MN8 net9 RESET_B VSS VSS sg13_lv_nmos m=1 w=740.00n l=130.00n ng=1
MN5 qint GATE_B net7 VSS sg13_lv_nmos m=1 w=420.00n l=130.00n ng=1
MN6 net7 qint_b VSS VSS sg13_lv_nmos m=1 w=420.00n l=130.00n ng=1
MN9 Q qint_b VSS VSS sg13_lv_nmos m=1 w=740.00n l=130.00n ng=1
MN3 qint GATE_BB net1 VSS sg13_lv_nmos m=1 w=640.00n l=130.00n ng=1
MN4 net1 Db VSS VSS sg13_lv_nmos m=1 w=640.00n l=130.00n ng=1
MN2 Db D VSS VSS sg13_lv_nmos m=1 w=550.00n l=130.00n ng=1
MN0 GATE_B GATE VSS VSS sg13_lv_nmos m=1 w=740.00n l=130.00n ng=1
MN11 Q_N qintn_b VSS VSS sg13_lv_nmos m=1 w=740.00n l=130.00n ng=1
MN1 GATE_BB GATE_B VSS VSS sg13_lv_nmos m=1 w=740.00n l=130.00n ng=1
MN10 qintn_b qint_b VSS VSS sg13_lv_nmos m=1 w=550.00n l=130.00n ng=1
.ENDS

************************************************************************
* Library Name: sg13cmos5l_stdcell
* Cell Name:    sg13cmos5l_dlhrq_1
* View Name:    schematic
************************************************************************

.SUBCKT sg13cmos5l_dlhrq_1 Q D GATE RESET_B VDD VSS
*.PININFO D:I GATE:I RESET_B:I Q:O VDD:B VSS:B
MN8 net116 RESET_B VSS VSS sg13_lv_nmos m=1 w=740.00n l=130.00n ng=1
MN9 Q qint_b VSS VSS sg13_lv_nmos m=1 w=740.00n l=130.00n ng=1
MN1 GATE_BB GATE_B VSS VSS sg13_lv_nmos m=1 w=740.00n l=130.00n ng=1
MN5 qint GATE_B net89 VSS sg13_lv_nmos m=1 w=420.00n l=130.00n ng=1
MN7 qint_b qint net116 VSS sg13_lv_nmos m=1 w=740.00n l=130.00n ng=1
MN2 Db D VSS VSS sg13_lv_nmos m=1 w=550.00n l=130.00n ng=1
MN4 net61 Db VSS VSS sg13_lv_nmos m=1 w=640.00n l=130.00n ng=1
MN3 qint GATE_BB net61 VSS sg13_lv_nmos m=1 w=640.00n l=130.00n ng=1
MN6 net89 qint_b VSS VSS sg13_lv_nmos m=1 w=420.00n l=130.00n ng=1
MN0 GATE_B GATE VSS VSS sg13_lv_nmos m=1 w=740.00n l=130.00n ng=1
MP3 net60 Db VDD VDD sg13_lv_pmos m=1 w=1.000u l=130.00n ng=1
MP8 qint_b RESET_B VDD VDD sg13_lv_pmos m=1 w=1.000u l=130.00n ng=1
MP6 qint GATE_BB net92 VDD sg13_lv_pmos m=1 w=420.00n l=130.00n ng=1
MP9 Q qint_b VDD VDD sg13_lv_pmos m=1 w=1.12u l=130.00n ng=1
MP5 net92 qint_b VDD VDD sg13_lv_pmos m=1 w=420.00n l=130.00n ng=1
MP0 GATE_B GATE VDD VDD sg13_lv_pmos m=1 w=840.00n l=130.00n ng=1
MP2 Db D VDD VDD sg13_lv_pmos m=1 w=840.00n l=130.00n ng=1
MP4 qint GATE_B net60 VDD sg13_lv_pmos m=1 w=1.000u l=130.00n ng=1
MP1 GATE_BB GATE_B VDD VDD sg13_lv_pmos m=1 w=840.00n l=130.00n ng=1
MP7 qint_b qint VDD VDD sg13_lv_pmos m=1 w=1.000u l=130.00n ng=1
.ENDS

************************************************************************
* Library Name: sg13cmos5l_stdcell
* Cell Name:    sg13cmos5l_dllr_1
* View Name:    schematic
************************************************************************

.SUBCKT sg13cmos5l_dllr_1 Q Q_N D GATE_N RESET_B VDD VSS
*.PININFO D:I GATE_N:I RESET_B:I Q:O Q_N:O VDD:B VSS:B
MN2 Db D VSS VSS sg13_lv_nmos m=1 w=550.00n l=130.00n ng=1
MN0 gnb GATE_N VSS VSS sg13_lv_nmos m=1 w=740.00n l=130.00n ng=1
MN1 gnbb gnb VSS VSS sg13_lv_nmos m=1 w=740.00n l=130.00n ng=1
MN6 net89 qint_b VSS VSS sg13_lv_nmos m=1 w=420.00n l=130.00n ng=1
MN7 qint_b qint net116 VSS sg13_lv_nmos m=1 w=740.00n l=130.00n ng=1
MN8 net116 RESET_B VSS VSS sg13_lv_nmos m=1 w=740.00n l=130.00n ng=1
MN5 qint gnbb net89 VSS sg13_lv_nmos m=1 w=420.00n l=130.00n ng=1
MN11 Q_N qintn_b VSS VSS sg13_lv_nmos m=1 w=740.00n l=130.00n ng=1
MN3 qint gnb net61 VSS sg13_lv_nmos m=1 w=640.00n l=130.00n ng=1
MN10 qintn_b qint_b VSS VSS sg13_lv_nmos m=1 w=550.00n l=130.00n ng=1
MN4 net61 Db VSS VSS sg13_lv_nmos m=1 w=640.00n l=130.00n ng=1
MN9 Q qint_b VSS VSS sg13_lv_nmos m=1 w=740.00n l=130.00n ng=1
MP1 gnbb gnb VDD VDD sg13_lv_pmos m=1 w=840.00n l=130.00n ng=1
MP4 qint gnbb net60 VDD sg13_lv_pmos m=1 w=1.000u l=130.00n ng=1
MP10 qintn_b qint_b VDD VDD sg13_lv_pmos m=1 w=840.00n l=130.00n ng=1
MP11 Q_N qintn_b VDD VDD sg13_lv_pmos m=1 w=1.12u l=130.00n ng=1
MP3 net60 Db VDD VDD sg13_lv_pmos m=1 w=1.000u l=130.00n ng=1
MP5 net92 qint_b VDD VDD sg13_lv_pmos m=1 w=420.00n l=130.00n ng=1
MP8 qint_b RESET_B VDD VDD sg13_lv_pmos m=1 w=1.12u l=130.00n ng=1
MP2 Db D VDD VDD sg13_lv_pmos m=1 w=840.00n l=130.00n ng=1
MP0 gnb GATE_N VDD VDD sg13_lv_pmos m=1 w=840.00n l=130.00n ng=1
MP9 Q qint_b VDD VDD sg13_lv_pmos m=1 w=1.12u l=130.00n ng=1
MP6 qint gnb net92 VDD sg13_lv_pmos m=1 w=420.00n l=130.00n ng=1
MP7 qint_b qint VDD VDD sg13_lv_pmos m=1 w=1.12u l=130.00n ng=1
.ENDS

************************************************************************
* Library Name: sg13cmos5l_stdcell
* Cell Name:    sg13cmos5l_dllrq_1
* View Name:    schematic
************************************************************************

.SUBCKT sg13cmos5l_dllrq_1 Q D GATE_N RESET_B VDD VSS
*.PININFO D:I GATE_N:I RESET_B:I Q:O VDD:B VSS:B
MN5 qint gnbb net89 VSS sg13_lv_nmos m=1 w=420.00n l=130.00n ng=1
MN3 qint gnb net61 VSS sg13_lv_nmos m=1 w=640.00n l=130.00n ng=1
MN8 net116 RESET_B VSS VSS sg13_lv_nmos m=1 w=740.00n l=130.00n ng=1
MN9 Q qint_b VSS VSS sg13_lv_nmos m=1 w=740.00n l=130.00n ng=1
MN4 net61 Db VSS VSS sg13_lv_nmos m=1 w=640.00n l=130.00n ng=1
MN6 net89 qint_b VSS VSS sg13_lv_nmos m=1 w=420.00n l=130.00n ng=1
MN7 qint_b qint net116 VSS sg13_lv_nmos m=1 w=740.00n l=130.00n ng=1
MN2 Db D VSS VSS sg13_lv_nmos m=1 w=550.00n l=130.00n ng=1
MN0 gnb GATE_N VSS VSS sg13_lv_nmos m=1 w=740.00n l=130.00n ng=1
MN1 gnbb gnb VSS VSS sg13_lv_nmos m=1 w=740.00n l=130.00n ng=1
MP3 net59 Db VDD VDD sg13_lv_pmos m=1 w=1.000u l=130.00n ng=1
MP8 qint_b RESET_B VDD VDD sg13_lv_pmos m=1 w=1.000u l=130.00n ng=1
MP0 gnb GATE_N VDD VDD sg13_lv_pmos m=1 w=840.00n l=130.00n ng=1
MP5 net92 qint_b VDD VDD sg13_lv_pmos m=1 w=420.00n l=130.00n ng=1
MP7 qint_b qint VDD VDD sg13_lv_pmos m=1 w=1.000u l=130.00n ng=1
MP9 Q qint_b VDD VDD sg13_lv_pmos m=1 w=1.12u l=130.00n ng=1
MP4 qint gnbb net59 VDD sg13_lv_pmos m=1 w=1.000u l=130.00n ng=1
MP2 Db D VDD VDD sg13_lv_pmos m=1 w=840.00n l=130.00n ng=1
MP1 gnbb gnb VDD VDD sg13_lv_pmos m=1 w=840.00n l=130.00n ng=1
MP6 qint gnb net92 VDD sg13_lv_pmos m=1 w=420.00n l=130.00n ng=1
.ENDS

************************************************************************
* Library Name: sg13cmos5l_stdcell
* Cell Name:    sg13cmos5l_dlygate4sd1_1
* View Name:    schematic
************************************************************************

.SUBCKT sg13cmos5l_dlygate4sd1_1 X A VDD VSS
*.PININFO A:I X:O VDD:B VSS:B
MP3 X net3 VDD VDD sg13_lv_pmos m=1 w=1.12u l=130.00n ng=1
MP2 net3 net2 VDD VDD sg13_lv_pmos m=1 w=1.000u l=130.00n ng=1
MP1 net2 net1 VDD VDD sg13_lv_pmos m=1 w=1.000u l=130.00n ng=1
MP0 net1 A VDD VDD sg13_lv_pmos m=1 w=420.00n l=130.00n ng=1
MN3 X net3 VSS VSS sg13_lv_nmos m=1 w=740.00n l=130.00n ng=1
MN2 net3 net2 VSS VSS sg13_lv_nmos m=1 w=420.00n l=130.00n ng=1
MN1 net2 net1 VSS VSS sg13_lv_nmos m=1 w=420.00n l=130.00n ng=1
MN0 net1 A VSS VSS sg13_lv_nmos m=1 w=420.00n l=130.00n ng=1
.ENDS

************************************************************************
* Library Name: sg13cmos5l_stdcell
* Cell Name:    sg13cmos5l_dlygate4sd2_1
* View Name:    schematic
************************************************************************

.SUBCKT sg13cmos5l_dlygate4sd2_1 X A VDD VSS
*.PININFO A:I X:O VDD:B VSS:B
MP3 X net3 VDD VDD sg13_lv_pmos m=1 w=1.12u l=130.00n ng=1
MP2 net3 net2 VDD VDD sg13_lv_pmos m=1 w=1.000u l=250.00n ng=1
MP1 net2 net1 VDD VDD sg13_lv_pmos m=1 w=1.000u l=250.00n ng=1
MP0 net1 A VDD VDD sg13_lv_pmos m=1 w=420.00n l=130.00n ng=1
MN3 X net3 VSS VSS sg13_lv_nmos m=1 w=740.00n l=130.00n ng=1
MN2 net3 net2 VSS VSS sg13_lv_nmos m=1 w=420.00n l=180.00n ng=1
MN1 net2 net1 VSS VSS sg13_lv_nmos m=1 w=420.00n l=180.00n ng=1
MN0 net1 A VSS VSS sg13_lv_nmos m=1 w=420.00n l=130.00n ng=1
.ENDS

************************************************************************
* Library Name: sg13cmos5l_stdcell
* Cell Name:    sg13cmos5l_dlygate4sd3_1
* View Name:    schematic
************************************************************************

.SUBCKT sg13cmos5l_dlygate4sd3_1 X A VDD VSS
*.PININFO A:I X:O VDD:B VSS:B
MP3 X net3 VDD VDD sg13_lv_pmos m=1 w=1.12u l=130.00n ng=1
MP2 net3 net2 VDD VDD sg13_lv_pmos m=1 w=1.000u l=500.0n ng=1
MP1 net2 net1 VDD VDD sg13_lv_pmos m=1 w=1.000u l=500.0n ng=1
MP0 net1 A VDD VDD sg13_lv_pmos m=1 w=420.00n l=130.00n ng=1
MN3 X net3 VSS VSS sg13_lv_nmos m=1 w=740.00n l=130.00n ng=1
MN2 net3 net2 VSS VSS sg13_lv_nmos m=1 w=420.00n l=500.0n ng=1
MN1 net2 net1 VSS VSS sg13_lv_nmos m=1 w=420.00n l=500.0n ng=1
MN0 net1 A VSS VSS sg13_lv_nmos m=1 w=420.00n l=130.00n ng=1
.ENDS

************************************************************************
* Library Name: sg13cmos5l_stdcell
* Cell Name:    sg13cmos5l_ebufn_2
* View Name:    schematic
************************************************************************

.SUBCKT sg13cmos5l_ebufn_2 Z A TE_B VDD VSS
*.PININFO A:I TE_B:I Z:O VDD:B VSS:B
MN3 net4 net3 VSS VSS sg13_lv_nmos m=1 w=1.48u l=130.00n ng=2
MN2 Z net1 net4 VSS sg13_lv_nmos m=1 w=1.48u l=130.00n ng=2
MN1 net3 TE_B VSS VSS sg13_lv_nmos m=1 w=640.00n l=130.00n ng=1
MN0 net1 A VSS VSS sg13_lv_nmos m=1 w=640.00n l=130.00n ng=1
MP2 net2 TE_B VDD VDD sg13_lv_pmos m=1 w=2.24u l=130.00n ng=2
MP3 Z net1 net2 VDD sg13_lv_pmos m=1 w=2.24u l=130.00n ng=2
MP1 net3 TE_B VDD VDD sg13_lv_pmos m=1 w=1.000u l=130.00n ng=1
MP0 net1 A VDD VDD sg13_lv_pmos m=1 w=1.000u l=130.00n ng=1
.ENDS

************************************************************************
* Library Name: sg13cmos5l_stdcell
* Cell Name:    sg13cmos5l_ebufn_4
* View Name:    schematic
************************************************************************

.SUBCKT sg13cmos5l_ebufn_4 Z A TE_B VDD VSS
*.PININFO A:I TE_B:I Z:O VDD:B VSS:B
MN0 net23 A VSS VSS sg13_lv_nmos m=1 w=740.00n l=130.00n ng=1
MN1 net21 TE_B VSS VSS sg13_lv_nmos m=1 w=740.00n l=130.00n ng=1
MN2 Z net23 net22 VSS sg13_lv_nmos m=1 w=2.96u l=130.00n ng=4
MN3 net22 net21 VSS VSS sg13_lv_nmos m=1 w=2.96u l=130.00n ng=4
MP0 net23 A VDD VDD sg13_lv_pmos m=1 w=1.12u l=130.00n ng=1
MP1 net21 TE_B VDD VDD sg13_lv_pmos m=1 w=1.12u l=130.00n ng=1
MP3 Z net23 net24 VDD sg13_lv_pmos m=1 w=4.48u l=130.00n ng=4
MP2 net24 TE_B VDD VDD sg13_lv_pmos m=1 w=4.48u l=130.00n ng=4
.ENDS

************************************************************************
* Library Name: sg13cmos5l_stdcell
* Cell Name:    sg13cmos5l_ebufn_8
* View Name:    schematic
************************************************************************

.SUBCKT sg13cmos5l_ebufn_8 Z A TE_B VDD VSS
*.PININFO A:I TE_B:I Z:O VDD:B VSS:B
MN3 net23 net22 VSS VSS sg13_lv_nmos m=1 w=5.92u l=130.00n ng=8
MN2 Z net21 net23 VSS sg13_lv_nmos m=1 w=5.92u l=130.00n ng=8
MN1 net22 TE_B VSS VSS sg13_lv_nmos m=1 w=740.00n l=130.00n ng=1
MN0 net21 A VSS VSS sg13_lv_nmos m=1 w=1.48u l=130.00n ng=2
MP2 net24 TE_B VDD VDD sg13_lv_pmos m=1 w=8.96u l=130.00n ng=8
MP3 Z net21 net24 VDD sg13_lv_pmos m=1 w=8.96u l=130.00n ng=8
MP1 net22 TE_B VDD VDD sg13_lv_pmos m=1 w=1.12u l=130.00n ng=1
MP0 net21 A VDD VDD sg13_lv_pmos m=1 w=2.24u l=130.00n ng=2
.ENDS

************************************************************************
* Library Name: sg13cmos5l_stdcell
* Cell Name:    sg13cmos5l_einvn_2
* View Name:    schematic
************************************************************************

.SUBCKT sg13cmos5l_einvn_2 Z A TE_B VDD VSS
*.PININFO A:I TE_B:I Z:O VDD:B VSS:B
MN0 TE TE_B VSS VSS sg13_lv_nmos m=1 w=420.00n l=130.00n ng=1
MN2 net1 TE VSS VSS sg13_lv_nmos m=1 w=1.48u l=130.00n ng=2
MN1 Z A net1 VSS sg13_lv_nmos m=1 w=1.48u l=130.00n ng=2
MP0 TE TE_B VDD VDD sg13_lv_pmos m=1 w=640.00n l=130.00n ng=1
MP1 net2 TE_B VDD VDD sg13_lv_pmos m=1 w=2.24u l=130.00n ng=2
MP2 Z A net2 VDD sg13_lv_pmos m=1 w=2.24u l=130.00n ng=2
.ENDS

************************************************************************
* Library Name: sg13cmos5l_stdcell
* Cell Name:    sg13cmos5l_einvn_4
* View Name:    schematic
************************************************************************

.SUBCKT sg13cmos5l_einvn_4 Z A TE_B VDD VSS
*.PININFO A:I TE_B:I Z:O VDD:B VSS:B
MN2 net16 TE VSS VSS sg13_lv_nmos m=1 w=2.96u l=130.00n ng=4
MN0 TE TE_B VSS VSS sg13_lv_nmos m=1 w=740.00n l=130.00n ng=1
MN1 Z A net16 VSS sg13_lv_nmos m=1 w=2.96u l=130.00n ng=4
MP0 TE TE_B VDD VDD sg13_lv_pmos m=1 w=1.12u l=130.00n ng=1
MP1 net17 TE_B VDD VDD sg13_lv_pmos m=1 w=4.48u l=130.00n ng=4
MP2 Z A net17 VDD sg13_lv_pmos m=1 w=4.48u l=130.00n ng=4
.ENDS

************************************************************************
* Library Name: sg13cmos5l_stdcell
* Cell Name:    sg13cmos5l_einvn_8
* View Name:    schematic
************************************************************************

.SUBCKT sg13cmos5l_einvn_8 Z A TE_B VDD VSS
*.PININFO A:I TE_B:I Z:O VDD:B VSS:B
MN1 Z A net29 VSS sg13_lv_nmos m=1 w=5.92u l=130.00n ng=8
MN0 TE TE_B VSS VSS sg13_lv_nmos m=1 w=740.00n l=130.00n ng=1
MN2 net29 TE VSS VSS sg13_lv_nmos m=1 w=5.92u l=130.00n ng=8
MP1 net28 TE_B VDD VDD sg13_lv_pmos m=1 w=8.96u l=130.00n ng=8
MP2 Z A net28 VDD sg13_lv_pmos m=1 w=8.96u l=130.00n ng=8
MP0 TE TE_B VDD VDD sg13_lv_pmos m=1 w=1.12u l=130.00n ng=1
.ENDS

************************************************************************
* Library Name: sg13cmos5l_stdcell
* Cell Name:    sg13cmos5l_inv_1
* View Name:    schematic
************************************************************************

.SUBCKT sg13cmos5l_inv_1 Y A VDD VSS
*.PININFO A:I Y:O VDD:B VSS:B
MN0 Y A VSS VSS sg13_lv_nmos m=1 w=740.00n l=130.00n ng=1
MP0 Y A VDD VDD sg13_lv_pmos m=1 w=1.12u l=130.00n ng=1
.ENDS

************************************************************************
* Library Name: sg13cmos5l_stdcell
* Cell Name:    sg13cmos5l_inv_16
* View Name:    schematic
************************************************************************

.SUBCKT sg13cmos5l_inv_16 Y A VDD VSS
*.PININFO A:I Y:O VDD:B VSS:B
MN0 Y A VSS VSS sg13_lv_nmos m=1 w=11.84u l=130.00n ng=16
MP0 Y A VDD VDD sg13_lv_pmos m=1 w=17.92u l=130.00n ng=16
.ENDS

************************************************************************
* Library Name: sg13cmos5l_stdcell
* Cell Name:    sg13cmos5l_inv_2
* View Name:    schematic
************************************************************************

.SUBCKT sg13cmos5l_inv_2 Y A VDD VSS
*.PININFO A:I Y:O VDD:B VSS:B
MN0 Y A VSS VSS sg13_lv_nmos m=1 w=1.48u l=130.00n ng=2
MP0 Y A VDD VDD sg13_lv_pmos m=1 w=2.24u l=130.00n ng=2
.ENDS

************************************************************************
* Library Name: sg13cmos5l_stdcell
* Cell Name:    sg13cmos5l_inv_4
* View Name:    schematic
************************************************************************

.SUBCKT sg13cmos5l_inv_4 Y A VDD VSS
*.PININFO A:I Y:O VDD:B VSS:B
MP0 Y A VDD VDD sg13_lv_pmos m=1 w=4.48u l=130.00n ng=4
MN0 Y A VSS VSS sg13_lv_nmos m=1 w=2.96u l=130.00n ng=4
.ENDS

************************************************************************
* Library Name: sg13cmos5l_stdcell
* Cell Name:    sg13cmos5l_inv_8
* View Name:    schematic
************************************************************************

.SUBCKT sg13cmos5l_inv_8 Y A VDD VSS
*.PININFO A:I Y:O VDD:B VSS:B
MN0 Y A VSS VSS sg13_lv_nmos m=1 w=5.92u l=130.00n ng=8
MP0 Y A VDD VDD sg13_lv_pmos m=1 w=8.96u l=130.00n ng=8
.ENDS

************************************************************************
* Library Name: sg13cmos5l_stdcell
* Cell Name:    sg13cmos5l_lgcp_1
* View Name:    schematic
************************************************************************

.SUBCKT sg13cmos5l_lgcp_1 GCLK CLK GATE VDD VSS
*.PININFO CLK:I GATE:I GCLK:O VDD:B VSS:B
MP1 CLKBB CLKB VDD VDD sg13_lv_pmos m=1 w=840.00n l=130.00n ng=1
MP3 net1 CLKBB net4 VDD sg13_lv_pmos m=1 w=1.000u l=130.00n ng=1
MP4 int_GATE net1 VDD VDD sg13_lv_pmos m=1 w=1.12u l=130.00n ng=1
MP2 net4 GATE VDD VDD sg13_lv_pmos m=1 w=1.000u l=130.00n ng=1
MP8 net3 int_GATE VDD VDD sg13_lv_pmos m=1 w=840.00n l=130.00n ng=1
MP9 GCLK net3 VDD VDD sg13_lv_pmos m=1 w=1.12u l=130.00n ng=1
MP6 net1 CLKB net6 VDD sg13_lv_pmos m=1 w=420.00n l=130.00n ng=1
MP0 CLKB CLK VDD VDD sg13_lv_pmos m=1 w=840.00n l=130.00n ng=1
MP7 net3 CLK VDD VDD sg13_lv_pmos m=1 w=840.00n l=130.00n ng=1
MP5 net6 int_GATE VDD VDD sg13_lv_pmos m=1 w=420.00n l=130.00n ng=1
MN9 GCLK net3 VSS VSS sg13_lv_nmos m=1 w=740.00n l=130.00n ng=1
MN7 net3 int_GATE net5 VSS sg13_lv_nmos m=1 w=640.00n l=130.00n ng=1
MN4 int_GATE net1 VSS VSS sg13_lv_nmos m=1 w=740.00n l=130.00n ng=1
MN1 CLKBB CLKB VSS VSS sg13_lv_nmos m=1 w=740.00n l=130.00n ng=1
MN6 net7 int_GATE VSS VSS sg13_lv_nmos m=1 w=420.00n l=130.00n ng=1
MN3 net2 GATE VSS VSS sg13_lv_nmos m=1 w=640.00n l=130.00n ng=1
MN5 net1 CLKBB net7 VSS sg13_lv_nmos m=1 w=420.00n l=130.00n ng=1
MN0 CLKB CLK VSS VSS sg13_lv_nmos m=1 w=740.00n l=130.00n ng=1
MN8 net5 CLK VSS VSS sg13_lv_nmos m=1 w=640.00n l=130.00n ng=1
MN2 net1 CLKB net2 VSS sg13_lv_nmos m=1 w=640.00n l=130.00n ng=1
.ENDS

************************************************************************
* Library Name: sg13cmos5l_stdcell
* Cell Name:    sg13cmos5l_mux2_1
* View Name:    schematic
************************************************************************

.SUBCKT sg13cmos5l_mux2_1 X A0 A1 S VDD VSS
*.PININFO A0:I A1:I S:I X:O VDD:B VSS:B
MP1 net4 S VDD VDD sg13_lv_pmos m=1 w=1.000u l=130.00n ng=1
MP5 X net6 VDD VDD sg13_lv_pmos m=1 w=1.12u l=130.00n ng=1
MP4 net6 A1 net5 VDD sg13_lv_pmos m=1 w=1.000u l=130.00n ng=1
MP0 Sb S VDD VDD sg13_lv_pmos m=1 w=840.00n l=130.00n ng=1
MP3 net5 Sb VDD VDD sg13_lv_pmos m=1 w=1.000u l=130.00n ng=1
MP2 net6 A0 net4 VDD sg13_lv_pmos m=1 w=1.000u l=130.00n ng=1
MN4 net3 S VSS VSS sg13_lv_nmos m=1 w=740.00n l=130.00n ng=1
MN2 net1 Sb VSS VSS sg13_lv_nmos m=1 w=740.00n l=130.00n ng=1
MN5 X net6 VSS VSS sg13_lv_nmos m=1 w=740.00n l=130.00n ng=1
MN0 Sb S VSS VSS sg13_lv_nmos m=1 w=550.00n l=130.00n ng=1
MN3 net6 A1 net3 VSS sg13_lv_nmos m=1 w=740.00n l=130.00n ng=1
MN1 net6 A0 net1 VSS sg13_lv_nmos m=1 w=740.00n l=130.00n ng=1
.ENDS

************************************************************************
* Library Name: sg13cmos5l_stdcell
* Cell Name:    sg13cmos5l_mux2_2
* View Name:    schematic
************************************************************************

.SUBCKT sg13cmos5l_mux2_2 X A0 A1 S VDD VSS
*.PININFO A0:I A1:I S:I X:O VDD:B VSS:B
MP1 net4 S VDD VDD sg13_lv_pmos m=1 w=1.000u l=130.00n ng=1
MP5 X net6 VDD VDD sg13_lv_pmos m=1 w=2.24u l=130.00n ng=2
MP4 net6 A1 net5 VDD sg13_lv_pmos m=1 w=1.000u l=130.00n ng=1
MP0 Sb S VDD VDD sg13_lv_pmos m=1 w=840.00n l=130.00n ng=1
MP3 net5 Sb VDD VDD sg13_lv_pmos m=1 w=1.000u l=130.00n ng=1
MP2 net6 A0 net4 VDD sg13_lv_pmos m=1 w=1.000u l=130.00n ng=1
MN4 net3 S VSS VSS sg13_lv_nmos m=1 w=740.00n l=130.00n ng=1
MN2 net1 Sb VSS VSS sg13_lv_nmos m=1 w=740.00n l=130.00n ng=1
MN5 X net6 VSS VSS sg13_lv_nmos m=1 w=1.48u l=130.00n ng=2
MN0 Sb S VSS VSS sg13_lv_nmos m=1 w=550.00n l=130.00n ng=1
MN3 net6 A1 net3 VSS sg13_lv_nmos m=1 w=740.00n l=130.00n ng=1
MN1 net6 A0 net1 VSS sg13_lv_nmos m=1 w=740.00n l=130.00n ng=1
.ENDS

************************************************************************
* Library Name: sg13cmos5l_stdcell
* Cell Name:    sg13cmos5l_mux4_1
* View Name:    schematic
************************************************************************

.SUBCKT sg13cmos5l_mux4_1 X A0 A1 A2 A3 S0 S1 VDD VSS
*.PININFO A0:I A1:I A2:I A3:I S0:I S1:I X:O VDD:B VSS:B
MN12 X Xb VSS VSS sg13_lv_nmos m=1 w=740.00n l=130.00n ng=1
MN2 low S0b net7 VSS sg13_lv_nmos m=1 w=640.00n l=130.00n ng=1
MN3 net7 A0 VSS VSS sg13_lv_nmos m=1 w=640.00n l=130.00n ng=1
MN6 low S1b Xb VSS sg13_lv_nmos m=1 w=640.00n l=130.00n ng=1
MN11 high S1 Xb VSS sg13_lv_nmos m=1 w=640.00n l=130.00n ng=1
MN10 net4 A3 VSS VSS sg13_lv_nmos m=1 w=640.00n l=130.00n ng=1
MN9 high S0 net4 VSS sg13_lv_nmos m=1 w=640.00n l=130.00n ng=1
MN8 net6 A2 VSS VSS sg13_lv_nmos m=1 w=640.00n l=130.00n ng=1
MN7 high S0b net6 VSS sg13_lv_nmos m=1 w=640.00n l=130.00n ng=1
MN5 net2 A1 VSS VSS sg13_lv_nmos m=1 w=640.00n l=130.00n ng=1
MN4 low S0 net2 VSS sg13_lv_nmos m=1 w=640.00n l=130.00n ng=1
MN1 S1b S1 VSS VSS sg13_lv_nmos m=1 w=640.00n l=130.00n ng=1
MN0 S0b S0 VSS VSS sg13_lv_nmos m=1 w=640.00n l=130.00n ng=1
MP6 low S1 Xb VDD sg13_lv_pmos m=1 w=1.000u l=130.00n ng=1
MP11 high S1b Xb VDD sg13_lv_pmos m=1 w=1.000u l=130.00n ng=1
MP12 X Xb VDD VDD sg13_lv_pmos m=1 w=1.12u l=130.00n ng=1
MP10 high S0b net3 VDD sg13_lv_pmos m=1 w=1.000u l=130.00n ng=1
MP9 net3 A3 VDD VDD sg13_lv_pmos m=1 w=1.000u l=130.00n ng=1
MP8 high S0 net5 VDD sg13_lv_pmos m=1 w=1.000u l=130.00n ng=1
MP7 net5 A2 VDD VDD sg13_lv_pmos m=1 w=1.000u l=130.00n ng=1
MP2 net8 A0 VDD VDD sg13_lv_pmos m=1 w=1.000u l=130.00n ng=1
MP3 low S0 net8 VDD sg13_lv_pmos m=1 w=1.000u l=130.00n ng=1
MP1 S1b S1 VDD VDD sg13_lv_pmos m=1 w=1.000u l=130.00n ng=1
MP0 S0b S0 VDD VDD sg13_lv_pmos m=1 w=1.000u l=130.00n ng=1
MP5 low S0b net1 VDD sg13_lv_pmos m=1 w=1.000u l=130.00n ng=1
MP4 net1 A1 VDD VDD sg13_lv_pmos m=1 w=1.000u l=130.00n ng=1
.ENDS

************************************************************************
* Library Name: sg13cmos5l_stdcell
* Cell Name:    sg13cmos5l_nand2_1
* View Name:    schematic
************************************************************************

.SUBCKT sg13cmos5l_nand2_1 Y A B VDD VSS
*.PININFO A:I B:I Y:O VDD:B VSS:B
MP1 Y B VDD VDD sg13_lv_pmos m=1 w=1.12u l=130.00n ng=1
MP0 Y A VDD VDD sg13_lv_pmos m=1 w=1.12u l=130.00n ng=1
MN1 net1 B VSS VSS sg13_lv_nmos m=1 w=740.00n l=130.00n ng=1
MN0 Y A net1 VSS sg13_lv_nmos m=1 w=740.00n l=130.00n ng=1
.ENDS

************************************************************************
* Library Name: sg13cmos5l_stdcell
* Cell Name:    sg13cmos5l_nand2_2
* View Name:    schematic
************************************************************************

.SUBCKT sg13cmos5l_nand2_2 Y A B VDD VSS
*.PININFO A:I B:I Y:O VDD:B VSS:B
MP1 Y B VDD VDD sg13_lv_pmos m=1 w=2.24u l=130.00n ng=2
MP0 Y A VDD VDD sg13_lv_pmos m=1 w=2.24u l=130.00n ng=2
MN1 net1 B VSS VSS sg13_lv_nmos m=1 w=1.44u l=130.00n ng=2
MN0 Y A net1 VSS sg13_lv_nmos m=1 w=1.44u l=130.00n ng=2
.ENDS

************************************************************************
* Library Name: sg13cmos5l_stdcell
* Cell Name:    sg13cmos5l_nand2b_1
* View Name:    schematic
************************************************************************

.SUBCKT sg13cmos5l_nand2b_1 Y A_N B VDD VSS
*.PININFO A_N:I B:I Y:O VDD:B VSS:B
MP2 Y net2 VDD VDD sg13_lv_pmos m=1 w=1.12u l=130.00n ng=1
MP1 net2 A_N VDD VDD sg13_lv_pmos m=1 w=840.00n l=130.00n ng=1
MP0 Y B VDD VDD sg13_lv_pmos m=1 w=1.12u l=130.00n ng=1
MN1 Y net2 net1 VSS sg13_lv_nmos m=1 w=740.00n l=130.00n ng=1
MN0 net2 A_N VSS VSS sg13_lv_nmos m=1 w=550.00n l=130.00n ng=1
MN2 net1 B VSS VSS sg13_lv_nmos m=1 w=740.00n l=130.00n ng=1
.ENDS

************************************************************************
* Library Name: sg13cmos5l_stdcell
* Cell Name:    sg13cmos5l_nand2b_2
* View Name:    schematic
************************************************************************

.SUBCKT sg13cmos5l_nand2b_2 Y A_N B VDD VSS
*.PININFO A_N:I B:I Y:O VDD:B VSS:B
MP2 Y A VDD VDD sg13_lv_pmos m=1 w=2.24u l=130.00n ng=2
MP0 A A_N VDD VDD sg13_lv_pmos m=1 w=840.00n l=130.00n ng=1
MP1 Y B VDD VDD sg13_lv_pmos m=1 w=2.24u l=130.00n ng=2
MN1 Y B net1 VSS sg13_lv_nmos m=1 w=1.44u l=130.00n ng=2
MN0 A A_N VSS VSS sg13_lv_nmos m=1 w=550.00n l=130.00n ng=1
MN2 net1 A VSS VSS sg13_lv_nmos m=1 w=1.44u l=130.00n ng=2
.ENDS

************************************************************************
* Library Name: sg13cmos5l_stdcell
* Cell Name:    sg13cmos5l_nand3_1
* View Name:    schematic
************************************************************************

.SUBCKT sg13cmos5l_nand3_1 Y A B C VDD VSS
*.PININFO A:I B:I C:I Y:O VDD:B VSS:B
MP0 Y A VDD VDD sg13_lv_pmos m=1 w=1.12u l=130.00n ng=1
MP1 Y B VDD VDD sg13_lv_pmos m=1 w=1.12u l=130.00n ng=1
MP2 Y C VDD VDD sg13_lv_pmos m=1 w=1.12u l=130.00n ng=1
MN1 net2 B net3 VSS sg13_lv_nmos m=1 w=740.00n l=130.00n ng=1
MN2 net3 C VSS VSS sg13_lv_nmos m=1 w=740.00n l=130.00n ng=1
MN0 Y A net2 VSS sg13_lv_nmos m=1 w=740.00n l=130.00n ng=1
.ENDS

************************************************************************
* Library Name: sg13cmos5l_stdcell
* Cell Name:    sg13cmos5l_nand3b_1
* View Name:    schematic
************************************************************************

.SUBCKT sg13cmos5l_nand3b_1 Y A_N B C VDD VSS
*.PININFO A_N:I B:I C:I Y:O VDD:B VSS:B
MP0 net1 A_N VDD VDD sg13_lv_pmos m=1 w=840.00n l=130.00n ng=1
MP1 Y net1 VDD VDD sg13_lv_pmos m=1 w=1.12u l=130.00n ng=1
MP2 Y B VDD VDD sg13_lv_pmos m=1 w=1.12u l=130.00n ng=1
MP3 Y C VDD VDD sg13_lv_pmos m=1 w=1.12u l=130.00n ng=1
MN2 net2 B net3 VSS sg13_lv_nmos m=1 w=740.00n l=130.00n ng=1
MN3 net3 C VSS VSS sg13_lv_nmos m=1 w=740.00n l=130.00n ng=1
MN0 net1 A_N VSS VSS sg13_lv_nmos m=1 w=550.00n l=130.00n ng=1
MN1 Y net1 net2 VSS sg13_lv_nmos m=1 w=740.00n l=130.00n ng=1
.ENDS

************************************************************************
* Library Name: sg13cmos5l_stdcell
* Cell Name:    sg13cmos5l_nand4_1
* View Name:    schematic
************************************************************************

.SUBCKT sg13cmos5l_nand4_1 Y A B C D VDD VSS
*.PININFO A:I B:I C:I D:I Y:O VDD:B VSS:B
MP3 Y D VDD VDD sg13_lv_pmos m=1 w=1.12u l=130.00n ng=1
MP0 Y A VDD VDD sg13_lv_pmos m=1 w=1.12u l=130.00n ng=1
MP1 Y B VDD VDD sg13_lv_pmos m=1 w=1.12u l=130.00n ng=1
MP2 Y C VDD VDD sg13_lv_pmos m=1 w=1.12u l=130.00n ng=1
MN1 net2 B net3 VSS sg13_lv_nmos m=1 w=740.00n l=130.00n ng=1
MN2 net3 C net5 VSS sg13_lv_nmos m=1 w=740.00n l=130.00n ng=1
MN0 Y A net2 VSS sg13_lv_nmos m=1 w=740.00n l=130.00n ng=1
MN3 net5 D VSS VSS sg13_lv_nmos m=1 w=740.00n l=130.00n ng=1
.ENDS

************************************************************************
* Library Name: sg13cmos5l_stdcell
* Cell Name:    sg13cmos5l_nor2_1
* View Name:    schematic
************************************************************************

.SUBCKT sg13cmos5l_nor2_1 Y A B VDD VSS
*.PININFO A:I B:I Y:O VDD:B VSS:B
MN0 Y A VSS VSS sg13_lv_nmos m=1 w=740.00n l=130.00n ng=1
MN1 Y B VSS VSS sg13_lv_nmos m=1 w=740.00n l=130.00n ng=1
MP0 net1 A VDD VDD sg13_lv_pmos m=1 w=1.12u l=130.00n ng=1
MP1 Y B net1 VDD sg13_lv_pmos m=1 w=1.12u l=130.00n ng=1
.ENDS

************************************************************************
* Library Name: sg13cmos5l_stdcell
* Cell Name:    sg13cmos5l_nor2_2
* View Name:    schematic
************************************************************************

.SUBCKT sg13cmos5l_nor2_2 Y A B VDD VSS
*.PININFO A:I B:I Y:O VDD:B VSS:B
MN0 Y A VSS VSS sg13_lv_nmos m=1 w=1.48u l=130.00n ng=2
MN1 Y B VSS VSS sg13_lv_nmos m=1 w=1.48u l=130.00n ng=2
MP0 net1 A VDD VDD sg13_lv_pmos m=1 w=2.24u l=130.00n ng=2
MP1 Y B net1 VDD sg13_lv_pmos m=1 w=2.24u l=130.00n ng=2
.ENDS

************************************************************************
* Library Name: sg13cmos5l_stdcell
* Cell Name:    sg13cmos5l_nor2b_1
* View Name:    schematic
************************************************************************

.SUBCKT sg13cmos5l_nor2b_1 Y A B_N VDD VSS
*.PININFO A:I B_N:I Y:O VDD:B VSS:B
MN0 B B_N VSS VSS sg13_lv_nmos m=1 w=550.00n l=130.00n ng=1
MN1 Y A VSS VSS sg13_lv_nmos m=1 w=740.00n l=130.00n ng=1
MN2 Y B VSS VSS sg13_lv_nmos m=1 w=740.00n l=130.00n ng=1
MP0 B B_N VDD VDD sg13_lv_pmos m=1 w=840.00n l=130.00n ng=1
MP1 net1 B VDD VDD sg13_lv_pmos m=1 w=1.12u l=130.00n ng=1
MP2 Y A net1 VDD sg13_lv_pmos m=1 w=1.12u l=130.00n ng=1
.ENDS

************************************************************************
* Library Name: sg13cmos5l_stdcell
* Cell Name:    sg13cmos5l_nor2b_2
* View Name:    schematic
************************************************************************

.SUBCKT sg13cmos5l_nor2b_2 Y A B_N VDD VSS
*.PININFO A:I B_N:I Y:O VDD:B VSS:B
MN0 B B_N VSS VSS sg13_lv_nmos m=1 w=640.00n l=130.00n ng=1
MN1 Y A VSS VSS sg13_lv_nmos m=1 w=1.44u l=130.00n ng=2
MN2 Y B VSS VSS sg13_lv_nmos m=1 w=1.44u l=130.00n ng=2
MP0 B B_N VDD VDD sg13_lv_pmos m=1 w=1.000u l=130.00n ng=1
MP1 net1 B VDD VDD sg13_lv_pmos m=1 w=2.24u l=130.00n ng=2
MP2 Y A net1 VDD sg13_lv_pmos m=1 w=2.24u l=130.00n ng=2
.ENDS

************************************************************************
* Library Name: sg13cmos5l_stdcell
* Cell Name:    sg13cmos5l_nor3_1
* View Name:    schematic
************************************************************************

.SUBCKT sg13cmos5l_nor3_1 Y A B C VDD VSS
*.PININFO A:I B:I C:I Y:O VDD:B VSS:B
MP2 Y C net2 VDD sg13_lv_pmos m=1 w=1.12u l=130.00n ng=1
MP1 net2 B net3 VDD sg13_lv_pmos m=1 w=1.12u l=130.00n ng=1
MP0 net3 A VDD VDD sg13_lv_pmos m=1 w=1.12u l=130.00n ng=1
MN0 Y A VSS VSS sg13_lv_nmos m=1 w=770.00n l=130.00n ng=1
MN1 Y B VSS VSS sg13_lv_nmos m=1 w=770.00n l=130.00n ng=1
MN2 Y C VSS VSS sg13_lv_nmos m=1 w=770.00n l=130.00n ng=1
.ENDS

************************************************************************
* Library Name: sg13cmos5l_stdcell
* Cell Name:    sg13cmos5l_nor3_2
* View Name:    schematic
************************************************************************

.SUBCKT sg13cmos5l_nor3_2 Y A B C VDD VSS
*.PININFO A:I B:I C:I Y:O VDD:B VSS:B
MP2 Y C net2 VDD sg13_lv_pmos m=1 w=2.24u l=130.00n ng=2
MP1 net2 B net3 VDD sg13_lv_pmos m=1 w=2.24u l=130.00n ng=2
MP0 net3 A VDD VDD sg13_lv_pmos m=1 w=2.24u l=130.00n ng=2
MN0 Y A VSS VSS sg13_lv_nmos m=1 w=1.48u l=130.00n ng=2
MN1 Y B VSS VSS sg13_lv_nmos m=1 w=1.48u l=130.00n ng=2
MN2 Y C VSS VSS sg13_lv_nmos m=1 w=1.48u l=130.00n ng=2
.ENDS

************************************************************************
* Library Name: sg13cmos5l_stdcell
* Cell Name:    sg13cmos5l_nor4_1
* View Name:    schematic
************************************************************************

.SUBCKT sg13cmos5l_nor4_1 Y A B C D VDD VSS
*.PININFO A:I B:I C:I D:I Y:O VDD:B VSS:B
MP0 net3 A VDD VDD sg13_lv_pmos m=1 w=1.12u l=130.00n ng=1
MP1 net2 B net3 VDD sg13_lv_pmos m=1 w=1.12u l=130.00n ng=1
MP2 net1 C net2 VDD sg13_lv_pmos m=1 w=1.12u l=130.00n ng=1
MP3 Y D net1 VDD sg13_lv_pmos m=1 w=1.12u l=130.00n ng=1
MN0 Y A VSS VSS sg13_lv_nmos m=1 w=740.00n l=130.00n ng=1
MN3 Y D VSS VSS sg13_lv_nmos m=1 w=740.00n l=130.00n ng=1
MN1 Y B VSS VSS sg13_lv_nmos m=1 w=740.00n l=130.00n ng=1
MN2 Y C VSS VSS sg13_lv_nmos m=1 w=740.00n l=130.00n ng=1
.ENDS

************************************************************************
* Library Name: sg13cmos5l_stdcell
* Cell Name:    sg13cmos5l_nor4_2
* View Name:    schematic
************************************************************************

.SUBCKT sg13cmos5l_nor4_2 Y A B C D VDD VSS
*.PININFO A:I B:I C:I D:I Y:O VDD:B VSS:B
MP0 net3 A VDD VDD sg13_lv_pmos m=1 w=2.24u l=130.00n ng=2
MP1 net2 B net3 VDD sg13_lv_pmos m=1 w=2.24u l=130.00n ng=2
MP2 net1 C net2 VDD sg13_lv_pmos m=1 w=2.24u l=130.00n ng=2
MP3 Y D net1 VDD sg13_lv_pmos m=1 w=2.24u l=130.00n ng=2
MN0 Y A VSS VSS sg13_lv_nmos m=1 w=1.48u l=130.00n ng=2
MN3 Y D VSS VSS sg13_lv_nmos m=1 w=1.48u l=130.00n ng=2
MN1 Y B VSS VSS sg13_lv_nmos m=1 w=1.48u l=130.00n ng=2
MN2 Y C VSS VSS sg13_lv_nmos m=1 w=1.48u l=130.00n ng=2
.ENDS

************************************************************************
* Library Name: sg13cmos5l_stdcell
* Cell Name:    sg13cmos5l_o21ai_1
* View Name:    schematic
************************************************************************

.SUBCKT sg13cmos5l_o21ai_1 Y A1 A2 B1 VDD VSS
*.PININFO A1:I A2:I B1:I Y:O VDD:B VSS:B
MP0 net14 A1 VDD VDD sg13_lv_pmos m=1 w=1.12u l=150.00n ng=1
MP1 Y A2 net14 VDD sg13_lv_pmos m=1 w=1.12u l=150.00n ng=1
MP2 Y B1 VDD VDD sg13_lv_pmos m=1 w=1.12u l=150.00n ng=1
MN0 net1 A2 VSS VSS sg13_lv_nmos m=1 w=740.00n l=150.00n ng=1
MN2 net1 A1 VSS VSS sg13_lv_nmos m=1 w=740.00n l=150.00n ng=1
MN1 Y B1 net1 VSS sg13_lv_nmos m=1 w=740.00n l=150.00n ng=1
.ENDS

************************************************************************
* Library Name: sg13cmos5l_stdcell
* Cell Name:    sg13cmos5l_or2_1
* View Name:    schematic
************************************************************************

.SUBCKT sg13cmos5l_or2_1 X A B VDD VSS
*.PININFO A:I B:I X:O VDD:B VSS:B
MP1 net2 B net3 VDD sg13_lv_pmos m=1 w=840.00n l=130.00n ng=1
MP0 net3 A VDD VDD sg13_lv_pmos m=1 w=840.00n l=130.00n ng=1
MP2 X net2 VDD VDD sg13_lv_pmos m=1 w=1.12u l=130.00n ng=1
MN1 net2 A VSS VSS sg13_lv_nmos m=1 w=550.00n l=130.00n ng=1
MN0 net2 B VSS VSS sg13_lv_nmos m=1 w=550.00n l=130.00n ng=1
MN2 X net2 VSS VSS sg13_lv_nmos m=1 w=740.00n l=130.00n ng=1
.ENDS

************************************************************************
* Library Name: sg13cmos5l_stdcell
* Cell Name:    sg13cmos5l_or2_2
* View Name:    schematic
************************************************************************

.SUBCKT sg13cmos5l_or2_2 X A B VDD VSS
*.PININFO A:I B:I X:O VDD:B VSS:B
MP1 net2 B net3 VDD sg13_lv_pmos m=1 w=840.00n l=130.00n ng=1
MP0 net3 A VDD VDD sg13_lv_pmos m=1 w=840.00n l=130.00n ng=1
MP2 X net2 VDD VDD sg13_lv_pmos m=1 w=2.24u l=130.00n ng=2
MN1 net2 A VSS VSS sg13_lv_nmos m=1 w=550.00n l=130.00n ng=1
MN0 net2 B VSS VSS sg13_lv_nmos m=1 w=550.00n l=130.00n ng=1
MN2 X net2 VSS VSS sg13_lv_nmos m=1 w=1.48u l=130.00n ng=2
.ENDS

************************************************************************
* Library Name: sg13cmos5l_stdcell
* Cell Name:    sg13cmos5l_or3_1
* View Name:    schematic
************************************************************************

.SUBCKT sg13cmos5l_or3_1 X A B C VDD VSS
*.PININFO A:I B:I C:I X:O VDD:B VSS:B
MN2 net1 C VSS VSS sg13_lv_nmos m=1 w=550.00n l=130.00n ng=1
MN3 X net1 VSS VSS sg13_lv_nmos m=1 w=740.00n l=130.00n ng=1
MN1 net1 B VSS VSS sg13_lv_nmos m=1 w=550.00n l=130.00n ng=1
MN0 net1 A VSS VSS sg13_lv_nmos m=1 w=550.00n l=130.00n ng=1
MP3 X net1 VDD VDD sg13_lv_pmos m=1 w=1.12u l=130.00n ng=1
MP1 net9 B net12 VDD sg13_lv_pmos m=1 w=1.000u l=130.00n ng=1
MP0 net12 A VDD VDD sg13_lv_pmos m=1 w=1.000u l=130.00n ng=1
MP2 net1 C net9 VDD sg13_lv_pmos m=1 w=1.000u l=130.00n ng=1
.ENDS

************************************************************************
* Library Name: sg13cmos5l_stdcell
* Cell Name:    sg13cmos5l_or3_2
* View Name:    schematic
************************************************************************

.SUBCKT sg13cmos5l_or3_2 X A B C VDD VSS
*.PININFO A:I B:I C:I X:O VDD:B VSS:B
MN2 net1 C VSS VSS sg13_lv_nmos m=1 w=550.00n l=130.00n ng=1
MN3 X net1 VSS VSS sg13_lv_nmos m=1 w=1.48u l=130.00n ng=2
MN1 net1 B VSS VSS sg13_lv_nmos m=1 w=550.00n l=130.00n ng=1
MN0 net1 A VSS VSS sg13_lv_nmos m=1 w=550.00n l=130.00n ng=1
MP3 X net1 VDD VDD sg13_lv_pmos m=1 w=2.24u l=130.00n ng=2
MP1 net9 B net12 VDD sg13_lv_pmos m=1 w=1.000u l=130.00n ng=1
MP0 net12 A VDD VDD sg13_lv_pmos m=1 w=1.000u l=130.00n ng=1
MP2 net1 C net9 VDD sg13_lv_pmos m=1 w=1.000u l=130.00n ng=1
.ENDS

************************************************************************
* Library Name: sg13cmos5l_stdcell
* Cell Name:    sg13cmos5l_or4_1
* View Name:    schematic
************************************************************************

.SUBCKT sg13cmos5l_or4_1 X A B C D VDD VSS
*.PININFO A:I B:I C:I D:I X:O VDD:B VSS:B
MN4 X net1 VSS VSS sg13_lv_nmos m=1 w=740.00n l=130.00n ng=1
MN3 net1 D VSS VSS sg13_lv_nmos m=1 w=550.00n l=130.00n ng=1
MN2 net1 C VSS VSS sg13_lv_nmos m=1 w=550.00n l=130.00n ng=1
MN1 net1 B VSS VSS sg13_lv_nmos m=1 w=550.00n l=130.00n ng=1
MN0 net1 A VSS VSS sg13_lv_nmos m=1 w=550.00n l=130.00n ng=1
MP0 net4 A VDD VDD sg13_lv_pmos m=1 w=1.000u l=130.00n ng=1
MP1 net3 B net4 VDD sg13_lv_pmos m=1 w=1.000u l=130.00n ng=1
MP2 net2 C net3 VDD sg13_lv_pmos m=1 w=1.000u l=130.00n ng=1
MP3 net1 D net2 VDD sg13_lv_pmos m=1 w=1.000u l=130.00n ng=1
MP4 X net1 VDD VDD sg13_lv_pmos m=1 w=1.12u l=130.00n ng=1
.ENDS

************************************************************************
* Library Name: sg13cmos5l_stdcell
* Cell Name:    sg13cmos5l_or4_2
* View Name:    schematic
************************************************************************

.SUBCKT sg13cmos5l_or4_2 X A B C D VDD VSS
*.PININFO A:I B:I C:I D:I X:O VDD:B VSS:B
MN4 X net1 VSS VSS sg13_lv_nmos m=1 w=1.48u l=130.00n ng=2
MN3 net1 D VSS VSS sg13_lv_nmos m=1 w=550.00n l=130.00n ng=1
MN2 net1 C VSS VSS sg13_lv_nmos m=1 w=550.00n l=130.00n ng=1
MN1 net1 B VSS VSS sg13_lv_nmos m=1 w=550.00n l=130.00n ng=1
MN0 net1 A VSS VSS sg13_lv_nmos m=1 w=550.00n l=130.00n ng=1
MP0 net4 A VDD VDD sg13_lv_pmos m=1 w=1.000u l=130.00n ng=1
MP1 net3 B net4 VDD sg13_lv_pmos m=1 w=1.000u l=130.00n ng=1
MP2 net2 C net3 VDD sg13_lv_pmos m=1 w=1.000u l=130.00n ng=1
MP3 net1 D net2 VDD sg13_lv_pmos m=1 w=1.000u l=130.00n ng=1
MP4 X net1 VDD VDD sg13_lv_pmos m=1 w=2.24u l=130.00n ng=2
.ENDS

************************************************************************
* Library Name: sg13cmos5l_stdcell
* Cell Name:    sg13cmos5l_sdfbbp_1
* View Name:    schematic
************************************************************************

.SUBCKT sg13cmos5l_sdfbbp_1 Q Q_N CLK D RESET_B SCD SCE SET_B VDD VSS
*.PININFO CLK:I D:I RESET_B:I SCD:I SCE:I SET_B:I Q:O Q_N:O VDD:B VSS:B
MP1 resetbb RESET_B VDD VDD sg13_lv_pmos m=1 w=640.00n l=130.00n ng=1
MP19 pre_q DbbLatch2 net8 VDD sg13_lv_pmos m=1 w=1.000u l=130.00n ng=1
MP20 pre_q SET_B VDD VDD sg13_lv_pmos m=1 w=1.000u l=130.00n ng=1
MP3 CLKbb CLKb VDD VDD sg13_lv_pmos m=1 w=1.12u l=130.00n ng=1
MP0 SCEb SCE VDD VDD sg13_lv_pmos m=1 w=640.00n l=130.00n ng=1
MP7 Db D net3 VDD sg13_lv_pmos m=1 w=640.00n l=130.00n ng=1
MP13 DbbTG CLKb net10 VDD sg13_lv_pmos m=1 w=420.00n l=130.00n ng=1
MP12 net10 DbLatchM VDD VDD sg13_lv_pmos m=1 w=420.00n l=130.00n ng=1
MP6 net3 SCE VDD VDD sg13_lv_pmos m=1 w=640.00n l=130.00n ng=1
MP21 Q_N pre_q VDD VDD sg13_lv_pmos m=1 w=1.12u l=130.00n ng=1
MP14 net1 DbLatchM VDD VDD sg13_lv_pmos m=1 w=840.00n l=130.00n ng=1
MP18 net8 resetbb VDD VDD sg13_lv_pmos m=1 w=1.000u l=130.00n ng=1
MP11 DbLatchM SET_B VDD VDD sg13_lv_pmos m=1 w=840.00n l=130.00n ng=1
MP4 net2 SCD VDD VDD sg13_lv_pmos m=1 w=640.00n l=130.00n ng=1
MP2 CLKb CLK VDD VDD sg13_lv_pmos m=1 w=1.12u l=130.00n ng=1
MP10 DbLatchM DbbTG net7 VDD sg13_lv_pmos m=1 w=840.00n l=130.00n ng=1
MP8 Db CLKbb DbbTG VDD sg13_lv_pmos m=1 w=640.00n l=130.00n ng=1
MP5 Db SCEb net2 VDD sg13_lv_pmos m=1 w=640.00n l=130.00n ng=1
MP22 pre_qb pre_q VDD VDD sg13_lv_pmos m=1 w=840.00n l=130.00n ng=1
MP9 net7 resetbb VDD VDD sg13_lv_pmos m=1 w=840.00n l=130.00n ng=1
MP16 net6 pre_q VDD VDD sg13_lv_pmos m=1 w=420.00n l=130.00n ng=1
MP17 DbbLatch2 CLKbb net6 VDD sg13_lv_pmos m=1 w=420.00n l=130.00n ng=1
MP15 DbbLatch2 CLKb net1 VDD sg13_lv_pmos m=1 w=840.00n l=130.00n ng=1
MP23 Q pre_qb VDD VDD sg13_lv_pmos m=1 w=1.12u l=130.00n ng=1
MN4 Db SCE net5 VSS sg13_lv_nmos m=1 w=420.00n l=130.00n ng=1
MN5 net5 SCD VSS VSS sg13_lv_nmos m=1 w=420.00n l=130.00n ng=1
MN18 pre_q DbbLatch2 net11 VSS sg13_lv_nmos m=1 w=740.00n l=130.00n ng=1
MN8 Db CLKb DbbTG VSS sg13_lv_nmos m=1 w=420.00n l=130.00n ng=1
MN7 net4 SCEb VSS VSS sg13_lv_nmos m=1 w=420.00n l=130.00n ng=1
MN3 CLKbb CLKb VSS VSS sg13_lv_nmos m=1 w=740.00n l=130.00n ng=1
MN1 resetbb RESET_B VSS VSS sg13_lv_nmos m=1 w=420.00n l=130.00n ng=1
MN17 net14 pre_q VSS VSS sg13_lv_nmos m=1 w=420.00n l=130.00n ng=1
MN9 DbLatchM DbbTG net12 VSS sg13_lv_nmos m=1 w=550.00n l=130.00n ng=1
MN0 SCEb SCE VSS VSS sg13_lv_nmos m=1 w=420.00n l=130.00n ng=1
MN10 net12 SET_B VSS VSS sg13_lv_nmos m=1 w=550.00n l=130.00n ng=1
MN13 net15 DbLatchM VSS VSS sg13_lv_nmos m=1 w=420.00n l=130.00n ng=1
MN19 net11 SET_B VSS VSS sg13_lv_nmos m=1 w=740.00n l=130.00n ng=1
MN12 DbbTG CLKbb net15 VSS sg13_lv_nmos m=1 w=420.00n l=130.00n ng=1
MN6 Db D net4 VSS sg13_lv_nmos m=1 w=420.00n l=130.00n ng=1
MN22 pre_qb pre_q VSS VSS sg13_lv_nmos m=1 w=550.00n l=130.00n ng=1
MN16 DbbLatch2 CLKb net14 VSS sg13_lv_nmos m=1 w=420.00n l=130.00n ng=1
MN23 Q pre_qb VSS VSS sg13_lv_nmos m=1 w=740.00n l=130.00n ng=1
MN15 net13 DbLatchM VSS VSS sg13_lv_nmos m=1 w=550.00n l=130.00n ng=1
MN2 CLKb CLK VSS VSS sg13_lv_nmos m=1 w=740.00n l=130.00n ng=1
MN14 DbbLatch2 CLKbb net13 VSS sg13_lv_nmos m=1 w=550.00n l=130.00n ng=1
MN11 DbLatchM resetbb net12 VSS sg13_lv_nmos m=1 w=550.00n l=130.00n ng=1
MN21 Q_N pre_q VSS VSS sg13_lv_nmos m=1 w=740.00n l=130.00n ng=1
MN20 pre_q resetbb net11 VSS sg13_lv_nmos m=1 w=740.00n l=130.00n ng=1
.ENDS

************************************************************************
* Library Name: sg13cmos5l_stdcell
* Cell Name:    sg13cmos5l_sighold
* View Name:    schematic
************************************************************************

.SUBCKT sg13cmos5l_sighold SH VDD VSS
*.PININFO SH:B VDD:B VSS:B
MN1 net1 SH VSS VSS sg13_lv_nmos m=1 w=300.0n l=130.00n ng=1
MN0 SH net1 VSS VSS sg13_lv_nmos m=1 w=300.0n l=700.0n ng=1
MP1 net1 SH VDD VDD sg13_lv_pmos m=1 w=450.00n l=130.00n ng=1
MP0 SH net1 VDD VDD sg13_lv_pmos m=1 w=300.0n l=700.0n ng=1
.ENDS

************************************************************************
* Library Name: sg13cmos5l_stdcell
* Cell Name:    sg13cmos5l_slgcp_1
* View Name:    schematic
************************************************************************

.SUBCKT sg13cmos5l_slgcp_1 GCLK CLK GATE SCE VDD VSS
*.PININFO CLK:I GATE:I SCE:I GCLK:O VDD:B VSS:B
MP10 GCLK net5 VDD VDD sg13_lv_pmos m=1 w=1.12u l=130.00n ng=1
MP4 net1 CLKbb net6 VDD sg13_lv_pmos m=1 w=840.00n l=130.00n ng=1
MP1 CLKbb CLKb VDD VDD sg13_lv_pmos m=1 w=840.00n l=130.00n ng=1
MP8 net5 int_GATE VDD VDD sg13_lv_pmos m=1 w=840.00n l=130.00n ng=1
MP2 net3 SCE VDD VDD sg13_lv_pmos m=1 w=840.00n l=130.00n ng=1
MP7 net6 CLKb net4 VDD sg13_lv_pmos m=1 w=420.00n l=130.00n ng=1
MP5 int_GATE net6 VDD VDD sg13_lv_pmos m=1 w=1.12u l=130.00n ng=1
MP0 CLKb CLK VDD VDD sg13_lv_pmos m=1 w=840.00n l=130.00n ng=1
MP9 net5 CLK VDD VDD sg13_lv_pmos m=1 w=840.00n l=130.00n ng=1
MP6 net4 int_GATE VDD VDD sg13_lv_pmos m=1 w=420.00n l=130.00n ng=1
MP3 net1 GATE net3 VDD sg13_lv_pmos m=1 w=840.00n l=130.00n ng=1
MN5 int_GATE net6 VSS VSS sg13_lv_nmos m=1 w=740.00n l=130.00n ng=1
MN9 net2 CLK VSS VSS sg13_lv_nmos m=1 w=640.00n l=130.00n ng=1
MN2 net1 SCE VSS VSS sg13_lv_nmos m=1 w=550.00n l=130.00n ng=1
MN4 net6 CLKb net1 VSS sg13_lv_nmos m=1 w=550.00n l=130.00n ng=1
MN7 net7 int_GATE VSS VSS sg13_lv_nmos m=1 w=420.00n l=130.00n ng=1
MN8 net5 int_GATE net2 VSS sg13_lv_nmos m=1 w=640.00n l=130.00n ng=1
MN10 GCLK net5 VSS VSS sg13_lv_nmos m=1 w=740.00n l=130.00n ng=1
MN1 CLKbb CLKb VSS VSS sg13_lv_nmos m=1 w=740.00n l=130.00n ng=1
MN3 net1 GATE VSS VSS sg13_lv_nmos m=1 w=550.00n l=130.00n ng=1
MN0 CLKb CLK VSS VSS sg13_lv_nmos m=1 w=740.00n l=130.00n ng=1
MN6 net6 CLKbb net7 VSS sg13_lv_nmos m=1 w=420.00n l=130.00n ng=1
.ENDS

************************************************************************
* Library Name: sg13cmos5l_stdcell
* Cell Name:    sg13cmos5l_tiehi
* View Name:    schematic
************************************************************************

.SUBCKT sg13cmos5l_tiehi L_HI VDD VSS
*.PININFO L_HI:O VDD:B VSS:B
MN1 net3 net2 VSS VSS sg13_lv_nmos m=1 w=795.00n l=130.00n ng=1
MN0 net1 net1 VSS VSS sg13_lv_nmos m=1 w=300n l=130.00n ng=1
MP1 L_HI net3 VDD VDD sg13_lv_pmos m=1 w=1.155u l=130.00n ng=1
MP0 net2 net1 VDD VDD sg13_lv_pmos m=1 w=660.0n l=130.00n ng=1
.ENDS

************************************************************************
* Library Name: sg13cmos5l_stdcell
* Cell Name:    sg13cmos5l_tielo
* View Name:    schematic
************************************************************************

.SUBCKT sg13cmos5l_tielo L_LO VDD VSS
*.PININFO L_LO:O VDD:B VSS:B
MN0 net3 net2 VSS VSS sg13_lv_nmos m=1 w=385.00n l=130.00n ng=1
MN1 L_LO net1 VSS VSS sg13_lv_nmos m=1 w=880.0n l=130.00n ng=1
MP0 net2 net2 VDD VDD sg13_lv_pmos m=1 w=300n l=130.00n ng=1
MP1 net1 net3 VDD VDD sg13_lv_pmos m=1 w=1.045u l=130.00n ng=1
.ENDS

************************************************************************
* Library Name: sg13cmos5l_stdcell
* Cell Name:    sg13cmos5l_xnor2_1
* View Name:    schematic
************************************************************************

.SUBCKT sg13cmos5l_xnor2_1 Y A B VDD VSS
*.PININFO A:I B:I Y:O VDD:B VSS:B
MP4 Y net1 VDD VDD sg13_lv_pmos m=1 w=1.12u l=130.00n ng=1
MP3 Y B net4 VDD sg13_lv_pmos m=1 w=1.12u l=130.00n ng=1
MP2 net4 A VDD VDD sg13_lv_pmos m=1 w=1.12u l=130.00n ng=1
MP1 net1 B VDD VDD sg13_lv_pmos m=1 w=840.00n l=130.00n ng=1
MP0 net1 A VDD VDD sg13_lv_pmos m=1 w=840.00n l=130.00n ng=1
MN3 Y net1 net3 VSS sg13_lv_nmos m=1 w=740.00n l=130.00n ng=1
MN1 net2 A VSS VSS sg13_lv_nmos m=1 w=640.00n l=130.00n ng=1
MN0 net1 B net2 VSS sg13_lv_nmos m=1 w=640.00n l=130.00n ng=1
MN4 net3 B VSS VSS sg13_lv_nmos m=1 w=740.00n l=130.00n ng=1
MN2 net3 A VSS VSS sg13_lv_nmos m=1 w=740.00n l=130.00n ng=1
.ENDS

************************************************************************
* Library Name: sg13cmos5l_stdcell
* Cell Name:    sg13cmos5l_xor2_1
* View Name:    schematic
************************************************************************

.SUBCKT sg13cmos5l_xor2_1 X A B VDD VSS
*.PININFO A:I B:I X:O VDD:B VSS:B
MN0 net1 A VSS VSS sg13_lv_nmos m=1 w=550.00n l=130.00n ng=1
MN3 X B net3 VSS sg13_lv_nmos m=1 w=740.00n l=130.00n ng=1
MN2 X net1 VSS VSS sg13_lv_nmos m=1 w=740.00n l=130.00n ng=1
MN4 net3 A VSS VSS sg13_lv_nmos m=1 w=740.00n l=130.00n ng=1
MN1 net1 B VSS VSS sg13_lv_nmos m=1 w=550.00n l=130.00n ng=1
MP0 net6 A VDD VDD sg13_lv_pmos m=1 w=1.000u l=130.00n ng=1
MP1 net1 B net6 VDD sg13_lv_pmos m=1 w=1.000u l=130.00n ng=1
MP2 net5 A VDD VDD sg13_lv_pmos m=1 w=1.12u l=130.00n ng=1
MP4 net5 B VDD VDD sg13_lv_pmos m=1 w=1.12u l=130.00n ng=1
MP3 X net1 net5 VDD sg13_lv_pmos m=1 w=1.12u l=130.00n ng=1
.ENDS

************************************************************************
* Library Name: sg13cmos5l_stdcell
* Cell Name:    sg13cmos5l_a22oi_1
* View Name:    schematic
************************************************************************

.SUBCKT sg13cmos5l_a22oi_1 Y A1 A2 B1 B2 VDD VSS
*.PININFO A1:I A2:I B1:I B2:I Y:O VDD:B VSS:B
MN1 net1 B1 VSS VSS sg13_lv_nmos m=1 w=740.00n l=130.00n ng=1
MN0 Y B2 net1 VSS sg13_lv_nmos m=1 w=740.00n l=130.00n ng=1
MN3 net2 A2 VSS VSS sg13_lv_nmos m=1 w=740.00n l=130.00n ng=1
MN2 Y A1 net2 VSS sg13_lv_nmos m=1 w=740.00n l=130.00n ng=1
MP1 Y B1 net3 VDD sg13_lv_pmos m=1 w=1.12u l=130.00n ng=1
MP3 Y B2 net3 VDD sg13_lv_pmos m=1 w=1.12u l=130.00n ng=1
MP2 net3 A2 VDD VDD sg13_lv_pmos m=1 w=1.12u l=130.00n ng=1
MP0 net3 A1 VDD VDD sg13_lv_pmos m=1 w=1.12u l=130.00n ng=1
.ENDS

************************************************************************
* Library Name: sg13cmos5l_stdcell
* Cell Name:    sg13cmos5l_sdfrbpq_1
* View Name:    schematic
************************************************************************

.SUBCKT sg13cmos5l_sdfrbpq_1 Q CLK D RESET_B SCD SCE VDD VSS
*.PININFO CLK:I D:I RESET_B:I SCD:I SCE:I Q:O VDD:B VSS:B
MN3 Db SCD net63 VSS sg13_lv_nmos m=1 w=740.00n l=130.00n ng=1
MN1 Db D net65 VSS sg13_lv_nmos m=1 w=740.00n l=130.00n ng=1
MN0 SCEb SCE VSS VSS sg13_lv_nmos m=1 w=550.00n l=130.00n ng=1
MN4 net63 SCE VSS VSS sg13_lv_nmos m=1 w=740.00n l=130.00n ng=1
MN2 net65 SCEb VSS VSS sg13_lv_nmos m=1 w=740.00n l=130.00n ng=1
MN17 net12 net2 VSS VSS sg13_lv_nmos m=1 w=420.00n l=130.00n ng=1
MN16 net5 clkneg net12 VSS sg13_lv_nmos m=1 w=420.00n l=130.00n ng=1
MN18 net2 net5 net11 VSS sg13_lv_nmos m=1 w=420.00n l=130.00n ng=1
MN19 net11 RESET_B VSS VSS sg13_lv_nmos m=1 w=420.00n l=130.00n ng=1
MN20 Q net2 VSS VSS sg13_lv_nmos m=1 w=740.00n l=130.00n ng=1
MN6 Dbbb Dbb net10 VSS sg13_lv_nmos m=1 w=420.00n l=130.00n ng=1
MN7 net10 RESET_B VSS VSS sg13_lv_nmos m=1 w=420.00n l=130.00n ng=1
MN10 Dbbb clkneg net6 VSS sg13_lv_nmos m=1 w=420.00n l=130.00n ng=1
MN11 net6 clkpos net9 VSS sg13_lv_nmos m=1 w=420.00n l=130.00n ng=1
MN12 net9 net4 net8 VSS sg13_lv_nmos m=1 w=420.00n l=130.00n ng=1
MN13 net8 RESET_B VSS VSS sg13_lv_nmos m=1 w=420.00n l=130.00n ng=1
MN14 net4 net6 VSS VSS sg13_lv_nmos m=1 w=740.00n l=130.00n ng=1
MN8 clkneg CLK VSS VSS sg13_lv_nmos m=1 w=740.00n l=130.00n ng=1
MN15 net4 clkpos net5 VSS sg13_lv_nmos m=1 w=740.00n l=130.00n ng=1
MN9 clkpos clkneg VSS VSS sg13_lv_nmos m=1 w=740.00n l=130.00n ng=1
MN5 Dbb Db VSS VSS sg13_lv_nmos m=1 w=740.00n l=130.00n ng=1
MP1 net64 SCE VDD VDD sg13_lv_pmos m=1 w=1.000u l=130.00n ng=1
MP3 net62 SCEb VDD VDD sg13_lv_pmos m=1 w=1.000u l=130.00n ng=1
MP0 SCEb SCE VDD VDD sg13_lv_pmos m=1 w=840.00n l=130.00n ng=1
MP4 Db SCD net62 VDD sg13_lv_pmos m=1 w=1.000u l=130.00n ng=1
MP2 Db D net64 VDD sg13_lv_pmos m=1 w=1.000u l=130.00n ng=1
MP17 net5 clkpos net3 VDD sg13_lv_pmos m=1 w=420.00n l=130.00n ng=1
MP18 net2 net5 VDD VDD sg13_lv_pmos m=1 w=420.00n l=130.00n ng=1
MP19 net2 RESET_B VDD VDD sg13_lv_pmos m=1 w=420.00n l=130.00n ng=1
MP20 Q net2 VDD VDD sg13_lv_pmos m=1 w=1.12u l=130.00n ng=1
MP10 Dbbb clkpos net6 VDD sg13_lv_pmos m=1 w=420.00n l=130.00n ng=1
MP6 Dbbb RESET_B VDD VDD sg13_lv_pmos m=1 w=420.00n l=130.00n ng=1
MP7 Dbbb Dbb VDD VDD sg13_lv_pmos m=1 w=420.00n l=130.00n ng=1
MP11 net7 net4 VDD VDD sg13_lv_pmos m=1 w=420.00n l=130.00n ng=1
MP12 net6 clkneg net7 VDD sg13_lv_pmos m=1 w=420.00n l=130.00n ng=1
MP13 net6 RESET_B VDD VDD sg13_lv_pmos m=1 w=420.00n l=130.00n ng=1
MP8 clkneg CLK VDD VDD sg13_lv_pmos m=1 w=1.12u l=130.00n ng=1
MP9 clkpos clkneg VDD VDD sg13_lv_pmos m=1 w=1.12u l=130.00n ng=1
MP14 net4 net6 VDD VDD sg13_lv_pmos m=1 w=1.000u l=130.00n ng=1
MP15 net4 clkneg net5 VDD sg13_lv_pmos m=1 w=1.000u l=130.00n ng=1
MP5 Dbb Db VDD VDD sg13_lv_pmos m=1 w=1.12u l=130.00n ng=1
MP16 net3 net2 VDD VDD sg13_lv_pmos m=1 w=420.00n l=130.00n ng=1
.ENDS

************************************************************************
* Library Name: sg13cmos5l_stdcell
* Cell Name:    sg13cmos5l_sdfrbpq_2
* View Name:    schematic
************************************************************************

.SUBCKT sg13cmos5l_sdfrbpq_2 Q CLK D RESET_B SCD SCE VDD VSS
*.PININFO CLK:I D:I RESET_B:I SCD:I SCE:I Q:O VDD:B VSS:B
MN3 Db SCD net63 VSS sg13_lv_nmos m=1 w=740.00n l=130.00n ng=1
MN1 Db D net65 VSS sg13_lv_nmos m=1 w=740.00n l=130.00n ng=1
MN0 SCEb SCE VSS VSS sg13_lv_nmos m=1 w=550.00n l=130.00n ng=1
MN4 net63 SCE VSS VSS sg13_lv_nmos m=1 w=740.00n l=130.00n ng=1
MN2 net65 SCEb VSS VSS sg13_lv_nmos m=1 w=740.00n l=130.00n ng=1
MN5 Dbb Db VSS VSS sg13_lv_nmos m=1 w=740.00n l=130.00n ng=1
MN17 net12 net2 VSS VSS sg13_lv_nmos m=1 w=420.00n l=130.00n ng=1
MN16 net5 clkneg net12 VSS sg13_lv_nmos m=1 w=420.00n l=130.00n ng=1
MN18 net2 net5 net11 VSS sg13_lv_nmos m=1 w=420.00n l=130.00n ng=1
MN19 net11 RESET_B VSS VSS sg13_lv_nmos m=1 w=420.00n l=130.00n ng=1
MN20 Q net2 VSS VSS sg13_lv_nmos m=1 w=1.48u l=130.00n ng=2
MN6 Dbbb Dbb net10 VSS sg13_lv_nmos m=1 w=420.00n l=130.00n ng=1
MN7 net10 RESET_B VSS VSS sg13_lv_nmos m=1 w=420.00n l=130.00n ng=1
MN10 Dbbb clkneg net6 VSS sg13_lv_nmos m=1 w=420.00n l=130.00n ng=1
MN11 net6 clkpos net9 VSS sg13_lv_nmos m=1 w=420.00n l=130.00n ng=1
MN12 net9 net4 net8 VSS sg13_lv_nmos m=1 w=420.00n l=130.00n ng=1
MN13 net8 RESET_B VSS VSS sg13_lv_nmos m=1 w=420.00n l=130.00n ng=1
MN14 net4 net6 VSS VSS sg13_lv_nmos m=1 w=740.00n l=130.00n ng=1
MN8 clkneg CLK VSS VSS sg13_lv_nmos m=1 w=740.00n l=130.00n ng=1
MN15 net4 clkpos net5 VSS sg13_lv_nmos m=1 w=740.00n l=130.00n ng=1
MN9 clkpos clkneg VSS VSS sg13_lv_nmos m=1 w=740.00n l=130.00n ng=1
MP1 net64 SCE VDD VDD sg13_lv_pmos m=1 w=1.000u l=130.00n ng=1
MP3 net62 SCEb VDD VDD sg13_lv_pmos m=1 w=1.000u l=130.00n ng=1
MP0 SCEb SCE VDD VDD sg13_lv_pmos m=1 w=840.00n l=130.00n ng=1
MP4 Db SCD net62 VDD sg13_lv_pmos m=1 w=1.000u l=130.00n ng=1
MP2 Db D net64 VDD sg13_lv_pmos m=1 w=1.000u l=130.00n ng=1
MP5 Dbb Db VDD VDD sg13_lv_pmos m=1 w=1.12u l=130.00n ng=1
MP17 net5 clkpos net3 VDD sg13_lv_pmos m=1 w=420.00n l=130.00n ng=1
MP18 net2 net5 VDD VDD sg13_lv_pmos m=1 w=420.00n l=130.00n ng=1
MP19 net2 RESET_B VDD VDD sg13_lv_pmos m=1 w=420.00n l=130.00n ng=1
MP20 Q net2 VDD VDD sg13_lv_pmos m=1 w=2.24u l=130.00n ng=2
MP10 Dbbb clkpos net6 VDD sg13_lv_pmos m=1 w=420.00n l=130.00n ng=1
MP6 Dbbb RESET_B VDD VDD sg13_lv_pmos m=1 w=420.00n l=130.00n ng=1
MP7 Dbbb Dbb VDD VDD sg13_lv_pmos m=1 w=420.00n l=130.00n ng=1
MP11 net7 net4 VDD VDD sg13_lv_pmos m=1 w=420.00n l=130.00n ng=1
MP12 net6 clkneg net7 VDD sg13_lv_pmos m=1 w=420.00n l=130.00n ng=1
MP13 net6 RESET_B VDD VDD sg13_lv_pmos m=1 w=420.00n l=130.00n ng=1
MP8 clkneg CLK VDD VDD sg13_lv_pmos m=1 w=1.12u l=130.00n ng=1
MP9 clkpos clkneg VDD VDD sg13_lv_pmos m=1 w=1.12u l=130.00n ng=1
MP14 net4 net6 VDD VDD sg13_lv_pmos m=1 w=1.000u l=130.00n ng=1
MP15 net4 clkneg net5 VDD sg13_lv_pmos m=1 w=1.000u l=130.00n ng=1
MP16 net3 net2 VDD VDD sg13_lv_pmos m=1 w=420.00n l=130.00n ng=1
.ENDS

************************************************************************
* Library Name: sg13cmos5l_stdcell
* Cell Name:    sg13cmos5l_sdfrbp_2
* View Name:    schematic
************************************************************************

.SUBCKT sg13cmos5l_sdfrbp_2 Q Q_N CLK D RESET_B SCD SCE VDD VSS
*.PININFO CLK:I D:I RESET_B:I SCD:I SCE:I Q:O Q_N:O VDD:B VSS:B
MN3 Db SCD net63 VSS sg13_lv_nmos m=1 w=740.00n l=130.00n ng=1
MN1 Db D net65 VSS sg13_lv_nmos m=1 w=740.00n l=130.00n ng=1
MN0 SCEb SCE VSS VSS sg13_lv_nmos m=1 w=550.00n l=130.00n ng=1
MN4 net63 SCE VSS VSS sg13_lv_nmos m=1 w=740.00n l=130.00n ng=1
MN2 net65 SCEb VSS VSS sg13_lv_nmos m=1 w=740.00n l=130.00n ng=1
MN5 Dbb Db VSS VSS sg13_lv_nmos m=1 w=740.00n l=130.00n ng=1
MN17 net12 net2 VSS VSS sg13_lv_nmos m=1 w=420.00n l=130.00n ng=1
MN16 net5 clkneg net12 VSS sg13_lv_nmos m=1 w=420.00n l=130.00n ng=1
MN18 net2 net5 net11 VSS sg13_lv_nmos m=1 w=420.00n l=130.00n ng=1
MN19 net11 RESET_B VSS VSS sg13_lv_nmos m=1 w=420.00n l=130.00n ng=1
MN20 Q_N net5 VSS VSS sg13_lv_nmos m=1 w=1.48u l=130.00n ng=2
MN6 Dbbb Dbb net10 VSS sg13_lv_nmos m=1 w=420.00n l=130.00n ng=1
MN7 net10 RESET_B VSS VSS sg13_lv_nmos m=1 w=420.00n l=130.00n ng=1
MN10 Dbbb clkneg net6 VSS sg13_lv_nmos m=1 w=420.00n l=130.00n ng=1
MN11 net6 clkpos net9 VSS sg13_lv_nmos m=1 w=420.00n l=130.00n ng=1
MN12 net9 net4 net8 VSS sg13_lv_nmos m=1 w=420.00n l=130.00n ng=1
MN13 net8 RESET_B VSS VSS sg13_lv_nmos m=1 w=420.00n l=130.00n ng=1
MN14 net4 net6 VSS VSS sg13_lv_nmos m=1 w=740.00n l=130.00n ng=1
MN8 clkneg CLK VSS VSS sg13_lv_nmos m=1 w=740.00n l=130.00n ng=1
MN15 net4 clkpos net5 VSS sg13_lv_nmos m=1 w=740.00n l=130.00n ng=1
MN9 clkpos clkneg VSS VSS sg13_lv_nmos m=1 w=740.00n l=130.00n ng=1
MN22 Q net1 VSS VSS sg13_lv_nmos m=1 w=1.48u l=130.00n ng=2
MN21 net1 net5 VSS VSS sg13_lv_nmos m=1 w=640.00n l=130.00n ng=1
MP1 net64 SCE VDD VDD sg13_lv_pmos m=1 w=1.000u l=130.00n ng=1
MP3 net62 SCEb VDD VDD sg13_lv_pmos m=1 w=1.000u l=130.00n ng=1
MP0 SCEb SCE VDD VDD sg13_lv_pmos m=1 w=840.00n l=130.00n ng=1
MP4 Db SCD net62 VDD sg13_lv_pmos m=1 w=1.000u l=130.00n ng=1
MP2 Db D net64 VDD sg13_lv_pmos m=1 w=1.000u l=130.00n ng=1
MP5 Dbb Db VDD VDD sg13_lv_pmos m=1 w=1.12u l=130.00n ng=1
MP17 net5 clkpos net3 VDD sg13_lv_pmos m=1 w=420.00n l=130.00n ng=1
MP18 net2 net5 VDD VDD sg13_lv_pmos m=1 w=420.00n l=130.00n ng=1
MP19 net2 RESET_B VDD VDD sg13_lv_pmos m=1 w=420.00n l=130.00n ng=1
MP20 Q_N net5 VDD VDD sg13_lv_pmos m=1 w=2.24u l=130.00n ng=2
MP10 Dbbb clkpos net6 VDD sg13_lv_pmos m=1 w=420.00n l=130.00n ng=1
MP6 Dbbb RESET_B VDD VDD sg13_lv_pmos m=1 w=420.00n l=130.00n ng=1
MP7 Dbbb Dbb VDD VDD sg13_lv_pmos m=1 w=420.00n l=130.00n ng=1
MP11 net7 net4 VDD VDD sg13_lv_pmos m=1 w=420.00n l=130.00n ng=1
MP12 net6 clkneg net7 VDD sg13_lv_pmos m=1 w=420.00n l=130.00n ng=1
MP13 net6 RESET_B VDD VDD sg13_lv_pmos m=1 w=420.00n l=130.00n ng=1
MP8 clkneg CLK VDD VDD sg13_lv_pmos m=1 w=1.12u l=130.00n ng=1
MP9 clkpos clkneg VDD VDD sg13_lv_pmos m=1 w=1.12u l=130.00n ng=1
MP14 net4 net6 VDD VDD sg13_lv_pmos m=1 w=1.000u l=130.00n ng=1
MP15 net4 clkneg net5 VDD sg13_lv_pmos m=1 w=1.000u l=130.00n ng=1
MP22 Q net1 VDD VDD sg13_lv_pmos m=1 w=2.24u l=130.00n ng=2
MP16 net3 net2 VDD VDD sg13_lv_pmos m=1 w=420.00n l=130.00n ng=1
MP21 net1 net5 VDD VDD sg13_lv_pmos m=1 w=1.000u l=130.00n ng=1
.ENDS

************************************************************************
* Library Name: sg13cmos5l_stdcell
* Cell Name:    sg13cmos5l_sdfrbp_1
* View Name:    schematic
************************************************************************

.SUBCKT sg13cmos5l_sdfrbp_1 Q Q_N CLK D RESET_B SCD SCE VDD VSS
*.PININFO CLK:I D:I RESET_B:I SCD:I SCE:I Q:O Q_N:O VDD:B VSS:B
MN3 Db SCD net63 VSS sg13_lv_nmos m=1 w=740.00n l=130.00n ng=1
MN1 Db D net65 VSS sg13_lv_nmos m=1 w=740.00n l=130.00n ng=1
MN0 SCEb SCE VSS VSS sg13_lv_nmos m=1 w=550.00n l=130.00n ng=1
MN4 net63 SCE VSS VSS sg13_lv_nmos m=1 w=740.00n l=130.00n ng=1
MN2 net65 SCEb VSS VSS sg13_lv_nmos m=1 w=740.00n l=130.00n ng=1
MN5 net13 Db VSS VSS sg13_lv_nmos m=1 w=740.00n l=130.00n ng=1
MN17 net12 net2 VSS VSS sg13_lv_nmos m=1 w=420.00n l=130.00n ng=1
MN16 net5 clkneg net12 VSS sg13_lv_nmos m=1 w=420.00n l=130.00n ng=1
MN18 net2 net5 net11 VSS sg13_lv_nmos m=1 w=420.00n l=130.00n ng=1
MN19 net11 RESET_B VSS VSS sg13_lv_nmos m=1 w=420.00n l=130.00n ng=1
MN20 Q_N net5 VSS VSS sg13_lv_nmos m=1 w=740.00n l=130.00n ng=1
MN6 Dbb net13 net10 VSS sg13_lv_nmos m=1 w=420.00n l=130.00n ng=1
MN7 net10 RESET_B VSS VSS sg13_lv_nmos m=1 w=420.00n l=130.00n ng=1
MN10 Dbb clkneg net6 VSS sg13_lv_nmos m=1 w=420.00n l=130.00n ng=1
MN11 net6 clkpos net9 VSS sg13_lv_nmos m=1 w=420.00n l=130.00n ng=1
MN12 net9 net4 net8 VSS sg13_lv_nmos m=1 w=420.00n l=130.00n ng=1
MN13 net8 RESET_B VSS VSS sg13_lv_nmos m=1 w=420.00n l=130.00n ng=1
MN14 net4 net6 VSS VSS sg13_lv_nmos m=1 w=740.00n l=130.00n ng=1
MN8 clkneg CLK VSS VSS sg13_lv_nmos m=1 w=740.00n l=130.00n ng=1
MN15 net4 clkpos net5 VSS sg13_lv_nmos m=1 w=740.00n l=130.00n ng=1
MN9 clkpos clkneg VSS VSS sg13_lv_nmos m=1 w=740.00n l=130.00n ng=1
MN22 Q net1 VSS VSS sg13_lv_nmos m=1 w=740.00n l=130.00n ng=1
MN21 net1 net5 VSS VSS sg13_lv_nmos m=1 w=640.00n l=130.00n ng=1
MP1 net64 SCE VDD VDD sg13_lv_pmos m=1 w=1.000u l=130.00n ng=1
MP3 net62 SCEb VDD VDD sg13_lv_pmos m=1 w=1.000u l=130.00n ng=1
MP0 SCEb SCE VDD VDD sg13_lv_pmos m=1 w=840.00n l=130.00n ng=1
MP4 Db SCD net62 VDD sg13_lv_pmos m=1 w=1.000u l=130.00n ng=1
MP2 Db D net64 VDD sg13_lv_pmos m=1 w=1.000u l=130.00n ng=1
MP5 net13 Db VDD VDD sg13_lv_pmos m=1 w=1.12u l=130.00n ng=1
MP17 net5 clkpos net3 VDD sg13_lv_pmos m=1 w=420.00n l=130.00n ng=1
MP18 net2 net5 VDD VDD sg13_lv_pmos m=1 w=420.00n l=130.00n ng=1
MP19 net2 RESET_B VDD VDD sg13_lv_pmos m=1 w=420.00n l=130.00n ng=1
MP20 Q_N net5 VDD VDD sg13_lv_pmos m=1 w=1.12u l=130.00n ng=1
MP10 Dbb clkpos net6 VDD sg13_lv_pmos m=1 w=420.00n l=130.00n ng=1
MP6 Dbb RESET_B VDD VDD sg13_lv_pmos m=1 w=420.00n l=130.00n ng=1
MP7 Dbb net13 VDD VDD sg13_lv_pmos m=1 w=420.00n l=130.00n ng=1
MP11 net7 net4 VDD VDD sg13_lv_pmos m=1 w=420.00n l=130.00n ng=1
MP12 net6 clkneg net7 VDD sg13_lv_pmos m=1 w=420.00n l=130.00n ng=1
MP13 net6 RESET_B VDD VDD sg13_lv_pmos m=1 w=420.00n l=130.00n ng=1
MP8 clkneg CLK VDD VDD sg13_lv_pmos m=1 w=1.12u l=130.00n ng=1
MP9 clkpos clkneg VDD VDD sg13_lv_pmos m=1 w=1.12u l=130.00n ng=1
MP14 net4 net6 VDD VDD sg13_lv_pmos m=1 w=1.000u l=130.00n ng=1
MP15 net4 clkneg net5 VDD sg13_lv_pmos m=1 w=1.000u l=130.00n ng=1
MP22 Q net1 VDD VDD sg13_lv_pmos m=1 w=1.12u l=130.00n ng=1
MP16 net3 net2 VDD VDD sg13_lv_pmos m=1 w=420.00n l=130.00n ng=1
MP21 net1 net5 VDD VDD sg13_lv_pmos m=1 w=1.000u l=130.00n ng=1
.ENDS

************************************************************************
* Library Name: sg13cmos5l_stdcell
* Cell Name:    sg13cmos5l_dfrbpq_2
* View Name:    schematic
************************************************************************

.SUBCKT sg13cmos5l_dfrbpq_2 Q CLK D RESET_B VDD VSS
*.PININFO CLK:I D:I RESET_B:I Q:O VDD:B VSS:B
MN11 net12 net2 VSS VSS sg13_lv_nmos m=1 w=420.00n l=130.00n ng=1
MN10 net5 clkneg net12 VSS sg13_lv_nmos m=1 w=420.00n l=130.00n ng=1
MN12 net2 net5 net11 VSS sg13_lv_nmos m=1 w=420.00n l=130.00n ng=1
MN13 net11 RESET_B VSS VSS sg13_lv_nmos m=1 w=420.00n l=130.00n ng=1
MN0 Db D net10 VSS sg13_lv_nmos m=1 w=420.00n l=130.00n ng=1
MN1 net10 RESET_B VSS VSS sg13_lv_nmos m=1 w=420.00n l=130.00n ng=1
MN4 Db clkneg net6 VSS sg13_lv_nmos m=1 w=420.00n l=130.00n ng=1
MN5 net6 clkpos net9 VSS sg13_lv_nmos m=1 w=420.00n l=130.00n ng=1
MN6 net9 net4 net8 VSS sg13_lv_nmos m=1 w=420.00n l=130.00n ng=1
MN7 net8 RESET_B VSS VSS sg13_lv_nmos m=1 w=420.00n l=130.00n ng=1
MN8 net4 net6 VSS VSS sg13_lv_nmos m=1 w=740.00n l=130.00n ng=1
MN2 clkneg CLK VSS VSS sg13_lv_nmos m=1 w=740.00n l=130.00n ng=1
MN9 net4 clkpos net5 VSS sg13_lv_nmos m=1 w=740.00n l=130.00n ng=1
MN3 clkpos clkneg VSS VSS sg13_lv_nmos m=1 w=740.00n l=130.00n ng=1
MN15 Q net1 VSS VSS sg13_lv_nmos m=1 w=1.48u l=130.00n ng=2
MN14 net1 net5 VSS VSS sg13_lv_nmos m=1 w=640.00n l=130.00n ng=1
MP11 net5 clkpos net3 VDD sg13_lv_pmos m=1 w=420.00n l=130.00n ng=1
MP12 net2 net5 VDD VDD sg13_lv_pmos m=1 w=420.00n l=130.00n ng=1
MP13 net2 RESET_B VDD VDD sg13_lv_pmos m=1 w=420.00n l=130.00n ng=1
MP4 Db clkpos net6 VDD sg13_lv_pmos m=1 w=420.00n l=130.00n ng=1
MP0 Db RESET_B VDD VDD sg13_lv_pmos m=1 w=420.00n l=130.00n ng=1
MP1 Db D VDD VDD sg13_lv_pmos m=1 w=420.00n l=130.00n ng=1
MP5 net7 net4 VDD VDD sg13_lv_pmos m=1 w=420.00n l=130.00n ng=1
MP6 net6 clkneg net7 VDD sg13_lv_pmos m=1 w=420.00n l=130.00n ng=1
MP7 net6 RESET_B VDD VDD sg13_lv_pmos m=1 w=420.00n l=130.00n ng=1
MP2 clkneg CLK VDD VDD sg13_lv_pmos m=1 w=1.12u l=130.00n ng=1
MP3 clkpos clkneg VDD VDD sg13_lv_pmos m=1 w=1.12u l=130.00n ng=1
MP8 net4 net6 VDD VDD sg13_lv_pmos m=1 w=1.000u l=130.00n ng=1
MP9 net4 clkneg net5 VDD sg13_lv_pmos m=1 w=1.000u l=130.00n ng=1
MP15 Q net1 VDD VDD sg13_lv_pmos m=1 w=2.24u l=130.00n ng=2
MP10 net3 net2 VDD VDD sg13_lv_pmos m=1 w=420.00n l=130.00n ng=1
MP14 net1 net5 VDD VDD sg13_lv_pmos m=1 w=1.000u l=130.00n ng=1
.ENDS

************************************************************************
* Library Name: sg13cmos5l_stdcell
* Cell Name:    sg13cmos5l_dfrbpq_1
* View Name:    schematic
************************************************************************

.SUBCKT sg13cmos5l_dfrbpq_1 Q CLK D RESET_B VDD VSS
*.PININFO CLK:I D:I RESET_B:I Q:O VDD:B VSS:B
MN11 net12 net2 VSS VSS sg13_lv_nmos m=1 w=420.00n l=130.00n ng=1
MN10 net5 clkneg net12 VSS sg13_lv_nmos m=1 w=420.00n l=130.00n ng=1
MN12 net2 net5 net11 VSS sg13_lv_nmos m=1 w=420.00n l=130.00n ng=1
MN13 net11 RESET_B VSS VSS sg13_lv_nmos m=1 w=420.00n l=130.00n ng=1
MN0 Db D net10 VSS sg13_lv_nmos m=1 w=420.00n l=130.00n ng=1
MN1 net10 RESET_B VSS VSS sg13_lv_nmos m=1 w=420.00n l=130.00n ng=1
MN4 Db clkneg net6 VSS sg13_lv_nmos m=1 w=420.00n l=130.00n ng=1
MN5 net6 clkpos net9 VSS sg13_lv_nmos m=1 w=420.00n l=130.00n ng=1
MN6 net9 net4 net8 VSS sg13_lv_nmos m=1 w=420.00n l=130.00n ng=1
MN7 net8 RESET_B VSS VSS sg13_lv_nmos m=1 w=420.00n l=130.00n ng=1
MN8 net4 net6 VSS VSS sg13_lv_nmos m=1 w=740.00n l=130.00n ng=1
MN2 clkneg CLK VSS VSS sg13_lv_nmos m=1 w=740.00n l=130.00n ng=1
MN9 net4 clkpos net5 VSS sg13_lv_nmos m=1 w=740.00n l=130.00n ng=1
MN3 clkpos clkneg VSS VSS sg13_lv_nmos m=1 w=740.00n l=130.00n ng=1
MN15 Q net1 VSS VSS sg13_lv_nmos m=1 w=740.00n l=130.00n ng=1
MN14 net1 net5 VSS VSS sg13_lv_nmos m=1 w=740.00n l=130.00n ng=1
MP11 net5 clkpos net3 VDD sg13_lv_pmos m=1 w=420.00n l=130.00n ng=1
MP12 net2 net5 VDD VDD sg13_lv_pmos m=1 w=420.00n l=130.00n ng=1
MP13 net2 RESET_B VDD VDD sg13_lv_pmos m=1 w=420.00n l=130.00n ng=1
MP4 Db clkpos net6 VDD sg13_lv_pmos m=1 w=420.00n l=130.00n ng=1
MP0 Db RESET_B VDD VDD sg13_lv_pmos m=1 w=420.00n l=130.00n ng=1
MP1 Db D VDD VDD sg13_lv_pmos m=1 w=420.00n l=130.00n ng=1
MP5 net7 net4 VDD VDD sg13_lv_pmos m=1 w=420.00n l=130.00n ng=1
MP6 net6 clkneg net7 VDD sg13_lv_pmos m=1 w=420.00n l=130.00n ng=1
MP7 net6 RESET_B VDD VDD sg13_lv_pmos m=1 w=420.00n l=130.00n ng=1
MP2 clkneg CLK VDD VDD sg13_lv_pmos m=1 w=1.12u l=130.00n ng=1
MP3 clkpos clkneg VDD VDD sg13_lv_pmos m=1 w=1.12u l=130.00n ng=1
MP8 net4 net6 VDD VDD sg13_lv_pmos m=1 w=1.000u l=130.00n ng=1
MP9 net4 clkneg net5 VDD sg13_lv_pmos m=1 w=1.000u l=130.00n ng=1
MP15 Q net1 VDD VDD sg13_lv_pmos m=1 w=1.12u l=130.00n ng=1
MP10 net3 net2 VDD VDD sg13_lv_pmos m=1 w=420.00n l=130.00n ng=1
MP14 net1 net5 VDD VDD sg13_lv_pmos m=1 w=1.12u l=130.00n ng=1
.ENDS

************************************************************************
* Library Name: sg13cmos5l_stdcell
* Cell Name:    sg13cmos5l_fill_1
* View Name:    schematic
************************************************************************

.SUBCKT sg13cmos5l_fill_1 VDD VSS
*.PININFO VDD:B VSS:B
.ENDS

************************************************************************
* Library Name: sg13cmos5l_stdcell
* Cell Name:    sg13cmos5l_fill_2
* View Name:    schematic
************************************************************************

.SUBCKT sg13cmos5l_fill_2 VDD VSS
*.PININFO VDD:B VSS:B
.ENDS

************************************************************************
* Library Name: sg13cmos5l_stdcell
* Cell Name:    sg13cmos5l_fill_4
* View Name:    schematic
************************************************************************

.SUBCKT sg13cmos5l_fill_4 VDD VSS
*.PININFO VDD:B VSS:B
.ENDS

************************************************************************
* Library Name: sg13cmos5l_stdcell
* Cell Name:    sg13cmos5l_fill_8
* View Name:    schematic
************************************************************************

.SUBCKT sg13cmos5l_fill_8 VDD VSS
*.PININFO VDD:B VSS:B
.ENDS

* -------------------------------------------------------------
* FINAL POST-P&R SAR FSM
* -------------------------------------------------------------
* CDL Netlist generated by OpenROAD

*.BUSDELIMITER [

.SUBCKT sar_fsm_wrapper bn0 bn1 bn2 bn3 bn4 bn5 bn6 bn7 bn8
+ bn9 bp0 bp1 bp2 bp3 bp4 bp5 bp6 bp7 bp8 bp9 busy clk code0
+ code1 code2 code3 code4 code5 code6 code7 code8 code9 comp
+ comp_clk rst_n sample start valid VDD VSS
X_212_ _210_ _001_ VDD VSS sg13cmos5l_inv_1
X_213_ _050_ net119 VDD VSS sg13cmos5l_inv_1
X_214_ _051_ net161 VDD VSS sg13cmos5l_inv_1
X_215_ _052_ net158 VDD VSS sg13cmos5l_inv_1
X_216_ _053_ net57 VDD VSS sg13cmos5l_inv_1
X_217_ _054_ u_sar.bit_idx\[2\] VDD VSS sg13cmos5l_inv_1
X_218_ _055_ net104 VDD VSS sg13cmos5l_inv_1
X_219_ _056_ net134 VDD VSS sg13cmos5l_inv_1
X_220_ _057_ net141 VDD VSS sg13cmos5l_inv_1
X_221_ _058_ net145 VDD VSS sg13cmos5l_inv_1
X_222_ _059_ net151 VDD VSS sg13cmos5l_inv_1
X_223_ _060_ net135 VDD VSS sg13cmos5l_inv_1
X_224_ _061_ net139 VDD VSS sg13cmos5l_inv_1
X_225_ _062_ net130 VDD VSS sg13cmos5l_inv_1
X_226_ _063_ net108 VDD VSS sg13cmos5l_inv_1
X_227_ _064_ net121 VDD VSS sg13cmos5l_inv_1
X_228_ _065_ net112 VDD VSS sg13cmos5l_inv_1
X_229_ _066_ net129 VDD VSS sg13cmos5l_inv_1
X_230_ _067_ net137 VDD VSS sg13cmos5l_inv_1
X_231_ _068_ net132 VDD VSS sg13cmos5l_inv_1
X_232_ _069_ net123 VDD VSS sg13cmos5l_inv_1
X_233_ _070_ net125 VDD VSS sg13cmos5l_inv_1
X_234_ _071_ net147 VDD VSS sg13cmos5l_inv_1
X_235_ _072_ net127 VDD VSS sg13cmos5l_inv_1
X_236_ _073_ net149 VDD VSS sg13cmos5l_inv_1
X_237_ _074_ net143 VDD VSS sg13cmos5l_inv_1
X_238_ _075_ net110 VDD VSS sg13cmos5l_inv_1
X_239_ _076_ net76 VDD VSS sg13cmos5l_inv_1
X_240_ _077_ net3 VDD VSS sg13cmos5l_inv_1
X_241_ _078_ u_sar.state\[1\] u_sar.state\[0\] VDD VSS sg13cmos5l_nor2b_1
X_242_ _079_ net155 net104 net164 VDD VSS sg13cmos5l_nand3b_1
X_243_ _049_ _079_ VDD VSS sg13cmos5l_inv_1
X_244_ _080_ net104 net155 net164 VDD VSS sg13cmos5l_nand3b_1
X_245_ _211_\[5\] _080_ VDD VSS sg13cmos5l_inv_1
X_246_ _081_ _079_ _080_ VDD VSS sg13cmos5l_and2_1
X_247_ _082_ _079_ _080_ VDD VSS sg13cmos5l_nand2_1
X_248_ _083_ u_sar.state\[0\] u_sar.state\[1\] VDD VSS sg13cmos5l_nor2_1
X_249_ _084_ net168 _083_ VDD VSS sg13cmos5l_and2_1
X_250_ _085_ u_sar.state\[2\] _083_ VDD VSS sg13cmos5l_nand2_1
X_251_ _086_ net57 net59 VDD VSS sg13cmos5l_nor2b_1
X_252_ _087_ net56 net58 VDD VSS sg13cmos5l_nand2b_1
X_253_ _088_ _210_ u_sar.bit_idx\[2\] _087_ VDD VSS sg13cmos5l_nor3_1
X_254_ _089_ net55 net51 VDD VSS sg13cmos5l_nand2_1
X_255_ _090_ u_sar.state\[0\] u_sar.state\[1\] net104 VDD
+ VSS sg13cmos5l_nor3_1
X_256_ _091_ _077_ _090_ VDD VSS sg13cmos5l_and2_1
X_257_ _092_ _077_ _090_ VDD VSS sg13cmos5l_nand2_1
X_258_ _093_ net55 net51 _091_ VDD VSS sg13cmos5l_a21oi_1
X_259_ _094_ net55 net52 _090_ _077_ _082_ VDD VSS sg13cmos5l_a221oi_1
X_260_ _095_ _055_ _078_ VDD VSS sg13cmos5l_and2_1
X_261_ _096_ net174 net104 VDD VSS sg13cmos5l_nor2_1
X_262_ _097_ net155 _096_ VDD VSS sg13cmos5l_nand2_1
X_263_ _098_ u_sar.count\[4\] u_sar.count\[5\] u_sar.count\[6\]
+ u_sar.count\[7\] VDD VSS sg13cmos5l_or4_1
X_264_ _099_ u_sar.count\[0\] u_sar.count\[1\] VDD VSS sg13cmos5l_nand2b_1
X_265_ _100_ u_sar.count\[2\] net114 _098_ _099_ VDD VSS sg13cmos5l_nor4_1
X_266_ _101_ _097_ net115 VDD VSS sg13cmos5l_nor2_1
X_267_ _102_ net117 _095_ net116 VDD VSS sg13cmos5l_nor3_1
X_268_ _002_ net117 _094_ _102_ VDD VSS sg13cmos5l_a21oi_1
X_269_ _103_ net117 net119 VDD VSS sg13cmos5l_xor2_1
X_270_ _104_ _095_ net116 _103_ VDD VSS sg13cmos5l_o21ai_1
X_271_ _003_ _050_ _094_ _104_ VDD VSS sg13cmos5l_o21ai_1
X_272_ _105_ net117 net119 net153 VDD VSS sg13cmos5l_a21oi_1
X_273_ _106_ _094_ net153 VDD VSS sg13cmos5l_nand2b_1
X_274_ _107_ _055_ _078_ _096_ u_sar.state\[1\] VDD VSS sg13cmos5l_a22oi_1
X_275_ _108_ _095_ _097_ VDD VSS sg13cmos5l_nand2b_1
X_276_ _109_ net117 net119 net153 VDD VSS sg13cmos5l_nand3_1
X_277_ _110_ _108_ _109_ VDD VSS sg13cmos5l_nand2_1
X_278_ _004_ _106_ _110_ _105_ VDD VSS sg13cmos5l_a21oi_1
X_279_ _111_ _094_ net114 VDD VSS sg13cmos5l_nor2b_1
X_280_ _112_ net114 _109_ VDD VSS sg13cmos5l_or2_1
X_281_ _113_ net114 _109_ VDD VSS sg13cmos5l_nand2_1
X_282_ _114_ _098_ _112_ _095_ VDD VSS sg13cmos5l_o21ai_1
X_283_ _115_ _112_ _113_ _114_ _097_ VDD VSS sg13cmos5l_a22oi_1
X_284_ _005_ _111_ _115_ VDD VSS sg13cmos5l_or2_1
X_285_ _116_ net117 net119 net153 net114 VDD VSS sg13cmos5l_and4_1
X_286_ _117_ net163 _116_ VDD VSS sg13cmos5l_nor2_1
X_287_ _118_ _094_ net163 VDD VSS sg13cmos5l_nand2b_1
X_288_ _119_ net163 _116_ VDD VSS sg13cmos5l_nand2_1
X_289_ _120_ _108_ _119_ VDD VSS sg13cmos5l_nand2_1
X_290_ _006_ _118_ _120_ _117_ VDD VSS sg13cmos5l_a21oi_1
X_291_ _121_ _094_ net161 VDD VSS sg13cmos5l_nand2b_1
X_292_ _122_ u_sar.count\[4\] net161 _116_ VDD VSS sg13cmos5l_nand3_1
X_293_ _123_ _108_ _122_ VDD VSS sg13cmos5l_nand2_1
X_294_ _007_ _051_ _119_ _121_ _123_ VDD VSS sg13cmos5l_a22oi_1
X_295_ _124_ u_sar.count\[4\] u_sar.count\[5\] net158 _116_
+ VDD VSS sg13cmos5l_nand4_1
X_296_ _125_ _107_ _124_ VDD VSS sg13cmos5l_nand2b_1
X_297_ _126_ _094_ _125_ VDD VSS sg13cmos5l_nand2_1
X_298_ _127_ _107_ _122_ _052_ VDD VSS sg13cmos5l_o21ai_1
X_299_ _008_ _126_ net159 VDD VSS sg13cmos5l_and2_1
X_300_ _128_ net156 _107_ _124_ VDD VSS sg13cmos5l_nor3_1
X_301_ _009_ net156 _126_ _128_ VDD VSS sg13cmos5l_a21o_1
X_302_ _129_ _081_ _092_ _107_ VDD VSS sg13cmos5l_nand3_1
X_303_ _130_ net46 _089_ VDD VSS sg13cmos5l_nand2b_1
X_304_ _010_ net55 _130_ net58 VDD VSS sg13cmos5l_mux2_1
X_305_ _131_ net58 net56 VDD VSS sg13cmos5l_nand2b_1
X_306_ _132_ _087_ _131_ net53 VDD VSS sg13cmos5l_a21oi_1
X_307_ _011_ _132_ net56 _130_ VDD VSS sg13cmos5l_mux2_1
X_308_ _133_ net165 net46 VDD VSS sg13cmos5l_nand2_1
X_309_ _134_ _054_ _086_ VDD VSS sg13cmos5l_xnor2_1
X_310_ _135_ net55 _134_ VDD VSS sg13cmos5l_nand2_1
X_311_ _012_ _130_ _135_ _133_ VDD VSS sg13cmos5l_o21ai_1
X_312_ _136_ _054_ _086_ net167 VDD VSS sg13cmos5l_a21oi_1
X_313_ _137_ net54 net52 VDD VSS sg13cmos5l_nor2_1
X_314_ _138_ net53 net51 _136_ VDD VSS sg13cmos5l_nor3_1
X_315_ _013_ net167 _130_ _138_ VDD VSS sg13cmos5l_a21o_1
X_316_ _139_ _097_ _100_ _092_ VDD VSS sg13cmos5l_o21ai_1
X_317_ _140_ _092_ _114_ VDD VSS sg13cmos5l_and2_1
X_318_ _141_ net55 net52 net105 VDD VSS sg13cmos5l_a21oi_1
X_319_ _014_ _139_ net106 _114_ VDD VSS sg13cmos5l_o21ai_1
X_320_ _142_ net54 net51 _107_ VDD VSS sg13cmos5l_o21ai_1
X_321_ _015_ _140_ _142_ net116 VDD VSS sg13cmos5l_a21o_1
X_322_ _016_ _080_ _089_ VDD VSS sg13cmos5l_nand2_1
X_323_ _143_ net46 _137_ net25 VDD VSS sg13cmos5l_o21ai_1
X_324_ _017_ _076_ _089_ _143_ VDD VSS sg13cmos5l_o21ai_1
X_325_ _144_ net51 _136_ VDD VSS sg13cmos5l_nor2_1
X_326_ _145_ _210_ net58 net56 u_sar.bit_idx\[2\] VDD VSS
+ sg13cmos5l_nor4_1
X_327_ _146_ net54 _145_ VDD VSS sg13cmos5l_nor2_1
X_328_ _147_ net47 _146_ net99 VDD VSS sg13cmos5l_o21ai_1
X_329_ _148_ _076_ net51 VDD VSS sg13cmos5l_nor2_1
X_330_ _149_ net59 _053_ net76 VDD VSS sg13cmos5l_nand3b_1
X_331_ _150_ _134_ _149_ VDD VSS sg13cmos5l_nor2_1
X_332_ _151_ _138_ _150_ VDD VSS sg13cmos5l_nand2_1
X_333_ _018_ net100 _151_ VDD VSS sg13cmos5l_nand2_1
X_334_ _152_ _001_ net58 net56 _054_ VDD VSS sg13cmos5l_and4_1
X_335_ _153_ net54 _152_ VDD VSS sg13cmos5l_nor2_1
X_336_ _154_ net47 _153_ net85 VDD VSS sg13cmos5l_o21ai_1
X_337_ _155_ net59 net57 net76 VDD VSS sg13cmos5l_nand3_1
X_338_ _156_ net53 net51 _134_ _136_ VDD VSS sg13cmos5l_or4_1
X_339_ _019_ _155_ _156_ net86 VDD VSS sg13cmos5l_o21ai_1
X_340_ _157_ _210_ net58 _053_ u_sar.bit_idx\[2\] VDD VSS
+ sg13cmos5l_nor4_1
X_341_ _158_ net54 _157_ VDD VSS sg13cmos5l_nor2_1
X_342_ _159_ net47 _158_ net78 VDD VSS sg13cmos5l_o21ai_1
X_343_ _160_ net59 net57 net76 VDD VSS sg13cmos5l_nand3b_1
X_344_ _020_ _156_ _160_ net79 VDD VSS sg13cmos5l_o21ai_1
X_345_ _161_ _210_ _054_ _087_ VDD VSS sg13cmos5l_nor3_1
X_346_ _162_ net54 _161_ VDD VSS sg13cmos5l_nor2_1
X_347_ _163_ net47 _162_ net102 VDD VSS sg13cmos5l_o21ai_1
X_348_ _164_ net59 _053_ _148_ VDD VSS sg13cmos5l_nand3_1
X_349_ _021_ _156_ _164_ _163_ VDD VSS sg13cmos5l_o21ai_1
X_350_ _165_ _210_ net59 net56 _054_ VDD VSS sg13cmos5l_nor4_1
X_351_ _166_ net53 _165_ VDD VSS sg13cmos5l_nor2_1
X_352_ _167_ net46 _166_ net83 VDD VSS sg13cmos5l_o21ai_1
X_353_ _168_ net55 _134_ _144_ VDD VSS sg13cmos5l_nand3_1
X_354_ _022_ _149_ _168_ _167_ VDD VSS sg13cmos5l_o21ai_1
X_355_ _169_ _001_ net58 net56 u_sar.bit_idx\[2\] VDD VSS
+ sg13cmos5l_and4_1
X_356_ _170_ net53 _169_ VDD VSS sg13cmos5l_nor2_1
X_357_ _171_ net46 _170_ net88 VDD VSS sg13cmos5l_o21ai_1
X_358_ _023_ _155_ _168_ net89 VDD VSS sg13cmos5l_o21ai_1
X_359_ _172_ _210_ net59 _053_ _054_ VDD VSS sg13cmos5l_nor4_1
X_360_ _173_ net53 _172_ VDD VSS sg13cmos5l_nor2_1
X_361_ _174_ net46 _173_ net81 VDD VSS sg13cmos5l_o21ai_1
X_362_ _024_ _160_ _168_ _174_ VDD VSS sg13cmos5l_o21ai_1
X_363_ _175_ _001_ u_sar.bit_idx\[2\] _087_ VDD VSS sg13cmos5l_nor3_1
X_364_ _176_ net53 _175_ VDD VSS sg13cmos5l_nor2_1
X_365_ _177_ net46 _176_ net93 VDD VSS sg13cmos5l_o21ai_1
X_366_ _025_ _135_ _164_ net94 VDD VSS sg13cmos5l_o21ai_1
X_367_ _178_ _001_ net58 net56 u_sar.bit_idx\[2\] VDD VSS
+ sg13cmos5l_nor4_1
X_368_ _179_ net53 _178_ VDD VSS sg13cmos5l_nor2_1
X_369_ _180_ net46 _179_ net96 VDD VSS sg13cmos5l_o21ai_1
X_370_ _181_ net51 _136_ _150_ VDD VSS sg13cmos5l_o21ai_1
X_371_ _026_ net54 _181_ net97 VDD VSS sg13cmos5l_o21ai_1
X_372_ _182_ _081_ _097_ VDD VSS sg13cmos5l_and2_1
X_373_ _183_ _081_ _097_ VDD VSS sg13cmos5l_nand2_1
X_374_ _184_ net1 _085_ net52 VDD VSS sg13cmos5l_or3_1
X_375_ _185_ net52 net55 net1 VDD VSS sg13cmos5l_nand3b_1
X_376_ _186_ net52 net48 net43 VDD VSS sg13cmos5l_nand3_1
X_377_ _187_ _084_ _091_ _183_ VDD VSS sg13cmos5l_nor3_1
X_378_ _027_ _056_ _186_ net39 VDD VSS sg13cmos5l_a21oi_1
X_379_ _188_ net50 _145_ net45 net42 VDD VSS sg13cmos5l_nand4_1
X_380_ _028_ _057_ _188_ net39 VDD VSS sg13cmos5l_a21oi_1
X_381_ _189_ net50 _152_ net45 net42 VDD VSS sg13cmos5l_nand4_1
X_382_ _029_ _058_ _189_ net39 VDD VSS sg13cmos5l_a21oi_1
X_383_ _190_ net50 _157_ net45 net42 VDD VSS sg13cmos5l_nand4_1
X_384_ _030_ _059_ _190_ net39 VDD VSS sg13cmos5l_a21oi_1
X_385_ _191_ net50 _161_ net45 net42 VDD VSS sg13cmos5l_nand4_1
X_386_ _031_ _060_ _191_ net40 VDD VSS sg13cmos5l_a21oi_1
X_387_ _192_ net50 _165_ net45 net42 VDD VSS sg13cmos5l_nand4_1
X_388_ _032_ _061_ _192_ net40 VDD VSS sg13cmos5l_a21oi_1
X_389_ _193_ net50 _169_ net45 net42 VDD VSS sg13cmos5l_nand4_1
X_390_ _033_ _062_ _193_ net40 VDD VSS sg13cmos5l_a21oi_1
X_391_ _194_ _093_ _172_ _182_ net42 VDD VSS sg13cmos5l_nand4_1
X_392_ _034_ _063_ _194_ net39 VDD VSS sg13cmos5l_a21oi_1
X_393_ _195_ net48 _175_ net43 net42 VDD VSS sg13cmos5l_nand4_1
X_394_ _035_ _064_ _195_ net39 VDD VSS sg13cmos5l_a21oi_1
X_395_ _196_ net48 _178_ net43 _184_ VDD VSS sg13cmos5l_nand4_1
X_396_ _036_ _065_ _196_ net39 VDD VSS sg13cmos5l_a21oi_1
X_397_ _037_ _066_ _186_ net39 VDD VSS sg13cmos5l_a21oi_1
X_398_ _197_ net48 _145_ net43 net41 VDD VSS sg13cmos5l_nand4_1
X_399_ _038_ _067_ _197_ net38 VDD VSS sg13cmos5l_a21oi_1
X_400_ _198_ net48 _152_ net43 net41 VDD VSS sg13cmos5l_nand4_1
X_401_ _039_ _068_ _198_ net38 VDD VSS sg13cmos5l_a21oi_1
X_402_ _199_ net48 _157_ net43 net41 VDD VSS sg13cmos5l_nand4_1
X_403_ _040_ _069_ _199_ net40 VDD VSS sg13cmos5l_a21oi_1
X_404_ _200_ net48 _161_ net43 net41 VDD VSS sg13cmos5l_nand4_1
X_405_ _041_ _070_ _200_ net38 VDD VSS sg13cmos5l_a21oi_1
X_406_ _201_ net49 _165_ net44 net41 VDD VSS sg13cmos5l_nand4_1
X_407_ _042_ _071_ _201_ net38 VDD VSS sg13cmos5l_a21oi_1
X_408_ _202_ net49 _169_ net44 net41 VDD VSS sg13cmos5l_nand4_1
X_409_ _043_ _072_ _202_ net38 VDD VSS sg13cmos5l_a21oi_1
X_410_ _203_ net48 _172_ net43 net41 VDD VSS sg13cmos5l_nand4_1
X_411_ _044_ _073_ _203_ net38 VDD VSS sg13cmos5l_a21oi_1
X_412_ _204_ net49 _175_ net44 net41 VDD VSS sg13cmos5l_nand4_1
X_413_ _045_ _074_ _204_ net38 VDD VSS sg13cmos5l_a21oi_1
X_414_ _205_ net49 _178_ net44 _185_ VDD VSS sg13cmos5l_nand4_1
X_415_ _046_ _075_ _205_ net38 VDD VSS sg13cmos5l_a21oi_1
X_416_ _206_ net69 _090_ VDD VSS sg13cmos5l_nand2_1
X_417_ _207_ _080_ _085_ _107_ VDD VSS sg13cmos5l_nand3_1
X_418_ _208_ net24 _207_ VDD VSS sg13cmos5l_nand2_1
X_419_ _047_ net70 _208_ VDD VSS sg13cmos5l_nand2_1
X_420_ _209_ _084_ _183_ net72 VDD VSS sg13cmos5l_o21ai_1
X_421_ _048_ _114_ net70 net73 VDD VSS sg13cmos5l_nand3_1
X_422_ u_sar.count\[0\] clknet_3_1__leaf_clk net118 net64
+ VDD VSS sg13cmos5l_dfrbpq_1
X_423_ u_sar.count\[1\] clknet_3_4__leaf_clk net120 net64
+ VDD VSS sg13cmos5l_dfrbpq_1
X_424_ u_sar.count\[2\] clknet_3_1__leaf_clk net154 net61
+ VDD VSS sg13cmos5l_dfrbpq_1
X_425_ u_sar.count\[3\] clknet_3_4__leaf_clk _005_ net64 VDD
+ VSS sg13cmos5l_dfrbpq_1
X_426_ u_sar.count\[4\] clknet_3_0__leaf_clk _006_ net61 VDD
+ VSS sg13cmos5l_dfrbpq_1
X_427_ u_sar.count\[5\] clknet_3_0__leaf_clk net162 net61
+ VDD VSS sg13cmos5l_dfrbpq_1
X_428_ u_sar.count\[6\] clknet_3_0__leaf_clk net160 net61
+ VDD VSS sg13cmos5l_dfrbpq_1
X_429_ u_sar.count\[7\] clknet_3_0__leaf_clk net157 net61
+ VDD VSS sg13cmos5l_dfrbpq_1
X_430_ _000_ clknet_3_0__leaf_clk _010_ net61 VDD VSS sg13cmos5l_dfrbpq_1
X_431_ u_sar.bit_idx\[1\] clknet_3_1__leaf_clk _011_ net61
+ VDD VSS sg13cmos5l_dfrbpq_1
X_432_ u_sar.bit_idx\[2\] clknet_3_0__leaf_clk net166 net60
+ VDD VSS sg13cmos5l_dfrbpq_1
X_433_ _001_ clknet_3_0__leaf_clk _013_ net60 VDD VSS sg13cmos5l_dfrbpq_1
X_434_ u_sar.state\[0\] clknet_3_4__leaf_clk net107 net64
+ VDD VSS sg13cmos5l_dfrbpq_1
X_435_ u_sar.state\[1\] clknet_3_1__leaf_clk _015_ net61 VDD
+ VSS sg13cmos5l_dfrbpq_1
X_436_ u_sar.state\[2\] clknet_3_1__leaf_clk _016_ net66 VDD
+ VSS sg13cmos5l_dfrbpq_1
X_437_ net25 clknet_3_3__leaf_clk net77 net66 VDD VSS sg13cmos5l_dfrbpq_1
X_438_ net26 clknet_3_3__leaf_clk net101 net66 VDD VSS sg13cmos5l_dfrbpq_1
X_439_ net27 clknet_3_3__leaf_clk net87 net66 VDD VSS sg13cmos5l_dfrbpq_1
X_440_ net28 clknet_3_3__leaf_clk net80 net60 VDD VSS sg13cmos5l_dfrbpq_1
X_441_ net29 clknet_3_2__leaf_clk net103 net67 VDD VSS sg13cmos5l_dfrbpq_1
X_442_ net30 clknet_3_2__leaf_clk net84 net60 VDD VSS sg13cmos5l_dfrbpq_1
X_443_ net31 clknet_3_2__leaf_clk net90 net60 VDD VSS sg13cmos5l_dfrbpq_1
X_444_ net32 clknet_3_2__leaf_clk net82 net60 VDD VSS sg13cmos5l_dfrbpq_1
X_445_ net33 clknet_3_2__leaf_clk net95 net60 VDD VSS sg13cmos5l_dfrbpq_1
X_446_ net34 clknet_3_2__leaf_clk net98 net60 VDD VSS sg13cmos5l_dfrbpq_1
X_447_ net4 clknet_3_7__leaf_clk _027_ net65 VDD VSS sg13cmos5l_dfrbpq_1
X_448_ net5 clknet_3_7__leaf_clk net142 net65 VDD VSS sg13cmos5l_dfrbpq_1
X_449_ net6 clknet_3_7__leaf_clk net146 net66 VDD VSS sg13cmos5l_dfrbpq_1
X_450_ net7 clknet_3_7__leaf_clk net152 net66 VDD VSS sg13cmos5l_dfrbpq_1
X_451_ net8 clknet_3_7__leaf_clk net136 net65 VDD VSS sg13cmos5l_dfrbpq_1
X_452_ net9 clknet_3_7__leaf_clk net140 net65 VDD VSS sg13cmos5l_dfrbpq_1
X_453_ net10 clknet_3_6__leaf_clk net131 net67 VDD VSS sg13cmos5l_dfrbpq_1
X_454_ net11 clknet_3_3__leaf_clk net109 net65 VDD VSS sg13cmos5l_dfrbpq_1
X_455_ net12 clknet_3_6__leaf_clk net122 net65 VDD VSS sg13cmos5l_dfrbpq_1
X_456_ net13 clknet_3_6__leaf_clk net113 net65 VDD VSS sg13cmos5l_dfrbpq_1
X_457_ net14 clknet_3_6__leaf_clk _037_ net65 VDD VSS sg13cmos5l_dfrbpq_1
X_458_ net15 clknet_3_6__leaf_clk net138 net62 VDD VSS sg13cmos5l_dfrbpq_1
X_459_ net16 clknet_3_6__leaf_clk net133 net63 VDD VSS sg13cmos5l_dfrbpq_1
X_460_ net17 clknet_3_5__leaf_clk net124 net63 VDD VSS sg13cmos5l_dfrbpq_1
X_461_ net18 clknet_3_5__leaf_clk net126 net62 VDD VSS sg13cmos5l_dfrbpq_1
X_462_ net19 clknet_3_5__leaf_clk net148 net62 VDD VSS sg13cmos5l_dfrbpq_1
X_463_ net20 clknet_3_5__leaf_clk net128 net62 VDD VSS sg13cmos5l_dfrbpq_1
X_464_ net21 clknet_3_4__leaf_clk net150 net62 VDD VSS sg13cmos5l_dfrbpq_1
X_465_ net22 clknet_3_5__leaf_clk net144 net62 VDD VSS sg13cmos5l_dfrbpq_1
X_466_ net23 clknet_3_5__leaf_clk net111 net62 VDD VSS sg13cmos5l_dfrbpq_1
X_467_ net24 clknet_3_1__leaf_clk net71 net63 VDD VSS sg13cmos5l_dfrbpq_1
X_468_ net37 clknet_3_3__leaf_clk _049_ net66 VDD VSS sg13cmos5l_dfrbpq_1
X_469_ net36 clknet_3_4__leaf_clk net74 net63 VDD VSS sg13cmos5l_dfrbpq_1
X_470_ net35 clknet_3_4__leaf_clk _211_\[5\] net62 VDD VSS
+ sg13cmos5l_dfrbpq_1
Xclkbuf_0_clk clknet_0_clk clk VDD VSS sg13cmos5l_buf_8
Xinput1 net1 net75 VDD VSS sg13cmos5l_buf_1
Xinput2 net2 net91 VDD VSS sg13cmos5l_buf_1
Xinput3 net3 net68 VDD VSS sg13cmos5l_buf_1
Xoutput4 bn0 net134 VDD VSS sg13cmos5l_buf_1
Xoutput5 bn1 net141 VDD VSS sg13cmos5l_buf_1
Xoutput6 bn2 net145 VDD VSS sg13cmos5l_buf_1
Xoutput7 bn3 net151 VDD VSS sg13cmos5l_buf_1
Xoutput8 bn4 net135 VDD VSS sg13cmos5l_buf_1
Xoutput9 bn5 net139 VDD VSS sg13cmos5l_buf_1
Xoutput10 bn6 net130 VDD VSS sg13cmos5l_buf_1
Xoutput11 bn7 net108 VDD VSS sg13cmos5l_buf_1
Xoutput12 bn8 net121 VDD VSS sg13cmos5l_buf_1
Xoutput13 bn9 net112 VDD VSS sg13cmos5l_buf_1
Xoutput14 bp0 net129 VDD VSS sg13cmos5l_buf_1
Xoutput15 bp1 net137 VDD VSS sg13cmos5l_buf_1
Xoutput16 bp2 net132 VDD VSS sg13cmos5l_buf_1
Xoutput17 bp3 net123 VDD VSS sg13cmos5l_buf_1
Xoutput18 bp4 net125 VDD VSS sg13cmos5l_buf_1
Xoutput19 bp5 net147 VDD VSS sg13cmos5l_buf_1
Xoutput20 bp6 net127 VDD VSS sg13cmos5l_buf_1
Xoutput21 bp7 net149 VDD VSS sg13cmos5l_buf_1
Xoutput22 bp8 net143 VDD VSS sg13cmos5l_buf_1
Xoutput23 bp9 net110 VDD VSS sg13cmos5l_buf_1
Xoutput24 busy net172 VDD VSS sg13cmos5l_buf_1
Xoutput25 code0 net171 VDD VSS sg13cmos5l_buf_1
Xoutput26 code1 net99 VDD VSS sg13cmos5l_buf_1
Xoutput27 code2 net85 VDD VSS sg13cmos5l_buf_1
Xoutput28 code3 net78 VDD VSS sg13cmos5l_buf_1
Xoutput29 code4 net102 VDD VSS sg13cmos5l_buf_1
Xoutput30 code5 net83 VDD VSS sg13cmos5l_buf_1
Xoutput31 code6 net88 VDD VSS sg13cmos5l_buf_1
Xoutput32 code7 net81 VDD VSS sg13cmos5l_buf_1
Xoutput33 code8 net93 VDD VSS sg13cmos5l_buf_1
Xoutput34 code9 net96 VDD VSS sg13cmos5l_buf_1
Xoutput35 comp_clk net169 VDD VSS sg13cmos5l_buf_1
Xoutput36 sample net72 VDD VSS sg13cmos5l_buf_1
Xoutput37 valid net170 VDD VSS sg13cmos5l_buf_1
Xfanout38 net38 net40 VDD VSS sg13cmos5l_buf_1
Xfanout39 net39 net40 VDD VSS sg13cmos5l_buf_1
Xfanout40 net40 _187_ VDD VSS sg13cmos5l_buf_1
Xfanout41 net41 _185_ VDD VSS sg13cmos5l_buf_1
Xfanout42 net42 _184_ VDD VSS sg13cmos5l_buf_1
Xfanout43 net43 net45 VDD VSS sg13cmos5l_buf_1
Xfanout44 net44 net45 VDD VSS sg13cmos5l_buf_1
Xfanout45 net45 _182_ VDD VSS sg13cmos5l_buf_1
Xfanout46 net46 _129_ VDD VSS sg13cmos5l_buf_1
Xfanout47 net47 _129_ VDD VSS sg13cmos5l_buf_1
Xfanout48 net48 net50 VDD VSS sg13cmos5l_buf_1
Xfanout49 net49 net50 VDD VSS sg13cmos5l_buf_1
Xfanout50 net50 _093_ VDD VSS sg13cmos5l_buf_1
Xfanout51 net51 _088_ VDD VSS sg13cmos5l_buf_1
Xfanout52 net52 _088_ VDD VSS sg13cmos5l_buf_1
Xfanout53 net53 net54 VDD VSS sg13cmos5l_buf_1
Xfanout54 net54 _085_ VDD VSS sg13cmos5l_buf_1
Xfanout55 net55 _084_ VDD VSS sg13cmos5l_buf_1
Xfanout56 net56 net173 VDD VSS sg13cmos5l_buf_1
Xfanout57 net57 u_sar.bit_idx\[1\] VDD VSS sg13cmos5l_buf_1
Xfanout58 net58 net59 VDD VSS sg13cmos5l_buf_1
Xfanout59 net59 _000_ VDD VSS sg13cmos5l_buf_1
Xfanout60 net60 net67 VDD VSS sg13cmos5l_buf_1
Xfanout61 net61 net67 VDD VSS sg13cmos5l_buf_1
Xfanout62 net62 net64 VDD VSS sg13cmos5l_buf_1
Xfanout63 net63 net64 VDD VSS sg13cmos5l_buf_1
Xfanout64 net64 net67 VDD VSS sg13cmos5l_buf_1
Xfanout65 net65 net66 VDD VSS sg13cmos5l_buf_1
Xfanout66 net66 net67 VDD VSS sg13cmos5l_buf_1
Xfanout67 net67 net92 VDD VSS sg13cmos5l_buf_1
Xclkbuf_3_0__f_clk clknet_3_0__leaf_clk clknet_0_clk VDD VSS
+ sg13cmos5l_buf_8
Xclkbuf_3_1__f_clk clknet_3_1__leaf_clk clknet_0_clk VDD VSS
+ sg13cmos5l_buf_8
Xclkbuf_3_2__f_clk clknet_3_2__leaf_clk clknet_0_clk VDD VSS
+ sg13cmos5l_buf_8
Xclkbuf_3_3__f_clk clknet_3_3__leaf_clk clknet_0_clk VDD VSS
+ sg13cmos5l_buf_8
Xclkbuf_3_4__f_clk clknet_3_4__leaf_clk clknet_0_clk VDD VSS
+ sg13cmos5l_buf_8
Xclkbuf_3_5__f_clk clknet_3_5__leaf_clk clknet_0_clk VDD VSS
+ sg13cmos5l_buf_8
Xclkbuf_3_6__f_clk clknet_3_6__leaf_clk clknet_0_clk VDD VSS
+ sg13cmos5l_buf_8
Xclkbuf_3_7__f_clk clknet_3_7__leaf_clk clknet_0_clk VDD VSS
+ sg13cmos5l_buf_8
Xclkload0 _unconnected_0 clknet_3_1__leaf_clk VDD VSS sg13cmos5l_inv_1
Xclkload1 _unconnected_1 clknet_3_2__leaf_clk VDD VSS sg13cmos5l_inv_1
Xclkload2 _unconnected_2 clknet_3_3__leaf_clk VDD VSS sg13cmos5l_inv_1
Xclkload3 _unconnected_3 clknet_3_4__leaf_clk VDD VSS sg13cmos5l_inv_1
Xclkload4 _unconnected_4 clknet_3_5__leaf_clk VDD VSS sg13cmos5l_inv_1
Xclkload5 _unconnected_5 clknet_3_6__leaf_clk VDD VSS sg13cmos5l_inv_1
Xclkload6 _unconnected_6 clknet_3_7__leaf_clk VDD VSS sg13cmos5l_inv_1
Xhold68 net68 start VDD VSS sg13cmos5l_dlygate4sd3_1
Xhold69 net69 net3 VDD VSS sg13cmos5l_dlygate4sd3_1
Xhold70 net70 _206_ VDD VSS sg13cmos5l_dlygate4sd3_1
Xhold71 net71 _047_ VDD VSS sg13cmos5l_dlygate4sd3_1
Xhold72 net72 net36 VDD VSS sg13cmos5l_dlygate4sd3_1
Xhold73 net73 _209_ VDD VSS sg13cmos5l_dlygate4sd3_1
Xhold74 net74 _048_ VDD VSS sg13cmos5l_dlygate4sd3_1
Xhold75 net75 comp VDD VSS sg13cmos5l_dlygate4sd3_1
Xhold76 net76 net1 VDD VSS sg13cmos5l_dlygate4sd3_1
Xhold77 net77 _017_ VDD VSS sg13cmos5l_dlygate4sd3_1
Xhold78 net78 net28 VDD VSS sg13cmos5l_dlygate4sd3_1
Xhold79 net79 _159_ VDD VSS sg13cmos5l_dlygate4sd3_1
Xhold80 net80 _020_ VDD VSS sg13cmos5l_dlygate4sd3_1
Xhold81 net81 net32 VDD VSS sg13cmos5l_dlygate4sd3_1
Xhold82 net82 _024_ VDD VSS sg13cmos5l_dlygate4sd3_1
Xhold83 net83 net30 VDD VSS sg13cmos5l_dlygate4sd3_1
Xhold84 net84 _022_ VDD VSS sg13cmos5l_dlygate4sd3_1
Xhold85 net85 net27 VDD VSS sg13cmos5l_dlygate4sd3_1
Xhold86 net86 _154_ VDD VSS sg13cmos5l_dlygate4sd3_1
Xhold87 net87 _019_ VDD VSS sg13cmos5l_dlygate4sd3_1
Xhold88 net88 net31 VDD VSS sg13cmos5l_dlygate4sd3_1
Xhold89 net89 _171_ VDD VSS sg13cmos5l_dlygate4sd3_1
Xhold90 net90 _023_ VDD VSS sg13cmos5l_dlygate4sd3_1
Xhold91 net91 rst_n VDD VSS sg13cmos5l_dlygate4sd3_1
Xhold92 net92 net2 VDD VSS sg13cmos5l_dlygate4sd3_1
Xhold93 net93 net33 VDD VSS sg13cmos5l_dlygate4sd3_1
Xhold94 net94 _177_ VDD VSS sg13cmos5l_dlygate4sd3_1
Xhold95 net95 _025_ VDD VSS sg13cmos5l_dlygate4sd3_1
Xhold96 net96 net34 VDD VSS sg13cmos5l_dlygate4sd3_1
Xhold97 net97 _180_ VDD VSS sg13cmos5l_dlygate4sd3_1
Xhold98 net98 _026_ VDD VSS sg13cmos5l_dlygate4sd3_1
Xhold99 net99 net26 VDD VSS sg13cmos5l_dlygate4sd3_1
Xhold100 net100 _147_ VDD VSS sg13cmos5l_dlygate4sd3_1
Xhold101 net101 _018_ VDD VSS sg13cmos5l_dlygate4sd3_1
Xhold102 net102 net29 VDD VSS sg13cmos5l_dlygate4sd3_1
Xhold103 net103 _021_ VDD VSS sg13cmos5l_dlygate4sd3_1
Xhold104 net104 u_sar.state\[2\] VDD VSS sg13cmos5l_dlygate4sd3_1
Xhold105 net105 _096_ VDD VSS sg13cmos5l_dlygate4sd3_1
Xhold106 net106 _141_ VDD VSS sg13cmos5l_dlygate4sd3_1
Xhold107 net107 _014_ VDD VSS sg13cmos5l_dlygate4sd3_1
Xhold108 net108 net11 VDD VSS sg13cmos5l_dlygate4sd3_1
Xhold109 net109 _034_ VDD VSS sg13cmos5l_dlygate4sd3_1
Xhold110 net110 net23 VDD VSS sg13cmos5l_dlygate4sd3_1
Xhold111 net111 _046_ VDD VSS sg13cmos5l_dlygate4sd3_1
Xhold112 net112 net13 VDD VSS sg13cmos5l_dlygate4sd3_1
Xhold113 net113 _036_ VDD VSS sg13cmos5l_dlygate4sd3_1
Xhold114 net114 u_sar.count\[3\] VDD VSS sg13cmos5l_dlygate4sd3_1
Xhold115 net115 _100_ VDD VSS sg13cmos5l_dlygate4sd3_1
Xhold116 net116 _101_ VDD VSS sg13cmos5l_dlygate4sd3_1
Xhold117 net117 u_sar.count\[0\] VDD VSS sg13cmos5l_dlygate4sd3_1
Xhold118 net118 _002_ VDD VSS sg13cmos5l_dlygate4sd3_1
Xhold119 net119 u_sar.count\[1\] VDD VSS sg13cmos5l_dlygate4sd3_1
Xhold120 net120 _003_ VDD VSS sg13cmos5l_dlygate4sd3_1
Xhold121 net121 net12 VDD VSS sg13cmos5l_dlygate4sd3_1
Xhold122 net122 _035_ VDD VSS sg13cmos5l_dlygate4sd3_1
Xhold123 net123 net17 VDD VSS sg13cmos5l_dlygate4sd3_1
Xhold124 net124 _040_ VDD VSS sg13cmos5l_dlygate4sd3_1
Xhold125 net125 net18 VDD VSS sg13cmos5l_dlygate4sd3_1
Xhold126 net126 _041_ VDD VSS sg13cmos5l_dlygate4sd3_1
Xhold127 net127 net20 VDD VSS sg13cmos5l_dlygate4sd3_1
Xhold128 net128 _043_ VDD VSS sg13cmos5l_dlygate4sd3_1
Xhold129 net129 net14 VDD VSS sg13cmos5l_dlygate4sd3_1
Xhold130 net130 net10 VDD VSS sg13cmos5l_dlygate4sd3_1
Xhold131 net131 _033_ VDD VSS sg13cmos5l_dlygate4sd3_1
Xhold132 net132 net16 VDD VSS sg13cmos5l_dlygate4sd3_1
Xhold133 net133 _039_ VDD VSS sg13cmos5l_dlygate4sd3_1
Xhold134 net134 net4 VDD VSS sg13cmos5l_dlygate4sd3_1
Xhold135 net135 net8 VDD VSS sg13cmos5l_dlygate4sd3_1
Xhold136 net136 _031_ VDD VSS sg13cmos5l_dlygate4sd3_1
Xhold137 net137 net15 VDD VSS sg13cmos5l_dlygate4sd3_1
Xhold138 net138 _038_ VDD VSS sg13cmos5l_dlygate4sd3_1
Xhold139 net139 net9 VDD VSS sg13cmos5l_dlygate4sd3_1
Xhold140 net140 _032_ VDD VSS sg13cmos5l_dlygate4sd3_1
Xhold141 net141 net5 VDD VSS sg13cmos5l_dlygate4sd3_1
Xhold142 net142 _028_ VDD VSS sg13cmos5l_dlygate4sd3_1
Xhold143 net143 net22 VDD VSS sg13cmos5l_dlygate4sd3_1
Xhold144 net144 _045_ VDD VSS sg13cmos5l_dlygate4sd3_1
Xhold145 net145 net6 VDD VSS sg13cmos5l_dlygate4sd3_1
Xhold146 net146 _029_ VDD VSS sg13cmos5l_dlygate4sd3_1
Xhold147 net147 net19 VDD VSS sg13cmos5l_dlygate4sd3_1
Xhold148 net148 _042_ VDD VSS sg13cmos5l_dlygate4sd3_1
Xhold149 net149 net21 VDD VSS sg13cmos5l_dlygate4sd3_1
Xhold150 net150 _044_ VDD VSS sg13cmos5l_dlygate4sd3_1
Xhold151 net151 net7 VDD VSS sg13cmos5l_dlygate4sd3_1
Xhold152 net152 _030_ VDD VSS sg13cmos5l_dlygate4sd3_1
Xhold153 net153 u_sar.count\[2\] VDD VSS sg13cmos5l_dlygate4sd3_1
Xhold154 net154 _004_ VDD VSS sg13cmos5l_dlygate4sd3_1
Xhold155 net155 u_sar.state\[1\] VDD VSS sg13cmos5l_dlygate4sd3_1
Xhold156 net156 u_sar.count\[7\] VDD VSS sg13cmos5l_dlygate4sd3_1
Xhold157 net157 _009_ VDD VSS sg13cmos5l_dlygate4sd3_1
Xhold158 net158 u_sar.count\[6\] VDD VSS sg13cmos5l_dlygate4sd3_1
Xhold159 net159 _127_ VDD VSS sg13cmos5l_dlygate4sd3_1
Xhold160 net160 _008_ VDD VSS sg13cmos5l_dlygate4sd3_1
Xhold161 net161 u_sar.count\[5\] VDD VSS sg13cmos5l_dlygate4sd3_1
Xhold162 net162 _007_ VDD VSS sg13cmos5l_dlygate4sd3_1
Xhold163 net163 u_sar.count\[4\] VDD VSS sg13cmos5l_dlygate4sd3_1
Xhold164 net164 u_sar.state\[0\] VDD VSS sg13cmos5l_dlygate4sd3_1
Xhold165 net165 u_sar.bit_idx\[2\] VDD VSS sg13cmos5l_dlygate4sd3_1
Xhold166 net166 _012_ VDD VSS sg13cmos5l_dlygate4sd3_1
Xhold167 net167 _001_ VDD VSS sg13cmos5l_dlygate4sd3_1
Xhold168 net168 u_sar.state\[2\] VDD VSS sg13cmos5l_dlygate4sd3_1
Xhold169 net169 net35 VDD VSS sg13cmos5l_dlygate4sd3_1
Xhold170 net170 net37 VDD VSS sg13cmos5l_dlygate4sd3_1
Xhold171 net171 net25 VDD VSS sg13cmos5l_dlygate4sd3_1
Xhold172 net172 net24 VDD VSS sg13cmos5l_dlygate4sd3_1
Xhold173 net173 u_sar.bit_idx\[1\] VDD VSS sg13cmos5l_dlygate4sd3_1
Xhold174 net174 u_sar.state\[0\] VDD VSS sg13cmos5l_dlygate4sd3_1
XFILLER_0_0 VDD VSS sg13cmos5l_decap_8
XFILLER_0_7 VDD VSS sg13cmos5l_decap_8
XFILLER_0_14 VDD VSS sg13cmos5l_decap_8
XFILLER_0_21 VDD VSS sg13cmos5l_decap_8
XFILLER_0_28 VDD VSS sg13cmos5l_decap_8
XFILLER_0_35 VDD VSS sg13cmos5l_decap_8
XFILLER_0_42 VDD VSS sg13cmos5l_decap_8
XFILLER_0_49 VDD VSS sg13cmos5l_decap_8
XFILLER_0_56 VDD VSS sg13cmos5l_decap_8
XFILLER_0_63 VDD VSS sg13cmos5l_decap_8
XFILLER_0_70 VDD VSS sg13cmos5l_decap_8
XFILLER_0_77 VDD VSS sg13cmos5l_decap_8
XFILLER_0_84 VDD VSS sg13cmos5l_decap_8
XFILLER_0_91 VDD VSS sg13cmos5l_decap_8
XFILLER_0_98 VDD VSS sg13cmos5l_decap_8
XFILLER_0_105 VDD VSS sg13cmos5l_decap_8
XFILLER_0_112 VDD VSS sg13cmos5l_decap_8
XFILLER_0_119 VDD VSS sg13cmos5l_decap_8
XFILLER_0_126 VDD VSS sg13cmos5l_decap_8
XFILLER_0_133 VDD VSS sg13cmos5l_decap_8
XFILLER_0_140 VDD VSS sg13cmos5l_decap_8
XFILLER_0_147 VDD VSS sg13cmos5l_decap_8
XFILLER_0_154 VDD VSS sg13cmos5l_decap_8
XFILLER_0_161 VDD VSS sg13cmos5l_decap_8
XFILLER_0_168 VDD VSS sg13cmos5l_decap_8
XFILLER_0_175 VDD VSS sg13cmos5l_decap_8
XFILLER_1_0 VDD VSS sg13cmos5l_decap_8
XFILLER_1_7 VDD VSS sg13cmos5l_decap_8
XFILLER_1_14 VDD VSS sg13cmos5l_decap_8
XFILLER_1_21 VDD VSS sg13cmos5l_decap_8
XFILLER_1_28 VDD VSS sg13cmos5l_decap_8
XFILLER_1_35 VDD VSS sg13cmos5l_decap_8
XFILLER_1_42 VDD VSS sg13cmos5l_decap_8
XFILLER_1_49 VDD VSS sg13cmos5l_decap_8
XFILLER_1_56 VDD VSS sg13cmos5l_decap_8
XFILLER_1_63 VDD VSS sg13cmos5l_decap_8
XFILLER_1_70 VDD VSS sg13cmos5l_decap_8
XFILLER_1_77 VDD VSS sg13cmos5l_decap_8
XFILLER_1_84 VDD VSS sg13cmos5l_decap_8
XFILLER_1_91 VDD VSS sg13cmos5l_decap_8
XFILLER_1_98 VDD VSS sg13cmos5l_decap_8
XFILLER_1_105 VDD VSS sg13cmos5l_decap_8
XFILLER_1_112 VDD VSS sg13cmos5l_decap_8
XFILLER_1_119 VDD VSS sg13cmos5l_decap_8
XFILLER_1_126 VDD VSS sg13cmos5l_decap_8
XFILLER_1_133 VDD VSS sg13cmos5l_decap_8
XFILLER_1_140 VDD VSS sg13cmos5l_decap_8
XFILLER_1_147 VDD VSS sg13cmos5l_decap_8
XFILLER_1_154 VDD VSS sg13cmos5l_decap_8
XFILLER_1_161 VDD VSS sg13cmos5l_decap_8
XFILLER_1_168 VDD VSS sg13cmos5l_decap_4
XFILLER_1_172 VDD VSS sg13cmos5l_fill_2
XFILLER_1_208 VDD VSS sg13cmos5l_fill_1
XFILLER_2_0 VDD VSS sg13cmos5l_decap_8
XFILLER_2_7 VDD VSS sg13cmos5l_decap_8
XFILLER_2_14 VDD VSS sg13cmos5l_decap_8
XFILLER_2_21 VDD VSS sg13cmos5l_decap_8
XFILLER_2_28 VDD VSS sg13cmos5l_decap_8
XFILLER_2_35 VDD VSS sg13cmos5l_decap_8
XFILLER_2_42 VDD VSS sg13cmos5l_decap_8
XFILLER_2_49 VDD VSS sg13cmos5l_decap_8
XFILLER_2_56 VDD VSS sg13cmos5l_decap_8
XFILLER_2_63 VDD VSS sg13cmos5l_decap_8
XFILLER_2_70 VDD VSS sg13cmos5l_decap_4
XFILLER_2_74 VDD VSS sg13cmos5l_fill_2
XFILLER_2_80 VDD VSS sg13cmos5l_decap_8
XFILLER_2_87 VDD VSS sg13cmos5l_decap_8
XFILLER_2_94 VDD VSS sg13cmos5l_decap_4
XFILLER_2_98 VDD VSS sg13cmos5l_fill_1
XFILLER_2_109 VDD VSS sg13cmos5l_decap_8
XFILLER_2_116 VDD VSS sg13cmos5l_decap_4
XFILLER_2_120 VDD VSS sg13cmos5l_fill_2
XFILLER_2_127 VDD VSS sg13cmos5l_decap_8
XFILLER_2_134 VDD VSS sg13cmos5l_decap_8
XFILLER_2_141 VDD VSS sg13cmos5l_decap_8
XFILLER_2_148 VDD VSS sg13cmos5l_decap_8
XFILLER_2_155 VDD VSS sg13cmos5l_decap_8
XFILLER_2_162 VDD VSS sg13cmos5l_decap_4
XFILLER_2_189 VDD VSS sg13cmos5l_fill_1
XFILLER_3_0 VDD VSS sg13cmos5l_decap_8
XFILLER_3_7 VDD VSS sg13cmos5l_decap_8
XFILLER_3_14 VDD VSS sg13cmos5l_decap_8
XFILLER_3_21 VDD VSS sg13cmos5l_decap_8
XFILLER_3_28 VDD VSS sg13cmos5l_decap_8
XFILLER_3_35 VDD VSS sg13cmos5l_decap_8
XFILLER_3_42 VDD VSS sg13cmos5l_decap_8
XFILLER_3_49 VDD VSS sg13cmos5l_decap_8
XFILLER_3_56 VDD VSS sg13cmos5l_decap_8
XFILLER_3_63 VDD VSS sg13cmos5l_decap_8
XFILLER_3_70 VDD VSS sg13cmos5l_fill_1
XFILLER_3_76 VDD VSS sg13cmos5l_fill_1
XFILLER_3_109 VDD VSS sg13cmos5l_fill_2
XFILLER_3_111 VDD VSS sg13cmos5l_fill_1
XFILLER_3_144 VDD VSS sg13cmos5l_fill_2
XFILLER_3_149 VDD VSS sg13cmos5l_fill_2
XFILLER_3_151 VDD VSS sg13cmos5l_fill_1
XFILLER_4_0 VDD VSS sg13cmos5l_decap_8
XFILLER_4_7 VDD VSS sg13cmos5l_decap_8
XFILLER_4_14 VDD VSS sg13cmos5l_decap_8
XFILLER_4_21 VDD VSS sg13cmos5l_decap_8
XFILLER_4_28 VDD VSS sg13cmos5l_decap_8
XFILLER_4_35 VDD VSS sg13cmos5l_decap_8
XFILLER_4_42 VDD VSS sg13cmos5l_decap_8
XFILLER_4_49 VDD VSS sg13cmos5l_decap_4
XFILLER_4_80 VDD VSS sg13cmos5l_fill_2
XFILLER_4_96 VDD VSS sg13cmos5l_fill_2
XFILLER_4_98 VDD VSS sg13cmos5l_fill_1
XFILLER_4_113 VDD VSS sg13cmos5l_fill_2
XFILLER_4_115 VDD VSS sg13cmos5l_fill_1
XFILLER_4_125 VDD VSS sg13cmos5l_decap_4
XFILLER_5_0 VDD VSS sg13cmos5l_decap_8
XFILLER_5_7 VDD VSS sg13cmos5l_decap_8
XFILLER_5_14 VDD VSS sg13cmos5l_decap_8
XFILLER_5_21 VDD VSS sg13cmos5l_decap_8
XFILLER_5_28 VDD VSS sg13cmos5l_decap_8
XFILLER_5_35 VDD VSS sg13cmos5l_decap_8
XFILLER_5_42 VDD VSS sg13cmos5l_decap_8
XFILLER_5_49 VDD VSS sg13cmos5l_decap_4
XFILLER_5_66 VDD VSS sg13cmos5l_fill_1
XFILLER_5_88 VDD VSS sg13cmos5l_fill_2
XFILLER_5_108 VDD VSS sg13cmos5l_decap_4
XFILLER_5_165 VDD VSS sg13cmos5l_fill_1
XFILLER_5_198 VDD VSS sg13cmos5l_fill_1
XFILLER_6_0 VDD VSS sg13cmos5l_decap_8
XFILLER_6_7 VDD VSS sg13cmos5l_decap_8
XFILLER_6_14 VDD VSS sg13cmos5l_decap_8
XFILLER_6_21 VDD VSS sg13cmos5l_decap_8
XFILLER_6_28 VDD VSS sg13cmos5l_decap_8
XFILLER_6_35 VDD VSS sg13cmos5l_decap_4
XFILLER_6_39 VDD VSS sg13cmos5l_fill_2
XFILLER_6_92 VDD VSS sg13cmos5l_decap_4
XFILLER_6_100 VDD VSS sg13cmos5l_fill_1
XFILLER_6_135 VDD VSS sg13cmos5l_fill_1
XFILLER_6_215 VDD VSS sg13cmos5l_fill_2
XFILLER_7_4 VDD VSS sg13cmos5l_decap_8
XFILLER_7_11 VDD VSS sg13cmos5l_decap_8
XFILLER_7_18 VDD VSS sg13cmos5l_decap_8
XFILLER_7_25 VDD VSS sg13cmos5l_decap_8
XFILLER_7_32 VDD VSS sg13cmos5l_decap_8
XFILLER_7_39 VDD VSS sg13cmos5l_decap_8
XFILLER_7_46 VDD VSS sg13cmos5l_fill_1
XFILLER_7_92 VDD VSS sg13cmos5l_decap_8
XFILLER_7_99 VDD VSS sg13cmos5l_decap_8
XFILLER_7_106 VDD VSS sg13cmos5l_decap_4
XFILLER_7_118 VDD VSS sg13cmos5l_fill_1
XFILLER_7_192 VDD VSS sg13cmos5l_fill_2
XFILLER_8_9 VDD VSS sg13cmos5l_decap_8
XFILLER_8_16 VDD VSS sg13cmos5l_decap_8
XFILLER_8_23 VDD VSS sg13cmos5l_decap_8
XFILLER_8_30 VDD VSS sg13cmos5l_decap_8
XFILLER_8_37 VDD VSS sg13cmos5l_fill_1
XFILLER_8_106 VDD VSS sg13cmos5l_fill_1
XFILLER_8_115 VDD VSS sg13cmos5l_fill_1
XFILLER_8_146 VDD VSS sg13cmos5l_fill_2
XFILLER_9_0 VDD VSS sg13cmos5l_decap_8
XFILLER_9_7 VDD VSS sg13cmos5l_decap_8
XFILLER_9_14 VDD VSS sg13cmos5l_decap_8
XFILLER_9_21 VDD VSS sg13cmos5l_fill_2
XFILLER_9_23 VDD VSS sg13cmos5l_fill_1
XFILLER_9_33 VDD VSS sg13cmos5l_decap_8
XFILLER_9_48 VDD VSS sg13cmos5l_decap_8
XFILLER_9_55 VDD VSS sg13cmos5l_decap_8
XFILLER_9_62 VDD VSS sg13cmos5l_fill_2
XFILLER_9_91 VDD VSS sg13cmos5l_fill_2
XFILLER_9_93 VDD VSS sg13cmos5l_fill_1
XFILLER_9_121 VDD VSS sg13cmos5l_fill_2
XFILLER_9_159 VDD VSS sg13cmos5l_fill_1
XFILLER_9_178 VDD VSS sg13cmos5l_fill_1
XFILLER_9_197 VDD VSS sg13cmos5l_fill_2
XFILLER_10_0 VDD VSS sg13cmos5l_decap_8
XFILLER_10_7 VDD VSS sg13cmos5l_decap_8
XFILLER_10_14 VDD VSS sg13cmos5l_decap_8
XFILLER_10_21 VDD VSS sg13cmos5l_decap_8
XFILLER_10_28 VDD VSS sg13cmos5l_decap_8
XFILLER_10_35 VDD VSS sg13cmos5l_decap_8
XFILLER_10_42 VDD VSS sg13cmos5l_decap_8
XFILLER_10_49 VDD VSS sg13cmos5l_decap_4
XFILLER_10_53 VDD VSS sg13cmos5l_fill_1
XFILLER_10_81 VDD VSS sg13cmos5l_decap_8
XFILLER_10_88 VDD VSS sg13cmos5l_decap_8
XFILLER_10_95 VDD VSS sg13cmos5l_fill_1
XFILLER_10_109 VDD VSS sg13cmos5l_fill_1
XFILLER_10_135 VDD VSS sg13cmos5l_fill_1
XFILLER_10_224 VDD VSS sg13cmos5l_fill_2
XFILLER_11_0 VDD VSS sg13cmos5l_decap_8
XFILLER_11_7 VDD VSS sg13cmos5l_decap_8
XFILLER_11_14 VDD VSS sg13cmos5l_decap_8
XFILLER_11_21 VDD VSS sg13cmos5l_decap_8
XFILLER_11_28 VDD VSS sg13cmos5l_decap_8
XFILLER_11_35 VDD VSS sg13cmos5l_decap_8
XFILLER_11_42 VDD VSS sg13cmos5l_decap_8
XFILLER_11_49 VDD VSS sg13cmos5l_decap_4
XFILLER_11_53 VDD VSS sg13cmos5l_fill_2
XFILLER_11_82 VDD VSS sg13cmos5l_fill_1
XFILLER_11_101 VDD VSS sg13cmos5l_decap_8
XFILLER_11_108 VDD VSS sg13cmos5l_fill_1
XFILLER_11_146 VDD VSS sg13cmos5l_fill_2
XFILLER_11_153 VDD VSS sg13cmos5l_fill_1
XFILLER_12_0 VDD VSS sg13cmos5l_decap_8
XFILLER_12_7 VDD VSS sg13cmos5l_decap_8
XFILLER_12_14 VDD VSS sg13cmos5l_decap_8
XFILLER_12_21 VDD VSS sg13cmos5l_decap_8
XFILLER_12_28 VDD VSS sg13cmos5l_decap_8
XFILLER_12_35 VDD VSS sg13cmos5l_decap_8
XFILLER_12_42 VDD VSS sg13cmos5l_decap_8
XFILLER_12_49 VDD VSS sg13cmos5l_decap_8
XFILLER_12_56 VDD VSS sg13cmos5l_decap_8
XFILLER_12_73 VDD VSS sg13cmos5l_fill_2
XFILLER_12_112 VDD VSS sg13cmos5l_decap_8
XFILLER_12_119 VDD VSS sg13cmos5l_decap_4
XFILLER_12_136 VDD VSS sg13cmos5l_fill_1
XFILLER_12_149 VDD VSS sg13cmos5l_fill_1
XFILLER_13_0 VDD VSS sg13cmos5l_decap_8
XFILLER_13_7 VDD VSS sg13cmos5l_decap_8
XFILLER_13_14 VDD VSS sg13cmos5l_decap_8
XFILLER_13_21 VDD VSS sg13cmos5l_decap_8
XFILLER_13_28 VDD VSS sg13cmos5l_decap_8
XFILLER_13_35 VDD VSS sg13cmos5l_decap_8
XFILLER_13_42 VDD VSS sg13cmos5l_fill_1
XFILLER_13_82 VDD VSS sg13cmos5l_fill_1
XFILLER_13_93 VDD VSS sg13cmos5l_fill_1
XFILLER_13_103 VDD VSS sg13cmos5l_fill_1
XFILLER_13_113 VDD VSS sg13cmos5l_fill_2
XFILLER_13_115 VDD VSS sg13cmos5l_fill_1
XFILLER_13_145 VDD VSS sg13cmos5l_fill_1
XFILLER_13_188 VDD VSS sg13cmos5l_fill_2
XFILLER_13_225 VDD VSS sg13cmos5l_fill_1
XFILLER_14_0 VDD VSS sg13cmos5l_decap_8
XFILLER_14_7 VDD VSS sg13cmos5l_decap_8
XFILLER_14_14 VDD VSS sg13cmos5l_decap_8
XFILLER_14_21 VDD VSS sg13cmos5l_decap_8
XFILLER_14_28 VDD VSS sg13cmos5l_decap_8
XFILLER_14_35 VDD VSS sg13cmos5l_decap_4
XFILLER_14_43 VDD VSS sg13cmos5l_fill_1
XFILLER_14_65 VDD VSS sg13cmos5l_fill_2
XFILLER_14_67 VDD VSS sg13cmos5l_fill_1
XFILLER_14_92 VDD VSS sg13cmos5l_fill_1
XFILLER_14_148 VDD VSS sg13cmos5l_fill_1
XFILLER_14_175 VDD VSS sg13cmos5l_fill_1
XFILLER_14_187 VDD VSS sg13cmos5l_fill_1
XFILLER_15_4 VDD VSS sg13cmos5l_decap_8
XFILLER_15_11 VDD VSS sg13cmos5l_decap_8
XFILLER_15_18 VDD VSS sg13cmos5l_decap_8
XFILLER_15_25 VDD VSS sg13cmos5l_decap_8
XFILLER_15_32 VDD VSS sg13cmos5l_fill_2
XFILLER_15_78 VDD VSS sg13cmos5l_decap_4
XFILLER_15_82 VDD VSS sg13cmos5l_fill_2
XFILLER_15_87 VDD VSS sg13cmos5l_decap_8
XFILLER_15_114 VDD VSS sg13cmos5l_fill_1
XFILLER_15_154 VDD VSS sg13cmos5l_fill_1
XFILLER_15_173 VDD VSS sg13cmos5l_fill_1
XFILLER_16_9 VDD VSS sg13cmos5l_decap_8
XFILLER_16_16 VDD VSS sg13cmos5l_decap_8
XFILLER_16_23 VDD VSS sg13cmos5l_decap_8
XFILLER_16_30 VDD VSS sg13cmos5l_fill_1
XFILLER_16_58 VDD VSS sg13cmos5l_fill_2
XFILLER_16_65 VDD VSS sg13cmos5l_fill_2
XFILLER_16_67 VDD VSS sg13cmos5l_fill_1
XFILLER_16_73 VDD VSS sg13cmos5l_fill_1
XFILLER_16_92 VDD VSS sg13cmos5l_decap_4
XFILLER_16_107 VDD VSS sg13cmos5l_fill_2
XFILLER_16_140 VDD VSS sg13cmos5l_fill_1
XFILLER_16_189 VDD VSS sg13cmos5l_fill_2
XFILLER_17_0 VDD VSS sg13cmos5l_decap_8
XFILLER_17_7 VDD VSS sg13cmos5l_decap_8
XFILLER_17_14 VDD VSS sg13cmos5l_decap_4
XFILLER_17_18 VDD VSS sg13cmos5l_fill_2
XFILLER_17_61 VDD VSS sg13cmos5l_fill_2
XFILLER_17_81 VDD VSS sg13cmos5l_fill_1
XFILLER_17_90 VDD VSS sg13cmos5l_fill_2
XFILLER_17_114 VDD VSS sg13cmos5l_fill_2
XFILLER_17_163 VDD VSS sg13cmos5l_fill_1
XFILLER_18_0 VDD VSS sg13cmos5l_decap_8
XFILLER_18_7 VDD VSS sg13cmos5l_decap_8
XFILLER_18_14 VDD VSS sg13cmos5l_decap_8
XFILLER_18_48 VDD VSS sg13cmos5l_fill_2
XFILLER_18_82 VDD VSS sg13cmos5l_fill_1
XFILLER_18_101 VDD VSS sg13cmos5l_fill_1
XFILLER_18_106 VDD VSS sg13cmos5l_fill_2
XFILLER_18_163 VDD VSS sg13cmos5l_fill_2
XFILLER_19_0 VDD VSS sg13cmos5l_decap_8
XFILLER_19_7 VDD VSS sg13cmos5l_decap_8
XFILLER_19_14 VDD VSS sg13cmos5l_decap_8
XFILLER_19_21 VDD VSS sg13cmos5l_decap_8
XFILLER_19_28 VDD VSS sg13cmos5l_fill_1
XFILLER_19_48 VDD VSS sg13cmos5l_fill_1
XFILLER_19_58 VDD VSS sg13cmos5l_fill_2
XFILLER_19_155 VDD VSS sg13cmos5l_fill_1
XFILLER_19_216 VDD VSS sg13cmos5l_fill_1
XFILLER_20_0 VDD VSS sg13cmos5l_decap_8
XFILLER_20_7 VDD VSS sg13cmos5l_decap_8
XFILLER_20_14 VDD VSS sg13cmos5l_decap_8
XFILLER_20_21 VDD VSS sg13cmos5l_decap_4
XFILLER_20_25 VDD VSS sg13cmos5l_fill_1
XFILLER_20_148 VDD VSS sg13cmos5l_fill_1
XFILLER_21_4 VDD VSS sg13cmos5l_decap_8
XFILLER_21_11 VDD VSS sg13cmos5l_decap_8
XFILLER_21_18 VDD VSS sg13cmos5l_decap_8
XFILLER_21_25 VDD VSS sg13cmos5l_fill_2
XFILLER_21_90 VDD VSS sg13cmos5l_fill_1
XFILLER_21_225 VDD VSS sg13cmos5l_fill_1
XFILLER_22_13 VDD VSS sg13cmos5l_decap_8
XFILLER_22_20 VDD VSS sg13cmos5l_fill_2
XFILLER_22_22 VDD VSS sg13cmos5l_fill_1
XFILLER_22_27 VDD VSS sg13cmos5l_decap_4
XFILLER_22_31 VDD VSS sg13cmos5l_fill_2
XFILLER_22_81 VDD VSS sg13cmos5l_fill_1
.ENDS sar_fsm_wrapper

.END
