* PEX produced on Tue Sep 22 07:31:42 PM CEST 2026 using /home/arjun/eda/projects/SAR_ADC/circuit_files/src/sar_fsm/build/tools/sak-pex.sh with m=3 and s=1 (extresist threshold=10000 mOhm, minres=1000 mOhm, mindelay=1 ps)
* NGSPICE file created from sar_fsm_wrapper.ext - technology: ihp-sg13cmos5l

.subckt sar_fsm_wrapper busy code0 code1 code2 code3 code4 code5 code6 code7 code8
+ code9 valid bn0 bn1 bn2 bn3 bn4 bn5 bn6 bn7 bn8 bn9 bp0 bp1 bp2 bp3 bp4 bp5 bp6
+ bp7 bp8 bp9 clk comp comp_clk rst_n sample start VDD VSS
X0 VDD.t1366 a_2156_19734# code9 VDD.t270 sg13_lv_pmos ad=0.2114p pd=1.54u as=0.42p ps=2.99u w=1.12u l=0.13u
X1 VSS.t937 sg13cmos5l_o21ai_1_17.Y a_11288_19061# VSS.t1281 sg13_lv_nmos ad=79.8f pd=0.8u as=0.1428p ps=1.52u w=0.42u l=0.13u
X2 VDD.t1686 sg13cmos5l_nand4_1_1.A sg13cmos5l_a21oi_1_7.A2 VDD.t83 sg13_lv_pmos ad=0.3808p pd=2.92u as=0.2128p ps=1.5u w=1.12u l=0.13u
X3 a_14746_9912# sg13cmos5l_a22oi_1_0.B2 VDD.t1175 VDD.t52 sg13_lv_pmos ad=0.1428p pd=1.52u as=0.1523p ps=1.38u w=0.42u l=0.13u
X4 VSS.t1987 VDD.t2413 VSS.t1987 VSS.t1989 sg13_lv_nmos ad=79.8f pd=0.8u as=0 ps=0 w=0.42u l=1u
X5 VDD.t553 VSS.t1966 VDD.t551 VDD.t5 sg13_lv_pmos ad=0.19p pd=1.38u as=0 ps=0 w=1u l=1u
X6 VSS.t779 sg13cmos5l_nand2_1_3.Y a_8942_7656# VSS.t813 sg13_lv_nmos ad=0.2516p pd=2.16u as=96.2f ps=1u w=0.74u l=0.13u
X7 VSS.t779 VDD.t2468 VSS.t779 VSS.t1886 sg13_lv_nmos ad=0.1428p pd=1.52u as=0 ps=0 w=0.42u l=1u
X8 VDD.t671 a_19450_18226# a_19169_18448# VDD.t231 sg13_lv_pmos ad=0.1523p pd=1.38u as=0.34p ps=2.68u w=1u l=0.5u
X9 VSS.t1058 sg13cmos5l_buf_1_15.A a_5032_9948# VSS.t2317 sg13_lv_nmos ad=0.14875p pd=1.16u as=0.187p ps=1.78u w=0.55u l=0.13u
X10 sg13cmos5l_dlygate4sd3_1_16.A a_22506_9948# VDD.t996 VDD.t52 sg13_lv_pmos ad=0.3808p pd=2.92u as=0.2128p ps=1.5u w=1.12u l=0.13u
X11 VDD.t127 VSS.t1997 VDD.t126 VDD.t13 sg13_lv_pmos ad=0.19p pd=1.38u as=0 ps=0 w=1u l=1u
X12 VSS.t1614 VDD.t2560 VSS.t468 VSS.t1615 sg13_lv_nmos ad=79.8f pd=0.8u as=0 ps=0 w=0.42u l=1u
X13 a_14038_16742# sg13cmos5l_nor2_1_15.Y VSS.t204 VSS.t991 sg13_lv_nmos ad=0.1406p pd=1.12u as=0.1406p ps=1.12u w=0.74u l=0.15u
X14 VDD.t178 VSS.t1794 VDD.t177 VDD.t0 sg13_lv_pmos ad=0.34p pd=2.68u as=0 ps=0 w=1u l=1u
X15 a_7907_15532# sg13cmos5l_o21ai_1_5.A2 a_7805_15532# VDD.t16 sg13_lv_pmos ad=0.2464p pd=1.56u as=0.2128p ps=1.5u w=1.12u l=0.13u
X16 VDD.t216 VSS.t1805 VDD.t214 VDD.t52 sg13_lv_pmos ad=0.19p pd=1.38u as=0 ps=0 w=1u l=1u
X17 VSS.t1973 VDD.t2435 VSS.t1973 VSS.t1977 sg13_lv_nmos ad=79.8f pd=0.8u as=0 ps=0 w=0.42u l=1u
X18 sg13cmos5l_dlygate4sd3_1_69.A sg13cmos5l_o21ai_1_26.B1 a_12118_17886# VSS.t916 sg13_lv_nmos ad=0.2516p pd=2.16u as=0.1406p ps=1.12u w=0.74u l=0.15u
X19 bn4 a_11656_15272# VSS.t199 VSS.t976 sg13_lv_nmos ad=0.2886p pd=2.26u as=0.14875p ps=1.16u w=0.74u l=0.13u
X20 sg13cmos5l_buf_8_2.A a_12987_12214# VSS.t153 VSS.t2621 sg13_lv_nmos ad=0.1406p pd=1.12u as=0.1406p ps=1.12u w=0.74u l=0.13u
X21 a_14938_6888# sg13cmos5l_o21ai_1_4.Y VDD.t1180 VDD.t2 sg13_lv_pmos ad=0.1428p pd=1.52u as=0.1523p ps=1.38u w=0.42u l=0.13u
X22 sg13cmos5l_o21ai_1_1.Y sg13cmos5l_o21ai_1_1.B1 a_14230_7670# VSS.t1467 sg13_lv_nmos ad=0.2516p pd=2.16u as=0.1406p ps=1.12u w=0.74u l=0.15u
X23 VDD.t1597 sg13cmos5l_buf_8_2.A.t4 a_21531_13342# VDD.t83 sg13_lv_pmos ad=0.2128p pd=1.5u as=0.2128p ps=1.5u w=1.12u l=0.13u
X24 sg13cmos5l_nor3_1_2.C sg13cmos5l_nand4_1_0.C VDD.t1369 VDD.t8 sg13_lv_pmos ad=0.2128p pd=1.5u as=0.2128p ps=1.5u w=1.12u l=0.13u
X25 bp6 a_19432_3900# VSS.t273 VSS.t752 sg13_lv_nmos ad=0.2886p pd=2.26u as=0.14875p ps=1.16u w=0.74u l=0.13u
X26 VDD.t174 VSS.t1859 VDD.t173 VDD.t8 sg13_lv_pmos ad=0.34p pd=2.68u as=0 ps=0 w=1u l=1u
X27 sg13cmos5l_nand3_1_0.A sg13cmos5l_o21ai_1_0.A1 a_12022_8814# VSS.t2376 sg13_lv_nmos ad=0.2516p pd=2.16u as=0.1406p ps=1.12u w=0.74u l=0.15u
X28 VSS.t7 sg13cmos5l_inv_1_17.A a_19912_11460# VSS.t502 sg13_lv_nmos ad=0.14875p pd=1.16u as=0.187p ps=1.78u w=0.55u l=0.13u
X29 a_19630_15423# a_19745_15424# VSS.t514 VSS.t392 sg13_lv_nmos ad=0.1428p pd=1.52u as=0.1426p ps=1.16u w=0.42u l=0.5u
X30 sg13cmos5l_nor3_1_4.A sg13cmos5l_and4_1_1.A VDD.t1055 VDD.t19 sg13_lv_pmos ad=0.3808p pd=2.92u as=0.3808p ps=2.92u w=1.12u l=0.13u
X31 VSS.t2002 VDD.t2405 VSS.t2002 VSS.t2052 sg13_lv_nmos ad=79.8f pd=0.8u as=0 ps=0 w=0.42u l=1u
X32 sg13cmos5l_o21ai_1_18.B1 a_9846_17532# VDD.t1021 VDD.t310 sg13_lv_pmos ad=0.4256p pd=3u as=0.2254p ps=1.53u w=1.12u l=0.13u
X33 a_10634_17044# sg13cmos5l_a21oi_1_27.B1 VDD.t2049 VDD.t310 sg13_lv_pmos ad=0.1176p pd=1.33u as=0.4032p ps=2.96u w=1.12u l=0.13u
X34 VDD.t212 VSS.t1805 VDD.t211 VDD.t0 sg13_lv_pmos ad=0.34p pd=2.68u as=0 ps=0 w=1u l=1u
X35 a_6442_10666# sg13cmos5l_buf_8_2.A.t3 VSS.t362 VSS.t1027 sg13_lv_nmos ad=0.2553p pd=2.17u as=0.1406p ps=1.12u w=0.74u l=0.13u
X36 a_12058_7678# sg13cmos5l_nand3_1_3.Y VSS.t101 VSS.t1076 sg13_lv_nmos ad=0.1406p pd=1.12u as=0.2516p ps=2.16u w=0.74u l=0.13u
X37 VSS.t388 sg13cmos5l_nor3_1_2.B sg13cmos5l_nor3_1_2.Y VSS.t549 sg13_lv_nmos ad=0.1463p pd=1.15u as=0.1694p ps=1.21u w=0.77u l=0.13u
X38 a_10809_20085# a_9867_19892# a_10607_19847# VDD.t270 sg13_lv_pmos ad=93.45f pd=0.865u as=0.2048p ps=1.63u w=0.42u l=0.13u
X39 VDD.t1577 a_13294_16935# sg13cmos5l_nand2_1_12.A VDD.t310 sg13_lv_pmos ad=0.2254p pd=1.53u as=0.4256p ps=3u w=1.12u l=0.13u
X40 VDD.t84 VSS.t498 VDD.t429 VDD.t83 sg13_lv_pmos ad=0.34p pd=2.68u as=0 ps=0 w=1u l=1u
X41 VDD.t796 sg13cmos5l_dfrbpq_1_2.D a_16631_8065# VDD.t8 sg13_lv_pmos ad=0.1428p pd=1.52u as=79.8f ps=0.8u w=0.42u l=0.13u
X42 VSS.t674 sg13cmos5l_dfrbpq_1_19.CLK a_4031_15967# VSS.t2475 sg13_lv_nmos ad=3.97945p pd=25.095u as=0.2516p ps=2.16u w=0.74u l=0.13u
X43 VSS.t196 a_9446_13726# a_9558_13790# VSS.t66 sg13_lv_nmos ad=0.1426p pd=1.16u as=0.1428p ps=1.52u w=0.42u l=0.5u
X44 bp8 a_19720_3176# VSS.t122 VSS.t464 sg13_lv_nmos ad=0.2886p pd=2.26u as=0.14875p ps=1.16u w=0.74u l=0.13u
X45 VDD.t1293 a_13676_19734# code3 VDD.t270 sg13_lv_pmos ad=0.2114p pd=1.54u as=0.42p ps=2.99u w=1.12u l=0.13u
X46 a_5604_12976# a_6123_12983# a_6863_13333# VSS.t149 sg13_lv_nmos ad=0.3473p pd=2.71u as=0.12665p ps=1.145u w=0.74u l=0.13u
X47 a_20217_17631# a_19275_17519# a_20015_17869# VDD.t310 sg13_lv_pmos ad=93.45f pd=0.865u as=0.2048p ps=1.63u w=0.42u l=0.13u
X48 VDD.t0 a_21839_11821# a_22096_11702# VDD.t0 sg13_lv_pmos ad=2.1916p pd=14.26u as=79.8f ps=0.8u w=0.42u l=0.13u
X49 VDD.t2071 a_12140_19734# code5 VDD.t270 sg13_lv_pmos ad=0.2114p pd=1.54u as=0.42p ps=2.99u w=1.12u l=0.13u
X50 a_18706_15234# sg13cmos5l_dfrbpq_1_28.RESET_B VSS.t393 VSS.t392 sg13_lv_nmos ad=37.8f pd=0.6u as=79.8f ps=0.8u w=0.42u l=0.13u
X51 a_7044_11885# a_6756_11464# a_6982_11885# VSS.t1545 sg13_lv_nmos ad=0.1428p pd=1.52u as=37.8f ps=0.6u w=0.42u l=0.13u
X52 a_9934_9375# a_10049_9376# VDD.t1160 VDD.t52 sg13_lv_pmos ad=0.34p pd=2.68u as=0.2254p ps=1.53u w=1u l=0.5u
X53 VSS.t264 sg13cmos5l_inv_1_5.A a_16319_9456# VSS.t1037 sg13_lv_nmos ad=4.60297p pd=30.14u as=0.2516p ps=2.16u w=0.74u l=0.13u
X54 a_4366_18258# a_4108_18258# VSS.t1112 VSS.t1111 sg13_lv_nmos ad=0.1428p pd=1.52u as=79.8f ps=0.8u w=0.42u l=0.13u
X55 VSS.t91 sg13cmos5l_dfrbpq_1_28.RESET_B.t10 a_18564_17946# VSS.t865 sg13_lv_nmos ad=0.1626p pd=1.415u as=60.89999f ps=0.71u w=0.42u l=0.13u
X56 a_21911_16043# a_21215_15967# a_22005_16043# VSS.t706 sg13_lv_nmos ad=0.1296p pd=1.52u as=79.8f ps=0.8u w=0.42u l=0.13u
X57 VSS.t1966 VDD.t2438 VSS.t1966 VSS.t1969 sg13_lv_nmos ad=79.8f pd=0.8u as=0 ps=0 w=0.42u l=1u
X58 VSS.t1646 VDD.t2547 VSS.t1647 VSS.t227 sg13_lv_nmos ad=79.8f pd=0.8u as=0 ps=0 w=0.42u l=1u
X59 a_1294_15423# a_1409_15424# VSS.t312 VSS.t2325 sg13_lv_nmos ad=0.1428p pd=1.52u as=0.1426p ps=1.16u w=0.42u l=0.5u
X60 a_16274_15242# sg13cmos5l_nand4_1_5.D VSS.t136 VSS.t506 sg13_lv_nmos ad=0.1406p pd=1.12u as=0.2516p ps=2.16u w=0.74u l=0.13u
X61 a_14446_11727# a_14561_11726# VSS.t153 VSS.t2264 sg13_lv_nmos ad=0.1428p pd=1.52u as=0.1426p ps=1.16u w=0.42u l=0.5u
X62 VDD.t269 VSS.t1973 VDD.t299 VDD.t13 sg13_lv_pmos ad=0.19p pd=1.38u as=0 ps=0 w=1u l=1u
X63 a_7238_19458# sg13cmos5l_dfrbpq_1_21.D VDD.t2172 VDD.t231 sg13_lv_pmos ad=79.8f pd=0.8u as=0.1428p ps=1.52u w=0.42u l=0.13u
X64 a_3782_9948# a_3512_9989# VDD.t1186 VDD.t52 sg13_lv_pmos ad=0.34p pd=2.68u as=0.1523p ps=1.38u w=1u l=0.5u
X65 a_13738_17476# a_14181_17519# a_14121_17555# VDD.t310 sg13_lv_pmos ad=79.8f pd=0.8u as=63f ps=0.72u w=0.42u l=0.13u
X66 a_10990_8052# sg13cmos5l_nand3_1_3.Y a_10896_8052# VDD.t8 sg13_lv_pmos ad=0.1596p pd=1.22u as=0.2856p ps=2.36u w=0.84u l=0.13u
X67 VDD.t2351 sg13cmos5l_buf_8_2.A.t6 a_14218_18226# VDD.t231 sg13_lv_pmos ad=0.2128p pd=1.5u as=0.2128p ps=1.5u w=1.12u l=0.13u
X68 sg13cmos5l_nor2_1_7.Y sg13cmos5l_a21oi_1_27.B1 VSS.t585 VSS.t2292 sg13_lv_nmos ad=0.1406p pd=1.12u as=0.2516p ps=2.16u w=0.74u l=0.13u
X69 bn0 a_13384_14484# VDD.t1342 VDD.t19 sg13_lv_pmos ad=0.42p pd=2.99u as=0.2114p ps=1.54u w=1.12u l=0.13u
X70 VSS.t1732 VDD.t2510 VSS.t1734 VSS.t1733 sg13_lv_nmos ad=79.8f pd=0.8u as=0 ps=0 w=0.42u l=1u
X71 a_8122_8400# sg13cmos5l_or4_1_0.D VDD.t1223 VDD.t8 sg13_lv_pmos ad=0.1428p pd=1.52u as=0.1523p ps=1.38u w=0.42u l=0.13u
X72 VSS.t132 a_20384_16921# sg13cmos5l_dlygate4sd3_1_74.A VSS.t1333 sg13_lv_nmos ad=0.1406p pd=1.12u as=0.2516p ps=2.16u w=0.74u l=0.13u
X73 sg13cmos5l_nand2_1_13.A a_9558_13790# VDD.t723 VDD.t19 sg13_lv_pmos ad=0.4256p pd=3u as=0.2254p ps=1.53u w=1.12u l=0.13u
X74 sg13cmos5l_nand4_1_3.D sg13cmos5l_nand3b_1_3.C VDD.t1448 VDD.t19 sg13_lv_pmos ad=0.2128p pd=1.5u as=0.2198p ps=1.53u w=1.12u l=0.13u
X75 a_6442_10666# sg13cmos5l_buf_8_2.A.t3 VDD.t1407 VDD.t0 sg13_lv_pmos ad=0.3808p pd=2.92u as=0.2128p ps=1.5u w=1.12u l=0.13u
X76 VSS.t2010 VDD.t2401 VSS.t2010 VSS.t2060 sg13_lv_nmos ad=79.8f pd=0.8u as=0 ps=0 w=0.42u l=1u
X77 VSS.t1981 VDD.t2432 VSS.t1981 VSS.t1983 sg13_lv_nmos ad=0.1428p pd=1.52u as=0 ps=0 w=0.42u l=1u
X78 a_19246_6351# a_19361_6352# VDD.t1119 VDD.t2 sg13_lv_pmos ad=0.34p pd=2.68u as=0.2254p ps=1.53u w=1u l=0.5u
X79 VSS.t79 sg13cmos5l_o21ai_1_28.A1 a_12406_15230# VSS.t78 sg13_lv_nmos ad=0.1406p pd=1.12u as=0.2516p ps=2.16u w=0.74u l=0.15u
X80 VSS.t1660 VDD.t2544 VSS.t1660 VSS.t1661 sg13_lv_nmos ad=0.1428p pd=1.52u as=0 ps=0 w=0.42u l=1u
X81 a_7196_15552# sg13cmos5l_o21ai_1_7.A2 sg13cmos5l_o21ai_1_7.Y VDD.t16 sg13_lv_pmos ad=0.2128p pd=1.5u as=0.2128p ps=1.5u w=1.12u l=0.15u
X82 sg13cmos5l_nand4_1_3.B sg13cmos5l_mux2_1_1.A1 VSS.t67 VSS.t66 sg13_lv_nmos ad=0.1406p pd=1.12u as=0.1406p ps=1.12u w=0.74u l=0.13u
X83 a_19718_12214# a_19448_12214# VSS.t7 VSS.t1280 sg13_lv_nmos ad=0.1428p pd=1.52u as=79.8f ps=0.8u w=0.42u l=0.5u
X84 sg13cmos5l_dfrbpq_1_15.CLK a_6442_10666# VSS.t362 VSS.t2404 sg13_lv_nmos ad=0.1406p pd=1.12u as=0.1406p ps=1.12u w=0.74u l=0.13u
X85 VDD.t2019 a_15790_7191# sg13cmos5l_a21oi_1_9.A2 VDD.t2 sg13_lv_pmos ad=0.2254p pd=1.53u as=0.4256p ps=3u w=1.12u l=0.13u
X86 a_21934_10887# a_22049_10888# VSS.t76 VSS.t75 sg13_lv_nmos ad=0.1428p pd=1.52u as=0.1426p ps=1.16u w=0.42u l=0.5u
X87 sg13cmos5l_dlygate4sd3_1_25.A sg13cmos5l_buf_1_5.A a_16342_10694# VSS.t888 sg13_lv_nmos ad=0.2516p pd=2.16u as=0.1406p ps=1.12u w=0.74u l=0.15u
X88 a_9062_5850# a_9867_5423# a_9322_5380# VDD.t5 sg13_lv_pmos ad=0.1428p pd=1.52u as=79.8f ps=0.8u w=0.42u l=0.13u
X89 a_6958_19959# a_7073_19960# VSS.t1132 VSS.t2418 sg13_lv_nmos ad=0.1428p pd=1.52u as=0.1426p ps=1.16u w=0.42u l=0.5u
X90 a_9674_15532# sg13cmos5l_nor2b_1_1.A sg13cmos5l_a21oi_1_12.A2 VDD.t16 sg13_lv_pmos ad=0.1176p pd=1.33u as=0.3808p ps=2.92u w=1.12u l=0.13u
X91 code1 a_15400_15272# VSS.t201 VSS.t200 sg13_lv_nmos ad=0.2886p pd=2.26u as=0.14875p ps=1.16u w=0.74u l=0.13u
X92 sg13cmos5l_nand3_1_2.Y sg13cmos5l_nand3_1_2.A a_13880_10706# VSS.t1350 sg13_lv_nmos ad=0.2516p pd=2.16u as=0.1406p ps=1.12u w=0.74u l=0.13u
X93 a_16440_11016# sg13cmos5l_buf_1_14.A VDD.t743 VDD.t0 sg13_lv_pmos ad=0.2128p pd=1.5u as=0.3808p ps=2.92u w=1.12u l=0.15u
X94 VSS.t918 a_1294_9375# sg13cmos5l_buf_1_17.A VSS.t88 sg13_lv_nmos ad=0.1426p pd=1.16u as=0.2516p ps=2.16u w=0.74u l=0.13u
X95 a_13434_6887# sg13cmos5l_a21oi_1_9.A2 VSS.t284 VSS.t2335 sg13_lv_nmos ad=0.17462p pd=1.185u as=0.15245p ps=1.17u w=0.55u l=0.13u
X96 a_20015_19381# a_19173_19031# a_19921_19381# VSS.t1098 sg13_lv_nmos ad=0.12665p pd=1.145u as=0.1428p ps=1.52u w=0.42u l=0.13u
X97 a_6418_14922# sg13cmos5l_dfrbpq_1_24.RESET_B VSS.t585 VSS.t1146 sg13_lv_nmos ad=37.8f pd=0.6u as=79.8f ps=0.8u w=0.42u l=0.13u
X98 a_20554_12433# a_20997_12189# a_20294_12210# VSS.t1008 sg13_lv_nmos ad=79.8f pd=0.8u as=0.1296p ps=1.52u w=0.42u l=0.13u
X99 a_5700_7687# a_5412_7992# a_5638_7687# VSS.t93 sg13_lv_nmos ad=0.1428p pd=1.52u as=37.8f ps=0.6u w=0.42u l=0.13u
X100 VSS.t407 a_6286_16263# sg13cmos5l_o21ai_1_10.B1 VSS.t1323 sg13_lv_nmos ad=0.1426p pd=1.16u as=0.2516p ps=2.16u w=0.74u l=0.13u
X101 VDD.t7 VSS.t1920 VDD.t6 VDD.t5 sg13_lv_pmos ad=0.34p pd=2.68u as=0 ps=0 w=1u l=1u
X102 VDD.t1134 a_15983_6239# a_16650_6460# VDD.t2 sg13_lv_pmos ad=0.2128p pd=1.5u as=0.3864p ps=2.93u w=1.12u l=0.13u
X103 VDD.t763 a_6368_6337# sg13cmos5l_dfrbpq_1_15.Q VDD.t2 sg13_lv_pmos ad=0.2128p pd=1.5u as=0.3808p ps=2.92u w=1.12u l=0.13u
X104 VDD.t366 sg13cmos5l_buf_1_7.X a_20294_8874# VDD.t8 sg13_lv_pmos ad=0.36237p pd=2.605u as=79.8f ps=0.8u w=0.42u l=0.13u
X105 VSS.t309 a_3296_16921# sg13cmos5l_dfrbpq_1_23.Q VSS.t403 sg13_lv_nmos ad=0.1406p pd=1.12u as=0.2516p ps=2.16u w=0.74u l=0.13u
X106 sg13cmos5l_a21oi_1_1.A2 sg13cmos5l_nor3_1_6.Y VDD.t1581 VDD.t19 sg13_lv_pmos ad=0.2128p pd=1.5u as=0.2128p ps=1.5u w=1.12u l=0.13u
X107 sg13cmos5l_buf_1_43.X a_16840_12972# VSS.t172 VSS.t128 sg13_lv_nmos ad=0.2886p pd=2.26u as=0.14875p ps=1.16u w=0.74u l=0.13u
X108 VDD.t533 VSS.t1754 VDD.t532 VDD.t0 sg13_lv_pmos ad=0.19p pd=1.38u as=0 ps=0 w=1u l=1u
X109 VDD.t289 VSS.t1697 VDD.t288 VDD.t19 sg13_lv_pmos ad=0.34p pd=2.68u as=0 ps=0 w=1u l=1u
X110 VDD.t428 VSS.t1620 VDD.t312 VDD.t310 sg13_lv_pmos ad=0.19p pd=1.38u as=0 ps=0 w=1u l=1u
X111 VSS.t5 sg13cmos5l_nand3_1_5.Y a_7954_17886# VSS.t1529 sg13_lv_nmos ad=0.1406p pd=1.12u as=0.1406p ps=1.12u w=0.74u l=0.15u
X112 sg13cmos5l_a22oi_1_0.A2 a_13198_9228# VSS.t441 VSS.t2347 sg13_lv_nmos ad=0.1406p pd=1.12u as=0.17255p ps=1.25u w=0.74u l=0.13u
X113 sg13cmos5l_dlygate4sd3_1_29.A sg13cmos5l_inv_1_14.Y a_19827_7272# VSS.t87 sg13_lv_nmos ad=0.1406p pd=1.12u as=0.1406p ps=1.12u w=0.74u l=0.13u
X114 VSS.t1875 VDD.t2471 VSS.t1874 VSS.t1873 sg13_lv_nmos ad=0.1428p pd=1.52u as=0 ps=0 w=0.42u l=1u
X115 a_22234_19738# sg13cmos5l_dfrbpq_1_34.Q VDD.t1436 VDD.t270 sg13_lv_pmos ad=0.1428p pd=1.52u as=0.1523p ps=1.38u w=0.42u l=0.13u
X116 VDD.t1637 sg13cmos5l_nor4_1_2.Y sg13cmos5l_a21oi_1_25.A2 VDD.t310 sg13_lv_pmos ad=0.2128p pd=1.5u as=0.2128p ps=1.5u w=1.12u l=0.13u
X117 sg13cmos5l_dlygate4sd3_1_80.X a_13782_15302# VSS.t239 VSS.t635 sg13_lv_nmos ad=0.2516p pd=2.16u as=0.1426p ps=1.16u w=0.74u l=0.13u
X118 a_7047_6380# a_7199_6432# VSS.t271 VSS.t2395 sg13_lv_nmos ad=0.2516p pd=2.16u as=4.02307p ps=25.55u w=0.74u l=0.13u
X119 VDD.t310 sg13cmos5l_dfrbpq_1_28.RESET_B.t8 a_20716_16746# VDD.t310 sg13_lv_pmos ad=2.07625p pd=13.51u as=79.8f ps=0.8u w=0.42u l=0.13u
X120 a_8338_16742# sg13cmos5l_o21ai_1_14.A1 VSS.t48 VSS.t1357 sg13_lv_nmos ad=0.2516p pd=2.16u as=0.1406p ps=1.12u w=0.74u l=0.15u
X121 sg13cmos5l_dfrbpq_1_15.CLK a_6442_10666# VDD.t2157 VDD.t0 sg13_lv_pmos ad=0.2128p pd=1.5u as=0.2128p ps=1.5u w=1.12u l=0.13u
X122 sg13cmos5l_dfrbpq_1_5.CLK a_21531_13342# VSS.t163 VSS.t1240 sg13_lv_nmos ad=0.1406p pd=1.12u as=0.1406p ps=1.12u w=0.74u l=0.13u
X123 VSS.t245 sg13cmos5l_inv_1_12.A a_15208_12972# VSS.t128 sg13_lv_nmos ad=0.14875p pd=1.16u as=0.187p ps=1.78u w=0.55u l=0.13u
X124 VDD.t995 a_18094_9375# sg13cmos5l_dfrbpq_1_11.D VDD.t52 sg13_lv_pmos ad=0.2254p pd=1.53u as=0.4256p ps=3u w=1.12u l=0.13u
X125 VSS.t2010 VDD.t2419 VSS.t2014 VSS.t2013 sg13_lv_nmos ad=79.8f pd=0.8u as=0 ps=0 w=0.42u l=1u
X126 a_13764_16000# a_13738_15964# VDD.t887 VDD.t16 sg13_lv_pmos ad=0.34p pd=2.68u as=0.36237p ps=2.605u w=1u l=0.13u
X127 VSS.t1987 VDD.t2412 VSS.t291 VSS.t2037 sg13_lv_nmos ad=79.8f pd=0.8u as=0 ps=0 w=0.42u l=1u
X128 a_13018_7678# sg13cmos5l_nand2_1_0.A sg13cmos5l_nand2b_1_0.B VSS.t710 sg13_lv_nmos ad=0.1406p pd=1.12u as=0.2516p ps=2.16u w=0.74u l=0.13u
X129 a_4727_16043# a_4031_15967# a_4821_16043# VSS.t1446 sg13_lv_nmos ad=0.1296p pd=1.52u as=79.8f ps=0.8u w=0.42u l=0.13u
X130 a_6286_16263# a_6401_16262# VSS.t407 VSS.t954 sg13_lv_nmos ad=0.1428p pd=1.52u as=0.1426p ps=1.16u w=0.42u l=0.5u
X131 VDD.t131 VSS.t1997 VDD.t129 VDD.t13 sg13_lv_pmos ad=0.19p pd=1.38u as=0 ps=0 w=1u l=1u
X132 a_17829_6935# sg13cmos5l_inv_1_5.A VSS.t253 VSS.t1035 sg13_lv_nmos ad=0.2516p pd=2.16u as=4.21822p ps=27.295u w=0.74u l=0.13u
X133 a_18634_7897# a_19077_7653# a_19017_8065# VDD.t8 sg13_lv_pmos ad=79.8f pd=0.8u as=63f ps=0.72u w=0.42u l=0.13u
X134 VSS.t435 sg13cmos5l_dfrbpq_1_28.RESET_B.t12 a_20810_18258# VSS.t118 sg13_lv_nmos ad=79.8f pd=0.8u as=37.8f ps=0.6u w=0.42u l=0.13u
X135 a_4838_15238# a_4568_15238# VDD.t1426 VDD.t16 sg13_lv_pmos ad=0.34p pd=2.68u as=0.1523p ps=1.38u w=1u l=0.5u
X136 VSS.t1056 a_21350_19020# a_21462_19044# VSS.t1098 sg13_lv_nmos ad=0.1426p pd=1.16u as=0.1428p ps=1.52u w=0.42u l=0.5u
X137 a_11884_15996# sg13cmos5l_o21ai_1_5.A2 sg13cmos5l_nand3_1_6.C VDD.t16 sg13_lv_pmos ad=0.1176p pd=1.33u as=0.3808p ps=2.92u w=1.12u l=0.13u
X138 VDD.t304 VSS.t1663 VDD.t226 VDD.t16 sg13_lv_pmos ad=0.34p pd=2.68u as=0 ps=0 w=1u l=1u
X139 a_18468_10698# sg13cmos5l_dlygate4sd3_1_18.X a_18374_10698# VSS.t2564 sg13_lv_nmos ad=60.89999f pd=0.71u as=0.1428p ps=1.52u w=0.42u l=0.13u
X140 VSS.t380 sg13cmos5l_buf_1_47.X a_12118_17886# VSS.t1291 sg13_lv_nmos ad=0.1406p pd=1.12u as=0.2516p ps=2.16u w=0.74u l=0.15u
X141 a_20494_15423# a_20609_15424# VSS.t72 VSS.t580 sg13_lv_nmos ad=0.1428p pd=1.52u as=0.1426p ps=1.16u w=0.42u l=0.5u
X142 sg13cmos5l_o21ai_1_9.B1 sg13cmos5l_dlygate4sd3_1_45.X VDD.t677 VDD.t19 sg13_lv_pmos ad=0.2128p pd=1.5u as=0.3808p ps=2.92u w=1.12u l=0.13u
X143 a_11131_14874# sg13cmos5l_mux2_1_1.A1 a_11029_14874# VSS.t470 sg13_lv_nmos ad=0.1408p pd=1.08u as=0.1216p ps=1.02u w=0.64u l=0.13u
X144 a_12016_10190# a_11759_10309# a_12178_10386# VSS.t957 sg13_lv_nmos ad=0.1428p pd=1.52u as=37.8f ps=0.6u w=0.42u l=0.13u
X145 VSS.t67 a_8006_13726# a_8118_13790# VSS.t66 sg13_lv_nmos ad=0.1426p pd=1.16u as=0.1428p ps=1.52u w=0.42u l=0.5u
X146 VDD.t1103 sg13cmos5l_a21oi_1_2.A2 a_19829_3900# VDD.t13 sg13_lv_pmos ad=0.2128p pd=1.5u as=0.3808p ps=2.92u w=1.12u l=0.13u
X147 a_10268_17064# sg13cmos5l_o21ai_1_10.A2 sg13cmos5l_o21ai_1_15.Y VDD.t310 sg13_lv_pmos ad=0.2128p pd=1.5u as=0.2128p ps=1.5u w=1.12u l=0.15u
X148 a_22096_13942# sg13cmos5l_dfrbpq_1_28.RESET_B.t3 VDD.t19 VDD.t19 sg13_lv_pmos ad=79.8f pd=0.8u as=2.07625p ps=13.51u w=0.42u l=0.13u
X149 VSS.t1732 VDD.t2521 VSS.t1734 VSS.t1733 sg13_lv_nmos ad=79.8f pd=0.8u as=0 ps=0 w=0.42u l=1u
X150 VDD.t492 VSS.t1721 VDD.t491 VDD.t0 sg13_lv_pmos ad=0.34p pd=2.68u as=0 ps=0 w=1u l=1u
X151 VDD.t901 a_21350_17508# a_21462_17532# VDD.t310 sg13_lv_pmos ad=0.2254p pd=1.53u as=0.34p ps=2.68u w=1u l=0.5u
X152 a_14390_5837# a_13212_5773# a_13994_5692# VSS.t1579 sg13_lv_nmos ad=37.8f pd=0.6u as=0.1428p ps=1.52u w=0.42u l=0.13u
X153 sg13cmos5l_or4_1_0.C a_9546_9948# VSS.t740 VSS.t739 sg13_lv_nmos ad=0.2516p pd=2.16u as=0.1406p ps=1.12u w=0.74u l=0.13u
X154 a_12896_13897# a_13015_13686# VSS.t159 VSS.t66 sg13_lv_nmos ad=0.2516p pd=2.16u as=0.1406p ps=1.12u w=0.74u l=0.13u
X155 a_17241_18573# a_16299_18380# a_17039_18335# VDD.t231 sg13_lv_pmos ad=93.45f pd=0.865u as=0.2048p ps=1.63u w=0.42u l=0.13u
X156 VDD.t310 sg13cmos5l_dfrbpq_1_24.RESET_B a_3628_16746# VDD.t310 sg13_lv_pmos ad=2.1916p pd=14.26u as=79.8f ps=0.8u w=0.42u l=0.13u
X157 bn0 a_13384_14484# VSS.t969 VSS.t1460 sg13_lv_nmos ad=0.2886p pd=2.26u as=0.14875p ps=1.16u w=0.74u l=0.13u
X158 sg13cmos5l_o21ai_1_0.Y sg13cmos5l_o21ai_1_0.B1 VDD.t2237 VDD.t5 sg13_lv_pmos ad=0.2128p pd=1.5u as=0.3808p ps=2.92u w=1.12u l=0.15u
X159 VSS.t569 a_11840_9389# sg13cmos5l_a21o_1_0.A1 VSS.t882 sg13_lv_nmos ad=0.1331p pd=1.12u as=0.2516p ps=2.16u w=0.74u l=0.13u
X160 VSS.t2002 VDD.t2404 VSS.t2002 VSS.t2054 sg13_lv_nmos ad=79.8f pd=0.8u as=0 ps=0 w=0.42u l=1u
X161 VSS.t1127 a_7822_19959# sg13cmos5l_dfrbpq_1_21.D VSS.t2466 sg13_lv_nmos ad=0.1426p pd=1.16u as=0.2516p ps=2.16u w=0.74u l=0.13u
X162 VSS.t1099 sg13cmos5l_a21oi_1_19.Y a_21080_19061# VSS.t1098 sg13_lv_nmos ad=79.8f pd=0.8u as=0.1428p ps=1.52u w=0.42u l=0.13u
X163 a_7989_6320# sg13cmos5l_dfrbpq_1_13.RESET_B VDD.t1566 VDD.t2 sg13_lv_pmos ad=0.147p pd=1.54u as=0.1563p ps=1.22u w=0.42u l=0.13u
X164 VSS.t571 VDD.t2477 VSS.t571 VSS.t1854 sg13_lv_nmos ad=79.8f pd=0.8u as=0 ps=0 w=0.42u l=1u
X165 a_20580_14040# a_20554_13945# VDD.t869 VDD.t19 sg13_lv_pmos ad=0.34p pd=2.68u as=0.36237p ps=2.605u w=1u l=0.13u
X166 VSS.t120 sg13cmos5l_inv_1_18.A sg13cmos5l_nor3_1_0.Y VSS.t610 sg13_lv_nmos ad=0.1463p pd=1.15u as=0.2618p ps=2.22u w=0.77u l=0.13u
X167 sg13cmos5l_a21oi_1_0.Y sg13cmos5l_a21oi_1_2.B1 VSS.t273 VSS.t895 sg13_lv_nmos ad=0.1406p pd=1.12u as=0.2516p ps=2.16u w=0.74u l=0.13u
X168 a_21754_5376# sg13cmos5l_dlygate4sd3_1_2.A VDD.t1965 VDD.t5 sg13_lv_pmos ad=0.1428p pd=1.52u as=0.1523p ps=1.38u w=0.42u l=0.13u
X169 a_9716_15202# sg13cmos5l_buf_1_65.A VDD.t681 VDD.t16 sg13_lv_pmos ad=0.2856p pd=2.36u as=0.2618p ps=1.63u w=0.84u l=0.13u
X170 VSS.t76 a_22096_10190# a_21745_10309# VSS.t546 sg13_lv_nmos ad=79.8f pd=0.8u as=0.1428p ps=1.52u w=0.42u l=0.13u
X171 sg13cmos5l_a21oi_1_11.Y sg13cmos5l_nor3_1_1.Y a_10709_6460# VDD.t2 sg13_lv_pmos ad=0.3808p pd=2.92u as=0.2128p ps=1.5u w=1.12u l=0.13u
X172 VDD.t748 sg13cmos5l_nand4_1_15.B sg13cmos5l_a21oi_1_19.A2 VDD.t16 sg13_lv_pmos ad=0.2128p pd=1.5u as=0.2128p ps=1.5u w=1.12u l=0.13u
X173 sg13cmos5l_dlygate4sd3_1_45.X a_8118_13790# VDD.t643 VDD.t19 sg13_lv_pmos ad=0.4256p pd=3u as=0.2254p ps=1.53u w=1.12u l=0.13u
X174 VDD.t198 VSS.t2167 VDD.t197 VDD.t13 sg13_lv_pmos ad=0.34p pd=2.68u as=0 ps=0 w=1u l=1u
X175 VSS.t279 sg13cmos5l_nor3_1_1.Y sg13cmos5l_a21oi_1_11.Y VSS.t319 sg13_lv_nmos ad=0.2516p pd=2.16u as=0.1406p ps=1.12u w=0.74u l=0.13u
X176 a_5126_7674# a_5931_7796# a_5386_7897# VDD.t8 sg13_lv_pmos ad=0.1428p pd=1.52u as=79.8f ps=0.8u w=0.42u l=0.13u
X177 VDD.t956 a_6490_16714# a_6209_16936# VDD.t310 sg13_lv_pmos ad=0.1523p pd=1.38u as=0.34p ps=2.68u w=1u l=0.5u
X178 VSS.t2 a_20997_11471# a_21099_11471# VSS.t1009 sg13_lv_nmos ad=4.7455p pd=30.71u as=0.2516p ps=2.16u w=0.74u l=0.13u
X179 a_21363_9212# sg13cmos5l_a21oi_1_7.A2 VSS.t15 VSS.t994 sg13_lv_nmos ad=0.1406p pd=1.12u as=0.2516p ps=2.16u w=0.74u l=0.13u
X180 sg13cmos5l_buf_1_26.A a_18486_18326# VSS.t91 VSS.t90 sg13_lv_nmos ad=0.2516p pd=2.16u as=0.1426p ps=1.16u w=0.74u l=0.13u
X181 a_16558_11727# a_16673_11726# VSS.t222 VSS.t513 sg13_lv_nmos ad=0.1428p pd=1.52u as=0.1426p ps=1.16u w=0.42u l=0.5u
X182 a_10447_7294# a_10365_7194# sg13cmos5l_nand2b_1_3.Y VSS.t911 sg13_lv_nmos ad=0.1406p pd=1.12u as=0.333p ps=2.38u w=0.74u l=0.13u
X183 sg13cmos5l_a21oi_1_0.A2 sg13cmos5l_nand4_1_3.B VDD.t1584 VDD.t83 sg13_lv_pmos ad=0.2128p pd=1.5u as=0.2128p ps=1.5u w=1.12u l=0.13u
X184 VSS.t362 VDD.t2488 VSS.t362 VSS.t1827 sg13_lv_nmos ad=79.8f pd=0.8u as=0 ps=0 w=0.42u l=1u
X185 a_16240_6382# sg13cmos5l_buf_1_13.A VDD.t2 VDD.t2 sg13_lv_pmos ad=79.8f pd=0.8u as=2.1916p ps=14.26u w=0.42u l=0.13u
X186 VDD.t873 sg13cmos5l_nand3_1_6.C sg13cmos5l_o21ai_1_10.A2 VDD.t16 sg13_lv_pmos ad=0.3808p pd=2.92u as=0.2128p ps=1.5u w=1.12u l=0.13u
X187 VDD.t579 VSS.t1973 VDD.t300 VDD.t13 sg13_lv_pmos ad=0.19p pd=1.38u as=0 ps=0 w=1u l=1u
X188 a_16770_7290# sg13cmos5l_nand3_1_0.B a_16668_7290# VSS.t2526 sg13_lv_nmos ad=0.1406p pd=1.12u as=0.1406p ps=1.12u w=0.74u l=0.13u
X189 a_5412_7992# a_5386_7897# VDD.t993 VDD.t8 sg13_lv_pmos ad=0.34p pd=2.68u as=0.36237p ps=2.605u w=1u l=0.13u
X190 a_14534_10702# a_14264_10702# VDD.t1389 VDD.t0 sg13_lv_pmos ad=0.34p pd=2.68u as=0.1523p ps=1.38u w=1u l=0.5u
X191 VSS.t291 VDD.t2409 VSS.t291 VSS.t2042 sg13_lv_nmos ad=0.1428p pd=1.52u as=0 ps=0 w=0.42u l=1u
X192 VDD.t291 VSS.t1697 VDD.t290 VDD.t83 sg13_lv_pmos ad=0.34p pd=2.68u as=0 ps=0 w=1u l=1u
X193 VDD.t1401 VSS.t1905 VDD.t1404 VDD.t5 sg13_lv_pmos ad=0.34p pd=2.68u as=0 ps=0 w=1u l=1u
X194 sg13cmos5l_a22oi_1_1.B2 sg13cmos5l_nand2_1_6.A a_9754_7678# VSS.t2490 sg13_lv_nmos ad=0.2516p pd=2.16u as=0.1406p ps=1.12u w=0.74u l=0.13u
X195 VDD.t20 VSS.t46 VDD.t505 VDD.t19 sg13_lv_pmos ad=0.34p pd=2.68u as=0 ps=0 w=1u l=1u
X196 sg13cmos5l_or4_1_1.X a_9096_15996# VSS.t48 VSS.t754 sg13_lv_nmos ad=0.2516p pd=2.16u as=0.14135p ps=1.14u w=0.74u l=0.13u
X197 a_8637_5682# sg13cmos5l_nand2b_1_1.A_N VDD.t787 VDD.t5 sg13_lv_pmos ad=0.2856p pd=2.36u as=0.2198p ps=1.53u w=0.84u l=0.13u
X198 a_14052_19770# sg13cmos5l_inv_1_32.Y a_13958_19770# VSS.t914 sg13_lv_nmos ad=60.89999f pd=0.71u as=0.1428p ps=1.52u w=0.42u l=0.13u
X199 a_11840_9389# sg13cmos5l_nand3_1_0.A VDD.t1269 VDD.t52 sg13_lv_pmos ad=0.1596p pd=1.22u as=0.1918p ps=1.5u w=0.84u l=0.13u
X200 VSS.t99 a_14542_7191# sg13cmos5l_dlygate4sd3_1_7.X VSS.t1028 sg13_lv_nmos ad=0.1426p pd=1.16u as=0.2516p ps=2.16u w=0.74u l=0.13u
X201 VSS.t1860 VDD.t2474 VSS.t1859 VSS.t1858 sg13_lv_nmos ad=0.1428p pd=1.52u as=0 ps=0 w=0.42u l=1u
X202 a_20974_19959# a_21089_19960# VSS.t1099 VSS.t1055 sg13_lv_nmos ad=0.1428p pd=1.52u as=0.1426p ps=1.16u w=0.42u l=0.5u
X203 sg13cmos5l_or4_1_0.C a_9546_9948# VDD.t1158 VDD.t52 sg13_lv_pmos ad=0.3808p pd=2.92u as=0.2128p ps=1.5u w=1.12u l=0.13u
X204 VSS.t1981 VDD.t2431 VSS.t1981 VSS.t1985 sg13_lv_nmos ad=0.1428p pd=1.52u as=0 ps=0 w=0.42u l=1u
X205 a_8206_9375# a_8321_9376# VDD.t1291 VDD.t52 sg13_lv_pmos ad=0.34p pd=2.68u as=0.2254p ps=1.53u w=1u l=0.5u
X206 VDD.t850 sg13cmos5l_o21ai_1_4.A1 a_12188_6904# VDD.t2 sg13_lv_pmos ad=0.3808p pd=2.92u as=0.2128p ps=1.5u w=1.12u l=0.15u
X207 a_17733_8447# sg13cmos5l_inv_1_5.A VSS.t264 VSS.t1036 sg13_lv_nmos ad=0.2516p pd=2.16u as=4.60297p ps=30.14u w=0.74u l=0.13u
X208 VSS.t423 sg13cmos5l_buf_1_45.X.t13 a_16644_19770# VSS.t166 sg13_lv_nmos ad=0.1626p pd=1.415u as=60.89999f ps=0.71u w=0.42u l=0.13u
X209 VDD.t1522 a_10510_19287# sg13cmos5l_o21ai_1_13.B1 VDD.t231 sg13_lv_pmos ad=0.2254p pd=1.53u as=0.4256p ps=3u w=1.12u l=0.13u
X210 a_9298_10386# sg13cmos5l_dfrbpq_1_13.RESET_B VSS.t845 VSS.t1196 sg13_lv_nmos ad=37.8f pd=0.6u as=79.8f ps=0.8u w=0.42u l=0.13u
X211 a_19113_19067# a_18756_19024# VDD.t1756 VDD.t231 sg13_lv_pmos ad=63f pd=0.72u as=0.1563p ps=1.22u w=0.42u l=0.13u
X212 a_15780_18576# a_15754_18481# VSS.t113 VSS.t1432 sg13_lv_nmos ad=0.2516p pd=2.16u as=0.1626p ps=1.415u w=0.74u l=0.13u
X213 VSS.t853 a_1690_19738# a_1409_19960# VSS.t1063 sg13_lv_nmos ad=79.8f pd=0.8u as=0.1428p ps=1.52u w=0.42u l=0.5u
X214 a_14218_19993# a_14661_19749# a_14601_20161# VDD.t270 sg13_lv_pmos ad=79.8f pd=0.8u as=63f ps=0.72u w=0.42u l=0.13u
X215 VSS.t169 a_7941_19031# a_8043_19031# VSS.t1166 sg13_lv_nmos ad=3.91182p pd=24.955u as=0.2516p ps=2.16u w=0.74u l=0.13u
X216 VSS.t120 sg13cmos5l_buf_1_14.A a_16342_10694# VSS.t220 sg13_lv_nmos ad=0.1406p pd=1.12u as=0.2516p ps=2.16u w=0.74u l=0.15u
X217 VSS.t1981 VDD.t2415 VSS.t1981 VSS.t1984 sg13_lv_nmos ad=79.8f pd=0.8u as=0 ps=0 w=0.42u l=1u
X218 sg13cmos5l_nor4_1_0.Y sg13cmos5l_and4_1_0.D VSS.t759 VSS.t1013 sg13_lv_nmos ad=0.1406p pd=1.12u as=0.1406p ps=1.12u w=0.74u l=0.13u
X219 VDD.t1377 a_20015_17869# a_20682_17508# VDD.t310 sg13_lv_pmos ad=0.2128p pd=1.5u as=0.3864p ps=2.93u w=1.12u l=0.13u
X220 VSS.t201 sg13cmos5l_a21oi_1_4.A2 a_14761_15238# VSS.t1071 sg13_lv_nmos ad=0.1045p pd=0.93u as=0.187p ps=1.78u w=0.55u l=0.13u
X221 sg13cmos5l_a21oi_1_15.Y sg13cmos5l_a21oi_1_2.B1 a_16949_12508# VDD.t83 sg13_lv_pmos ad=0.3808p pd=2.92u as=0.2128p ps=1.5u w=1.12u l=0.13u
X222 a_20580_9952# a_21099_9959# a_21839_10309# VSS.t546 sg13_lv_nmos ad=0.3473p pd=2.71u as=0.12665p ps=1.145u w=0.74u l=0.13u
X223 VDD.t781 a_18778_6130# a_18497_6352# VDD.t2 sg13_lv_pmos ad=0.1523p pd=1.38u as=0.34p ps=2.68u w=1u l=0.5u
X224 sg13cmos5l_a21oi_1_2.A2 sg13cmos5l_nand4_1_18.D VDD.t971 VDD.t83 sg13_lv_pmos ad=0.2128p pd=1.5u as=0.3808p ps=2.92u w=1.12u l=0.13u
X225 sg13cmos5l_nor3_1_6.Y sg13cmos5l_a21oi_1_27.A1 a_9879_12972# VDD.t83 sg13_lv_pmos ad=0.3808p pd=2.92u as=0.2128p ps=1.5u w=1.12u l=0.13u
X226 a_22126_3327# a_22241_3328# VSS.t210 VSS.t2436 sg13_lv_nmos ad=0.1428p pd=1.52u as=0.1426p ps=1.16u w=0.42u l=0.5u
X227 VDD.t1349 a_11180_15198# sg13cmos5l_nor2b_1_1.A VDD.t16 sg13_lv_pmos ad=0.2114p pd=1.54u as=0.42p ps=2.99u w=1.12u l=0.13u
X228 sg13cmos5l_o21ai_1_28.Y sg13cmos5l_nand2_1_15.B a_12504_15552# VDD.t16 sg13_lv_pmos ad=0.2128p pd=1.5u as=0.2128p ps=1.5u w=1.12u l=0.15u
X229 a_6730_11428# a_7173_11471# a_7113_11507# VDD.t0 sg13_lv_pmos ad=79.8f pd=0.8u as=63f ps=0.72u w=0.42u l=0.13u
X230 VDD.t1119 a_19246_6351# sg13cmos5l_dfrbpq_1_1.D VDD.t2 sg13_lv_pmos ad=0.2254p pd=1.53u as=0.4256p ps=3u w=1.12u l=0.13u
X231 a_20974_16434# a_20716_16434# VSS.t863 VSS.t1191 sg13_lv_nmos ad=0.1428p pd=1.52u as=79.8f ps=0.8u w=0.42u l=0.13u
X232 VSS.t79 sg13cmos5l_buf_1_66.X a_12886_15230# VSS.t836 sg13_lv_nmos ad=0.1406p pd=1.12u as=0.2516p ps=2.16u w=0.74u l=0.15u
X233 a_8879_15238# a_8844_15424# sg13cmos5l_nand2_1_11.B VSS.t320 sg13_lv_nmos ad=0.1406p pd=1.12u as=0.2516p ps=2.16u w=0.74u l=0.13u
X234 a_16664_13730# sg13cmos5l_nand4_1_1.C a_16562_13730# VSS.t128 sg13_lv_nmos ad=0.1406p pd=1.12u as=0.1406p ps=1.12u w=0.74u l=0.13u
X235 VDD.t45 VSS.t1981 VDD.t44 VDD.t13 sg13_lv_pmos ad=0.34p pd=2.68u as=0 ps=0 w=1u l=1u
X236 a_13102_5850# a_12844_5850# VSS.t825 VSS.t824 sg13_lv_nmos ad=0.1428p pd=1.52u as=79.8f ps=0.8u w=0.42u l=0.13u
X237 VDD.t933 sg13cmos5l_mux2_1_0.S a_8337_13362# VDD.t83 sg13_lv_pmos ad=0.1596p pd=1.22u as=0.1596p ps=1.22u w=0.84u l=0.13u
X238 VDD.t2028 VSS.t1933 VDD.t944 VDD.t2 sg13_lv_pmos ad=0.19p pd=1.38u as=0 ps=0 w=1u l=1u
X239 VSS.t264 a_20997_8447# a_21099_8447# VSS.t903 sg13_lv_nmos ad=5.26052p pd=34.445u as=0.2516p ps=2.16u w=0.74u l=0.13u
X240 a_10510_19287# a_10625_19286# VDD.t1522 VDD.t231 sg13_lv_pmos ad=0.34p pd=2.68u as=0.2254p ps=1.53u w=1u l=0.5u
X241 sg13cmos5l_buf_1_20.A sg13cmos5l_dfrbpq_1_24.Q VSS.t196 VSS.t149 sg13_lv_nmos ad=0.1694p pd=1.21u as=0.1463p ps=1.15u w=0.77u l=0.13u
X242 VDD.t852 sg13cmos5l_o21ai_1_7.B1 a_4744_19808# VDD.t270 sg13_lv_pmos ad=0.2114p pd=1.54u as=0.2856p ps=2.36u w=0.84u l=0.13u
X243 a_7822_19959# a_7937_19960# VDD.t2216 VDD.t270 sg13_lv_pmos ad=0.34p pd=2.68u as=0.2254p ps=1.53u w=1u l=0.5u
X244 sg13cmos5l_inv_1_35.Y sg13cmos5l_dfrbpq_1_41.CLK VDD.t1099 VDD.t310 sg13_lv_pmos ad=0.3808p pd=2.92u as=0.3808p ps=2.92u w=1.12u l=0.13u
X245 a_19923_13748# sg13cmos5l_a21oi_1_13.A2 VSS.t1353 VSS.t128 sg13_lv_nmos ad=0.1406p pd=1.12u as=0.2516p ps=2.16u w=0.74u l=0.13u
X246 a_18398_13338# sg13cmos5l_nand4_1_15.B a_18296_13338# VSS.t128 sg13_lv_nmos ad=0.1406p pd=1.12u as=0.1406p ps=1.12u w=0.74u l=0.13u
X247 sg13cmos5l_a22oi_1_2.Y sg13cmos5l_or2_1_1.X a_12414_7656# VSS.t750 sg13_lv_nmos ad=0.2664p pd=1.46u as=96.2f ps=1u w=0.74u l=0.13u
X248 VDD.t537 VSS.t1058 VDD.t536 VDD.t0 sg13_lv_pmos ad=0.34p pd=2.68u as=0 ps=0 w=1u l=1u
X249 sg13cmos5l_nand2_1_13.A a_9558_13790# VSS.t196 VSS.t66 sg13_lv_nmos ad=0.2516p pd=2.16u as=0.1426p ps=1.16u w=0.74u l=0.13u
X250 VSS.t702 a_7162_6888# a_6881_7190# VSS.t2380 sg13_lv_nmos ad=79.8f pd=0.8u as=0.1428p ps=1.52u w=0.42u l=0.5u
X251 VDD.t279 VSS.t1695 VDD.t278 VDD.t19 sg13_lv_pmos ad=0.19p pd=1.38u as=0 ps=0 w=1u l=1u
X252 VSS.t1941 VDD.t2451 VSS.t1940 VSS.t1939 sg13_lv_nmos ad=0.1428p pd=1.52u as=0 ps=0 w=0.42u l=1u
X253 VSS.t97 sg13cmos5l_nand2b_1_0.B sg13cmos5l_nor2_1_0.Y VSS.t973 sg13_lv_nmos ad=0.2516p pd=2.16u as=0.1406p ps=1.12u w=0.74u l=0.13u
X254 a_19930_12936# sg13cmos5l_dfrbpq_1_28.Q VSS.t1059 VSS.t128 sg13_lv_nmos ad=0.1428p pd=1.52u as=79.8f ps=0.8u w=0.42u l=0.13u
X255 VDD.t2126 a_16188_9150# a_17211_9577# VDD.t52 sg13_lv_pmos ad=0.1563p pd=1.22u as=63f ps=0.72u w=0.42u l=0.13u
X256 VDD.t404 VSS.t1729 VDD.t265 VDD.t83 sg13_lv_pmos ad=0.19p pd=1.38u as=0 ps=0 w=1u l=1u
X257 VDD.t271 VSS.t1605 VDD.t273 VDD.t270 sg13_lv_pmos ad=0.19p pd=1.38u as=0 ps=0 w=1u l=1u
X258 VSS.t1056 a_21838_19959# sg13cmos5l_buf_1_25.A VSS.t1055 sg13_lv_nmos ad=0.1426p pd=1.16u as=0.2516p ps=2.16u w=0.74u l=0.13u
X259 a_17715_13320# sg13cmos5l_nand3_1_8.Y VSS.t129 VSS.t128 sg13_lv_nmos ad=0.1406p pd=1.12u as=0.2516p ps=2.16u w=0.74u l=0.13u
X260 a_8122_10666# sg13cmos5l_dlygate4sd3_1_37.A VDD.t1954 VDD.t0 sg13_lv_pmos ad=0.1428p pd=1.52u as=0.1523p ps=1.38u w=0.42u l=0.13u
X261 a_16068_18271# a_16299_18380# a_15754_18481# VSS.t324 sg13_lv_nmos ad=0.2373p pd=1.97u as=79.8f ps=0.8u w=0.42u l=0.13u
X262 VSS.t1987 VDD.t2412 VSS.t1987 VSS.t2036 sg13_lv_nmos ad=0.1428p pd=1.52u as=0 ps=0 w=0.42u l=1u
X263 VDD.t13 VSS.t1966 VDD.t13 VDD.t13 sg13_lv_pmos ad=0.19p pd=1.38u as=0 ps=0 w=1u l=1u
X264 VDD.t83 a_10895_12287# a_11152_12430# VDD.t83 sg13_lv_pmos ad=2.51485p pd=16.46u as=79.8f ps=0.8u w=0.42u l=0.13u
X265 VDD.t555 VSS.t1966 VDD.t554 VDD.t5 sg13_lv_pmos ad=0.34p pd=2.68u as=0 ps=0 w=1u l=1u
X266 VSS.t56 sg13cmos5l_o21ai_1_18.A2 a_8434_17886# VSS.t2414 sg13_lv_nmos ad=0.1406p pd=1.12u as=0.1406p ps=1.12u w=0.74u l=0.15u
X267 VSS.t279 sg13cmos5l_o21ai_1_0.A2 sg13cmos5l_nor3_1_1.Y VSS.t2591 sg13_lv_nmos ad=0.1463p pd=1.15u as=0.2618p ps=2.22u w=0.77u l=0.13u
X268 a_6201_14607# a_5259_14495# a_5999_14845# VDD.t19 sg13_lv_pmos ad=93.45f pd=0.865u as=0.2048p ps=1.63u w=0.42u l=0.13u
X269 VSS.t1436 sg13cmos5l_a21oi_1_18.B1 sg13cmos5l_dlygate4sd3_1_82.A VSS.t1103 sg13_lv_nmos ad=0.2516p pd=2.16u as=0.1406p ps=1.12u w=0.74u l=0.13u
X270 bn3 a_10696_15272# VSS.t199 VSS.t1310 sg13_lv_nmos ad=0.2886p pd=2.26u as=0.14875p ps=1.16u w=0.74u l=0.13u
X271 sg13cmos5l_dlygate4sd3_1_0.A a_22506_4948# VSS.t22 VSS.t42 sg13_lv_nmos ad=0.2516p pd=2.16u as=0.1406p ps=1.12u w=0.74u l=0.13u
X272 VSS.t1973 VDD.t2434 VSS.t1973 VSS.t1978 sg13_lv_nmos ad=0.1428p pd=1.52u as=0 ps=0 w=0.42u l=1u
X273 a_20294_4650# sg13cmos5l_dfrbpq_1_0.D VDD.t1435 VDD.t5 sg13_lv_pmos ad=79.8f pd=0.8u as=0.1428p ps=1.52u w=0.42u l=0.13u
X274 VDD.t1297 a_15804_7638# a_16827_8065# VDD.t8 sg13_lv_pmos ad=0.1563p pd=1.22u as=63f ps=0.72u w=0.42u l=0.13u
X275 VSS.t180 a_17710_17775# sg13cmos5l_buf_1_54.A VSS.t179 sg13_lv_nmos ad=0.1426p pd=1.16u as=0.2516p ps=2.16u w=0.74u l=0.13u
X276 VSS.t134 sg13cmos5l_nand4_1_5.D a_17730_16362# VSS.t507 sg13_lv_nmos ad=0.2516p pd=2.16u as=0.1406p ps=1.12u w=0.74u l=0.13u
X277 VSS.t1676 VDD.t2538 VSS.t1665 VSS.t1675 sg13_lv_nmos ad=0.1428p pd=1.52u as=0 ps=0 w=0.42u l=1u
X278 sg13cmos5l_a21oi_1_8.A2 sg13cmos5l_nand2_1_6.A a_7738_7294# VSS.t2492 sg13_lv_nmos ad=0.2516p pd=2.16u as=0.1406p ps=1.12u w=0.74u l=0.13u
X279 a_12414_7996# sg13cmos5l_nand2_1_5.Y VDD.t1429 VDD.t8 sg13_lv_pmos ad=0.2744p pd=1.61u as=0.3808p ps=2.92u w=1.12u l=0.13u
X280 sg13cmos5l_dfrbpq_1_41.CLK a_14218_18226# VSS.t113 VSS.t1427 sg13_lv_nmos ad=0.1406p pd=1.12u as=0.1406p ps=1.12u w=0.74u l=0.13u
X281 VSS.t86 a_12987_10318# sg13cmos5l_dfrbpq_1_13.CLK VSS.t1091 sg13_lv_nmos ad=0.1406p pd=1.12u as=0.1406p ps=1.12u w=0.74u l=0.13u
X282 VDD.t28 VSS.t2172 VDD.t1393 VDD.t13 sg13_lv_pmos ad=0.34p pd=2.68u as=0 ps=0 w=1u l=1u
X283 a_17769_6971# a_17412_6928# VDD.t360 VDD.t2 sg13_lv_pmos ad=63f pd=0.72u as=0.1563p ps=1.22u w=0.42u l=0.13u
X284 a_20388_14922# sg13cmos5l_dfrbpq_1_29.D a_20294_14922# VSS.t432 sg13_lv_nmos ad=60.89999f pd=0.71u as=0.1428p ps=1.52u w=0.42u l=0.13u
X285 VSS.t192 a_19930_4618# a_19649_4840# VSS.t191 sg13_lv_nmos ad=79.8f pd=0.8u as=0.1428p ps=1.52u w=0.42u l=0.5u
X286 VDD.t262 VSS.t542 VDD.t261 VDD.t2 sg13_lv_pmos ad=0.34p pd=2.68u as=0 ps=0 w=1u l=1u
X287 a_20997_13701# sg13cmos5l_dfrbpq_1_5.CLK VDD.t19 VDD.t19 sg13_lv_pmos ad=0.4088p pd=2.97u as=2.07625p ps=13.51u w=1.12u l=0.13u
X288 a_14842_9154# sg13cmos5l_nor2b_1_0.B_N VDD.t979 VDD.t52 sg13_lv_pmos ad=0.1428p pd=1.52u as=0.1523p ps=1.38u w=0.42u l=0.13u
X289 VSS.t222 sg13cmos5l_nor3_1_0.Y a_16666_12214# VSS.t723 sg13_lv_nmos ad=0.2516p pd=2.16u as=0.1406p ps=1.12u w=0.74u l=0.13u
X290 VDD.t742 sg13cmos5l_buf_1_14.A a_15592_10736# VDD.t0 sg13_lv_pmos ad=0.2114p pd=1.54u as=0.2856p ps=2.36u w=0.84u l=0.13u
X291 VDD.t1247 a_14517_13880# a_13596_13686# VDD.t19 sg13_lv_pmos ad=0.36237p pd=2.605u as=0.34p ps=2.68u w=1u l=0.13u
X292 VSS.t2193 VDD.t2377 VSS.t2192 VSS.t2191 sg13_lv_nmos ad=0.1428p pd=1.52u as=0 ps=0 w=0.42u l=1u
X293 VDD.t19 a_20997_14495# a_21099_14495# VDD.t19 sg13_lv_pmos ad=2.1916p pd=14.26u as=0.3864p ps=2.93u w=1.12u l=0.13u
X294 a_5626_19738# sg13cmos5l_dfrbpq_1_20.Q VDD.t2214 VDD.t270 sg13_lv_pmos ad=0.1428p pd=1.52u as=0.1523p ps=1.38u w=0.42u l=0.13u
X295 sg13cmos5l_dfrbpq_1_33.Q a_17706_18556# VDD.t859 VDD.t231 sg13_lv_pmos ad=0.3808p pd=2.92u as=0.2128p ps=1.5u w=1.12u l=0.13u
X296 VSS.t22 a_20794_3864# a_20513_4166# VSS.t304 sg13_lv_nmos ad=79.8f pd=0.8u as=0.1428p ps=1.52u w=0.42u l=0.5u
X297 VSS.t1618 VDD.t2555 VSS.t1620 VSS.t1619 sg13_lv_nmos ad=79.8f pd=0.8u as=0 ps=0 w=0.42u l=1u
X298 a_19173_17519# sg13cmos5l_inv_1_31.A VDD.t310 VDD.t310 sg13_lv_pmos ad=0.4088p pd=2.97u as=2.07625p ps=13.51u w=1.12u l=0.13u
X299 a_16002_16754# sg13cmos5l_buf_1_43.X a_15900_16754# VSS.t2581 sg13_lv_nmos ad=0.1406p pd=1.12u as=0.1406p ps=1.12u w=0.74u l=0.13u
X300 VSS.t260 a_6640_9406# a_6289_9263# VSS.t2196 sg13_lv_nmos ad=79.8f pd=0.8u as=0.1428p ps=1.52u w=0.42u l=0.13u
X301 a_9716_15202# sg13cmos5l_buf_1_65.A VSS.t46 VSS.t1548 sg13_lv_nmos ad=0.187p pd=1.78u as=0.17255p ps=1.25u w=0.55u l=0.13u
X302 sg13cmos5l_dlygate4sd3_1_71.X a_19830_12278# VSS.t7 VSS.t1045 sg13_lv_nmos ad=0.2516p pd=2.16u as=0.1426p ps=1.16u w=0.74u l=0.13u
X303 a_7498_18988# a_7941_19031# a_7881_19067# VDD.t231 sg13_lv_pmos ad=79.8f pd=0.8u as=63f ps=0.72u w=0.42u l=0.13u
X304 VDD.t669 sg13cmos5l_o21ai_1_22.Y a_9848_18262# VDD.t231 sg13_lv_pmos ad=0.1523p pd=1.38u as=0.1428p ps=1.52u w=0.42u l=0.13u
X305 VSS.t850 sg13cmos5l_buf_1_4.A sg13cmos5l_inv_1_4.Y VSS.t849 sg13_lv_nmos ad=0.2516p pd=2.16u as=0.2516p ps=2.16u w=0.74u l=0.13u
X306 VSS.t1971 VDD.t2437 VSS.t1966 VSS.t1970 sg13_lv_nmos ad=0.1428p pd=1.52u as=0 ps=0 w=0.42u l=1u
X307 a_1690_15202# start VSS.t230 VSS.t608 sg13_lv_nmos ad=0.1428p pd=1.52u as=79.8f ps=0.8u w=0.42u l=0.13u
X308 VSS.t1999 VDD.t2406 VSS.t1999 VSS.t2050 sg13_lv_nmos ad=79.8f pd=0.8u as=0 ps=0 w=0.42u l=1u
X309 a_20974_6351# a_21089_6352# VDD.t1163 VDD.t2 sg13_lv_pmos ad=0.34p pd=2.68u as=0.2254p ps=1.53u w=1u l=0.5u
X310 a_19450_18226# sg13cmos5l_a21oi_1_24.Y VDD.t671 VDD.t231 sg13_lv_pmos ad=0.1428p pd=1.52u as=0.1523p ps=1.38u w=0.42u l=0.13u
X311 VDD.t300 VSS.t1973 VDD.t299 VDD.t13 sg13_lv_pmos ad=0.34p pd=2.68u as=0 ps=0 w=1u l=1u
X312 a_18564_17946# sg13cmos5l_dfrbpq_1_39.D a_18470_17946# VSS.t179 sg13_lv_nmos ad=60.89999f pd=0.71u as=0.1428p ps=1.52u w=0.42u l=0.13u
X313 VDD.t870 sg13cmos5l_o21ai_1_5.A2 a_8332_15996# VDD.t16 sg13_lv_pmos ad=0.4032p pd=2.96u as=0.1176p ps=1.33u w=1.12u l=0.13u
X314 VDD.t582 VSS.t1918 VDD.t581 VDD.t2 sg13_lv_pmos ad=0.19p pd=1.38u as=0 ps=0 w=1u l=1u
X315 a_22005_16043# a_21063_16083# a_21866_16276# VSS.t647 sg13_lv_nmos ad=79.8f pd=0.8u as=0.2373p ps=1.97u w=0.42u l=0.13u
X316 sg13cmos5l_dfrbpq_1_41.CLK a_14218_18226# VSS.t113 VSS.t1423 sg13_lv_nmos ad=0.1406p pd=1.12u as=0.2516p ps=2.16u w=0.74u l=0.13u
X317 VDD.t281 VSS.t1695 VDD.t280 VDD.t83 sg13_lv_pmos ad=0.19p pd=1.38u as=0 ps=0 w=1u l=1u
X318 a_11372_10662# sg13cmos5l_buf_1_20.A VSS.t103 VSS.t202 sg13_lv_nmos ad=0.187p pd=1.78u as=0.14875p ps=1.16u w=0.55u l=0.13u
X319 a_13814_8828# sg13cmos5l_a22oi_1_0.B2 sg13cmos5l_nor3_1_2.B VSS.t767 sg13_lv_nmos ad=0.13875p pd=1.115u as=0.2664p ps=1.46u w=0.74u l=0.13u
X320 VDD.t2033 a_7498_18226# sg13cmos5l_dfrbpq_1_19.CLK VDD.t231 sg13_lv_pmos ad=0.2128p pd=1.5u as=0.2128p ps=1.5u w=1.12u l=0.13u
X321 sg13cmos5l_inv_1_31.A a_19035_16750# VDD.t917 VDD.t310 sg13_lv_pmos ad=0.2128p pd=1.5u as=0.2128p ps=1.5u w=1.12u l=0.13u
X322 a_5604_12976# a_5578_12940# VSS.t182 VSS.t1180 sg13_lv_nmos ad=0.2516p pd=2.16u as=0.1626p ps=1.415u w=0.74u l=0.13u
X323 a_7378_16374# sg13cmos5l_o21ai_1_5.A2.t1 VSS.t375 VSS.t385 sg13_lv_nmos ad=0.2516p pd=2.16u as=0.1406p ps=1.12u w=0.74u l=0.15u
X324 VDD.t905 a_16172_14448# sg13cmos5l_nand4_1_18.D VDD.t19 sg13_lv_pmos ad=0.2114p pd=1.54u as=0.42p ps=2.99u w=1.12u l=0.13u
X325 VDD.t1501 sg13cmos5l_dfrbpq_1_24.RESET_B a_4906_18988# VDD.t231 sg13_lv_pmos ad=0.1563p pd=1.22u as=0.147p ps=1.54u w=0.42u l=0.13u
X326 sg13cmos5l_dlygate4sd3_1_56.X a_10230_18326# VSS.t58 VSS.t184 sg13_lv_nmos ad=0.2516p pd=2.16u as=0.1426p ps=1.16u w=0.74u l=0.13u
X327 a_14517_13880# a_13575_13940# a_14378_13880# VSS.t207 sg13_lv_nmos ad=79.8f pd=0.8u as=0.2373p ps=1.97u w=0.42u l=0.13u
X328 VSS.t1722 VDD.t2512 VSS.t1721 VSS.t1720 sg13_lv_nmos ad=0.1428p pd=1.52u as=0 ps=0 w=0.42u l=1u
X329 VSS.t26 sg13cmos5l_buf_1_7.X a_20388_7362# VSS.t34 sg13_lv_nmos ad=0.1626p pd=1.415u as=60.89999f ps=0.71u w=0.42u l=0.13u
X330 a_18095_19847# a_17253_19749# a_18001_19847# VSS.t2432 sg13_lv_nmos ad=0.12665p pd=1.145u as=0.1428p ps=1.52u w=0.42u l=0.13u
X331 sg13cmos5l_nand2_1_12.Y sg13cmos5l_nand2_1_12.A a_12058_16750# VSS.t1519 sg13_lv_nmos ad=0.2516p pd=2.16u as=0.1406p ps=1.12u w=0.74u l=0.13u
X332 VSS.t15 sg13cmos5l_buf_1_16.A sg13cmos5l_a21oi_1_6.Y VSS.t1402 sg13_lv_nmos ad=0.2516p pd=2.16u as=0.1406p ps=1.12u w=0.74u l=0.13u
X333 sg13cmos5l_a21oi_1_23.A2 sg13cmos5l_nand4_1_16.D VDD.t1190 VDD.t19 sg13_lv_pmos ad=0.2128p pd=1.5u as=0.3808p ps=2.92u w=1.12u l=0.13u
X334 a_7282_13410# sg13cmos5l_dfrbpq_1_24.RESET_B VSS.t182 VSS.t149 sg13_lv_nmos ad=37.8f pd=0.6u as=79.8f ps=0.8u w=0.42u l=0.13u
X335 sg13cmos5l_a21oi_1_7.A2 sg13cmos5l_nand4_1_18.D VDD.t977 VDD.t83 sg13_lv_pmos ad=0.2128p pd=1.5u as=0.3808p ps=2.92u w=1.12u l=0.13u
X336 VSS.t37 a_22522_7642# a_22241_7864# VSS.t667 sg13_lv_nmos ad=79.8f pd=0.8u as=0.1428p ps=1.52u w=0.42u l=0.5u
X337 a_21838_19959# a_21953_19960# VDD.t1534 VDD.t270 sg13_lv_pmos ad=0.34p pd=2.68u as=0.2254p ps=1.53u w=1u l=0.5u
X338 sg13cmos5l_dlygate4sd3_1_45.X a_8118_13790# VSS.t67 VSS.t66 sg13_lv_nmos ad=0.2516p pd=2.16u as=0.1426p ps=1.16u w=0.74u l=0.13u
X339 VDD.t1291 a_8206_9375# sg13cmos5l_dlygate4sd3_1_38.X VDD.t52 sg13_lv_pmos ad=0.2254p pd=1.53u as=0.4256p ps=3u w=1.12u l=0.13u
X340 a_22041_8559# a_21099_8447# a_21839_8797# VDD.t8 sg13_lv_pmos ad=93.45f pd=0.865u as=0.2048p ps=1.63u w=0.42u l=0.13u
X341 VDD.t915 a_19035_16750# sg13cmos5l_inv_1_31.A VDD.t310 sg13_lv_pmos ad=0.2128p pd=1.5u as=0.2128p ps=1.5u w=1.12u l=0.13u
X342 a_4646_19458# sg13cmos5l_dlygate4sd3_1_51.X VDD.t1489 VDD.t231 sg13_lv_pmos ad=79.8f pd=0.8u as=0.1428p ps=1.52u w=0.42u l=0.13u
X343 VSS.t56 sg13cmos5l_buf_1_65.A a_8830_17874# VSS.t1546 sg13_lv_nmos ad=0.18575p pd=1.26u as=0.187p ps=1.78u w=0.55u l=0.13u
X344 a_17412_6928# a_17931_6935# a_18671_7285# VSS.t18 sg13_lv_nmos ad=0.3473p pd=2.71u as=0.12665p ps=1.145u w=0.74u l=0.13u
X345 a_16376_15242# sg13cmos5l_and2_1_3.X a_16274_15242# VSS.t1418 sg13_lv_nmos ad=0.1406p pd=1.12u as=0.1406p ps=1.12u w=0.74u l=0.13u
X346 a_17240_13730# sg13cmos5l_nand4_1_1.C a_17138_13730# VSS.t128 sg13_lv_nmos ad=0.1406p pd=1.12u as=0.1406p ps=1.12u w=0.74u l=0.13u
X347 a_7310_12400# sg13cmos5l_a21oi_1_4.A1 a_7482_12214# VSS.t145 sg13_lv_nmos ad=0.1628p pd=1.18u as=0.3367p ps=1.65u w=0.74u l=0.13u
X348 VDD.t49 VSS.t1981 VDD.t48 VDD.t13 sg13_lv_pmos ad=0.34p pd=2.68u as=0 ps=0 w=1u l=1u
X349 VSS.t759 a_10878_7180# sg13cmos5l_nor2_1_2.B VSS.t2630 sg13_lv_nmos ad=0.1447p pd=1.15u as=0.3552p ps=2.44u w=0.74u l=0.13u
X350 sg13cmos5l_nand2_1_5.Y sg13cmos5l_nand3_1_3.Y VDD.t1452 VDD.t8 sg13_lv_pmos ad=0.2128p pd=1.5u as=0.3808p ps=2.92u w=1.12u l=0.13u
X351 VDD.t676 a_7334_14484# a_7446_14508# VDD.t19 sg13_lv_pmos ad=0.2254p pd=1.53u as=0.34p ps=2.68u w=1u l=0.5u
X352 VSS.t1059 sg13cmos5l_a21oi_1_18.B1 sg13cmos5l_a21oi_1_13.Y VSS.t128 sg13_lv_nmos ad=0.2516p pd=2.16u as=0.1406p ps=1.12u w=0.74u l=0.13u
X353 VDD.t2361 a_12987_12214# sg13cmos5l_buf_8_2.A.t0 VDD.t83 sg13_lv_pmos ad=0.2128p pd=1.5u as=0.2128p ps=1.5u w=1.12u l=0.13u
X354 a_15322_16714# sg13cmos5l_dfrbpq_1_38.Q VSS.t373 VSS.t1181 sg13_lv_nmos ad=0.1428p pd=1.52u as=79.8f ps=0.8u w=0.42u l=0.13u
X355 sg13cmos5l_dlygate4sd3_1_18.A sg13cmos5l_a21oi_1_2.B1 a_17429_12508# VDD.t83 sg13_lv_pmos ad=0.3808p pd=2.92u as=0.2128p ps=1.5u w=1.12u l=0.13u
X356 a_12826_9154# sg13cmos5l_nor2_1_0.Y VDD.t2277 VDD.t52 sg13_lv_pmos ad=0.1428p pd=1.52u as=0.1523p ps=1.38u w=0.42u l=0.13u
X357 a_18634_10921# a_19077_10677# a_18374_10698# VSS.t589 sg13_lv_nmos ad=79.8f pd=0.8u as=0.1296p ps=1.52u w=0.42u l=0.13u
X358 VSS.t571 a_10771_9380# sg13cmos5l_a21o_1_0.X VSS.t1043 sg13_lv_nmos ad=0.15745p pd=1.175u as=0.2351p ps=2.16u w=0.74u l=0.13u
X359 VSS.t1127 sg13cmos5l_dfrbpq_1_24.RESET_B a_7332_19458# VSS.t1134 sg13_lv_nmos ad=0.1626p pd=1.415u as=60.89999f ps=0.71u w=0.42u l=0.13u
X360 VDD.t726 sg13cmos5l_buf_1_25.A a_12040_15272# VDD.t16 sg13_lv_pmos ad=0.2114p pd=1.54u as=0.2856p ps=2.36u w=0.84u l=0.13u
X361 VSS.t291 VDD.t2411 VSS.t291 VSS.t2038 sg13_lv_nmos ad=0.1428p pd=1.52u as=0 ps=0 w=0.42u l=1u
X362 sg13cmos5l_mux2_1_0.A1 a_12381_13912# VDD.t644 VDD.t19 sg13_lv_pmos ad=0.2128p pd=1.5u as=0.3808p ps=2.92u w=1.12u l=0.13u
X363 a_14724_6480# a_14698_6385# VSS.t206 VSS.t205 sg13_lv_nmos ad=0.2516p pd=2.16u as=0.1626p ps=1.415u w=0.74u l=0.13u
X364 VDD.t2167 sg13cmos5l_nand3b_1_1.Y a_8060_17488# VDD.t310 sg13_lv_pmos ad=0.3808p pd=2.92u as=0.2128p ps=1.5u w=1.12u l=0.15u
X365 VSS.t279 a_12512_5699# sg13cmos5l_dfrbpq_1_47.Q VSS.t2411 sg13_lv_nmos ad=0.1406p pd=1.12u as=0.2516p ps=2.16u w=0.74u l=0.13u
X366 VDD.t1863 sg13cmos5l_o21ai_1_23.B1 sg13cmos5l_o21ai_1_28.B1 VDD.t16 sg13_lv_pmos ad=0.3808p pd=2.92u as=0.2128p ps=1.5u w=1.12u l=0.15u
X367 a_14842_11424# sg13cmos5l_nor2b_1_0.B_N VDD.t744 VDD.t0 sg13_lv_pmos ad=0.1428p pd=1.52u as=0.1523p ps=1.38u w=0.42u l=0.13u
X368 sg13cmos5l_nand2_1_2.Y sg13cmos5l_nand3_1_2.A a_16090_10702# VSS.t1351 sg13_lv_nmos ad=0.2516p pd=2.16u as=0.1406p ps=1.12u w=0.74u l=0.13u
X369 VSS.t105 a_13936_19262# a_13585_19381# VSS.t426 sg13_lv_nmos ad=79.8f pd=0.8u as=0.1428p ps=1.52u w=0.42u l=0.13u
X370 VDD.t912 sg13cmos5l_buf_8_2.A.t5 a_19035_16750# VDD.t310 sg13_lv_pmos ad=0.2128p pd=1.5u as=0.2128p ps=1.5u w=1.12u l=0.13u
X371 a_5546_15532# sg13cmos5l_a21oi_1_27.B1 VDD.t2054 VDD.t16 sg13_lv_pmos ad=0.1176p pd=1.33u as=0.4032p ps=2.96u w=1.12u l=0.13u
X372 VDD.t244 VSS.t1830 VDD.t243 VDD.t52 sg13_lv_pmos ad=0.19p pd=1.38u as=0 ps=0 w=1u l=1u
X373 a_5028_14909# a_5259_14495# a_4714_14452# VSS.t491 sg13_lv_nmos ad=0.2373p pd=1.97u as=79.8f ps=0.8u w=0.42u l=0.13u
X374 a_20868_14909# a_20580_14488# a_20806_14909# VSS.t581 sg13_lv_nmos ad=0.1428p pd=1.52u as=37.8f ps=0.6u w=0.42u l=0.13u
X375 VDD.t85 VSS.t344 VDD.t84 VDD.t83 sg13_lv_pmos ad=0.19p pd=1.38u as=0 ps=0 w=1u l=1u
X376 VSS.t291 VDD.t2409 VSS.t291 VSS.t2043 sg13_lv_nmos ad=79.8f pd=0.8u as=0 ps=0 w=0.42u l=1u
X377 a_16713_5459# a_16356_5416# VDD.t378 VDD.t5 sg13_lv_pmos ad=63f pd=0.72u as=0.1563p ps=1.22u w=0.42u l=0.13u
X378 sg13cmos5l_dfrbpq_1_25.Q a_6858_19020# VSS.t1132 VSS.t1299 sg13_lv_nmos ad=0.2516p pd=2.16u as=0.1406p ps=1.12u w=0.74u l=0.13u
X379 VSS.t136 a_17434_14448# a_17153_14750# VSS.t139 sg13_lv_nmos ad=79.8f pd=0.8u as=0.1428p ps=1.52u w=0.42u l=0.5u
X380 VDD.t695 sg13cmos5l_nand2_1_18.A a_13208_11501# VDD.t0 sg13_lv_pmos ad=0.1523p pd=1.38u as=0.1428p ps=1.52u w=0.42u l=0.13u
X381 a_22096_11702# a_21839_11821# a_22258_11898# VSS.t16 sg13_lv_nmos ad=0.1428p pd=1.52u as=37.8f ps=0.6u w=0.42u l=0.13u
X382 a_16078_9501# a_15820_9186# VDD.t52 VDD.t52 sg13_lv_pmos ad=93.45f pd=0.865u as=1.8716p ps=12.115u w=0.42u l=0.13u
X383 VDD.t185 VSS.t2177 VDD.t580 VDD.t13 sg13_lv_pmos ad=0.34p pd=2.68u as=0 ps=0 w=1u l=1u
X384 a_13690_16714# sg13cmos5l_o21ai_1_24.Y VSS.t204 VSS.t1516 sg13_lv_nmos ad=0.1428p pd=1.52u as=79.8f ps=0.8u w=0.42u l=0.13u
X385 VDD.t2363 a_12987_12214# sg13cmos5l_buf_8_2.A.t0 VDD.t83 sg13_lv_pmos ad=0.2128p pd=1.5u as=0.2128p ps=1.5u w=1.12u l=0.13u
X386 a_14155_8784# sg13cmos5l_inv_1_18.Y a_14061_8784# VSS.t2391 sg13_lv_nmos ad=0.1216p pd=1.02u as=0.2176p ps=1.96u w=0.64u l=0.13u
X387 VSS.t455 a_22522_17472# a_22241_17774# VSS.t225 sg13_lv_nmos ad=79.8f pd=0.8u as=0.1428p ps=1.52u w=0.42u l=0.5u
X388 sg13cmos5l_a21oi_1_25.A2 sg13cmos5l_buf_1_43.X VDD.t1637 VDD.t310 sg13_lv_pmos ad=0.2128p pd=1.5u as=0.2128p ps=1.5u w=1.12u l=0.13u
X389 VSS.t1722 VDD.t2523 VSS.t1721 VSS.t1720 sg13_lv_nmos ad=0.1428p pd=1.52u as=0 ps=0 w=0.42u l=1u
X390 a_20794_3864# sg13cmos5l_dlygate4sd3_1_4.A VDD.t797 VDD.t13 sg13_lv_pmos ad=0.1428p pd=1.52u as=0.1523p ps=1.38u w=0.42u l=0.13u
X391 sg13cmos5l_a21oi_1_20.Y sg13cmos5l_inv_1_16.Y a_16563_14832# VSS.t1464 sg13_lv_nmos ad=0.1406p pd=1.12u as=0.1406p ps=1.12u w=0.74u l=0.13u
X392 VSS.t571 VDD.t2476 VSS.t571 VSS.t1855 sg13_lv_nmos ad=0.1428p pd=1.52u as=0 ps=0 w=0.42u l=1u
X393 a_10172_19000# sg13cmos5l_nor2_1_10.Y sg13cmos5l_o21ai_1_15.B1 VDD.t231 sg13_lv_pmos ad=0.2128p pd=1.5u as=0.2128p ps=1.5u w=1.12u l=0.15u
X394 VSS.t136 a_16172_14448# sg13cmos5l_nand4_1_18.D VSS.t1513 sg13_lv_nmos ad=0.14875p pd=1.16u as=0.2886p ps=2.26u w=0.74u l=0.13u
X395 VSS.t2005 VDD.t2421 VSS.t2005 VSS.t2007 sg13_lv_nmos ad=0.1428p pd=1.52u as=0 ps=0 w=0.42u l=1u
X396 VSS.t1849 VDD.t2479 VSS.t1215 VSS.t88 sg13_lv_nmos ad=79.8f pd=0.8u as=0 ps=0 w=0.42u l=1u
X397 a_8714_20068# sg13cmos5l_a21oi_1_27.B1 VDD.t2051 VDD.t270 sg13_lv_pmos ad=0.1176p pd=1.33u as=0.4032p ps=2.96u w=1.12u l=0.13u
X398 VSS.t1155 sg13cmos5l_nor2_1_10.Y a_10066_19398# VSS.t1154 sg13_lv_nmos ad=0.1406p pd=1.12u as=0.1406p ps=1.12u w=0.74u l=0.15u
X399 a_12777_19067# a_12420_19024# VDD.t893 VDD.t231 sg13_lv_pmos ad=63f pd=0.72u as=0.1563p ps=1.22u w=0.42u l=0.13u
X400 VSS.t2002 sg13cmos5l_o21ai_1_0.A2 a_13042_4646# VSS.t2590 sg13_lv_nmos ad=0.1406p pd=1.12u as=0.1406p ps=1.12u w=0.74u l=0.15u
X401 VDD.t1246 a_22522_6130# a_22241_6352# VDD.t2 sg13_lv_pmos ad=0.1523p pd=1.38u as=0.34p ps=2.68u w=1u l=0.5u
X402 a_17316_8440# a_17835_8447# a_18575_8797# VSS.t488 sg13_lv_nmos ad=0.3473p pd=2.71u as=0.12665p ps=1.145u w=0.74u l=0.13u
X403 a_16578_16754# sg13cmos5l_buf_1_43.X a_16476_16754# VSS.t2582 sg13_lv_nmos ad=0.1406p pd=1.12u as=0.1406p ps=1.12u w=0.74u l=0.13u
X404 VDD.t1709 sg13cmos5l_nand3_1_2.A sg13cmos5l_nand2_1_2.Y VDD.t0 sg13_lv_pmos ad=0.3808p pd=2.92u as=0.2128p ps=1.5u w=1.12u l=0.13u
X405 a_12614_6166# a_12344_6166# VSS.t279 VSS.t2393 sg13_lv_nmos ad=0.1428p pd=1.52u as=79.8f ps=0.8u w=0.42u l=0.5u
X406 sg13cmos5l_dlygate4sd3_1_97.X a_13014_17532# VDD.t1087 VDD.t310 sg13_lv_pmos ad=0.4256p pd=3u as=0.2254p ps=1.53u w=1.12u l=0.13u
X407 VSS.t248 a_11759_10309# a_12426_9948# VSS.t2501 sg13_lv_nmos ad=0.1406p pd=1.12u as=0.2516p ps=2.16u w=0.74u l=0.13u
X408 VDD.t83 a_10053_12189# a_10155_12332# VDD.t83 sg13_lv_pmos ad=2.51485p pd=16.46u as=0.3864p ps=2.93u w=1.12u l=0.13u
X409 VDD.t1458 a_19738_9912# a_19457_10214# VDD.t52 sg13_lv_pmos ad=0.1523p pd=1.38u as=0.34p ps=2.68u w=1u l=0.5u
X410 sg13cmos5l_nand2b_1_3.Y a_10365_7194# VDD.t1288 VDD.t2 sg13_lv_pmos ad=0.2128p pd=1.5u as=0.3808p ps=2.92u w=1.12u l=0.13u
X411 a_14244_20088# a_14218_19993# VSS.t105 VSS.t104 sg13_lv_nmos ad=0.2516p pd=2.16u as=0.1626p ps=1.415u w=0.74u l=0.13u
X412 VSS.t1973 VDD.t2436 VSS.t1973 VSS.t1974 sg13_lv_nmos ad=0.1428p pd=1.52u as=0 ps=0 w=0.42u l=1u
X413 a_16476_13338# sg13cmos5l_a21oi_1_4.A2 sg13cmos5l_nand3_1_8.Y VSS.t128 sg13_lv_nmos ad=0.1406p pd=1.12u as=0.2516p ps=2.16u w=0.74u l=0.13u
X414 VSS.t596 a_19919_10775# a_20586_10996# VSS.t2445 sg13_lv_nmos ad=0.1406p pd=1.12u as=0.2516p ps=2.16u w=0.74u l=0.13u
X415 VDD.t618 VSS.t1973 VDD.t617 VDD.t13 sg13_lv_pmos ad=0.34p pd=2.68u as=0 ps=0 w=1u l=1u
X416 sg13cmos5l_nor2b_1_2.Y a_12430_6980# VSS.t101 VSS.t100 sg13_lv_nmos ad=0.1406p pd=1.12u as=0.17255p ps=1.25u w=0.74u l=0.13u
X417 VDD.t645 a_5998_17775# sg13cmos5l_dfrbpq_1_23.D VDD.t310 sg13_lv_pmos ad=0.2254p pd=1.53u as=0.4256p ps=3u w=1.12u l=0.13u
X418 a_17028_15552# a_17547_15356# a_18287_15311# VSS.t392 sg13_lv_nmos ad=0.3473p pd=2.71u as=0.12665p ps=1.145u w=0.74u l=0.13u
X419 VDD.t1894 VSS.t1923 VDD.t4 VDD.t2 sg13_lv_pmos ad=0.19p pd=1.38u as=0 ps=0 w=1u l=1u
X420 a_4932_19024# a_5451_19031# a_6191_19381# VSS.t1171 sg13_lv_nmos ad=0.3473p pd=2.71u as=0.12665p ps=1.145u w=0.74u l=0.13u
X421 VDD.t1308 sg13cmos5l_buf_1_45.X.t7 a_13478_17946# VDD.t310 sg13_lv_pmos ad=0.36237p pd=2.605u as=79.8f ps=0.8u w=0.42u l=0.13u
X422 VDD.t16 a_15023_16357# a_15280_16238# VDD.t16 sg13_lv_pmos ad=2.07625p pd=13.51u as=79.8f ps=0.8u w=0.42u l=0.13u
X423 VSS.t380 a_12496_18478# a_12145_18335# VSS.t1151 sg13_lv_nmos ad=79.8f pd=0.8u as=0.1428p ps=1.52u w=0.42u l=0.13u
X424 a_22005_16043# sg13cmos5l_buf_1_15.A.t3 VDD.t1632 VDD.t16 sg13_lv_pmos ad=0.147p pd=1.54u as=0.1563p ps=1.22u w=0.42u l=0.13u
X425 a_7214_13768# sg13cmos5l_a21o_1_2.A1 a_6835_13916# VSS.t66 sg13_lv_nmos ad=81.6f pd=0.895u as=0.1216p ps=1.02u w=0.64u l=0.13u
X426 VDD.t1410 a_14446_11727# sg13cmos5l_nand3b_1_0.C VDD.t0 sg13_lv_pmos ad=0.2254p pd=1.53u as=0.4256p ps=3u w=1.12u l=0.13u
X427 a_5350_9199# sg13cmos5l_dfrbpq_1_13.RESET_B VSS.t1208 VSS.t88 sg13_lv_nmos ad=37.8f pd=0.6u as=0.1701p ps=1.65u w=0.42u l=0.13u
X428 a_10389_16258# sg13cmos5l_buf_1_65.A VSS.t54 VSS.t1549 sg13_lv_nmos ad=0.187p pd=1.78u as=0.18575p ps=1.26u w=0.55u l=0.13u
X429 VDD.t1954 a_8122_10666# a_7841_10888# VDD.t0 sg13_lv_pmos ad=0.1523p pd=1.38u as=0.34p ps=2.68u w=1u l=0.5u
X430 VSS.t269 a_20997_4629# a_21099_4772# VSS.t274 sg13_lv_nmos ad=17.54618p pd=0.11546m as=0.2516p ps=2.16u w=0.74u l=0.13u
X431 a_9156_5850# sg13cmos5l_dfrbpq_1_13.D a_9062_5850# VSS.t2594 sg13_lv_nmos ad=60.89999f pd=0.71u as=0.1428p ps=1.52u w=0.42u l=0.13u
X432 a_3886_17061# a_3628_16746# VDD.t310 VDD.t310 sg13_lv_pmos ad=93.45f pd=0.865u as=2.1916p ps=14.26u w=0.42u l=0.13u
X433 VDD.t1136 clk a_12987_12214# VDD.t83 sg13_lv_pmos ad=0.2128p pd=1.5u as=0.3808p ps=2.92u w=1.12u l=0.13u
X434 VSS.t850 VDD.t2399 VSS.t850 VSS.t2063 sg13_lv_nmos ad=0.1428p pd=1.52u as=0 ps=0 w=0.42u l=1u
X435 a_14786_5850# sg13cmos5l_buf_1_13.A VSS.t206 VSS.t2368 sg13_lv_nmos ad=60.89999f pd=0.71u as=0.1626p ps=1.415u w=0.42u l=0.13u
X436 a_7989_6320# a_7047_6380# a_7850_6320# VSS.t847 sg13_lv_nmos ad=79.8f pd=0.8u as=0.2373p ps=1.97u w=0.42u l=0.13u
X437 sg13cmos5l_nand2b_1_0.B sg13cmos5l_nand2_1_0.A VDD.t1132 VDD.t8 sg13_lv_pmos ad=0.2128p pd=1.5u as=0.3808p ps=2.92u w=1.12u l=0.13u
X438 VDD.t1492 sg13cmos5l_dfrbpq_1_24.RESET_B a_5318_13410# VDD.t83 sg13_lv_pmos ad=0.36237p pd=2.605u as=79.8f ps=0.8u w=0.42u l=0.13u
X439 a_21350_19020# a_21080_19061# VSS.t1099 VSS.t1098 sg13_lv_nmos ad=0.1428p pd=1.52u as=79.8f ps=0.8u w=0.42u l=0.5u
X440 a_10042_6130# sg13cmos5l_a21oi_1_10.Y VDD.t940 VDD.t2 sg13_lv_pmos ad=0.1428p pd=1.52u as=0.1523p ps=1.38u w=0.42u l=0.13u
X441 a_12902_17508# a_12632_17549# VSS.t380 VSS.t2412 sg13_lv_nmos ad=0.1428p pd=1.52u as=79.8f ps=0.8u w=0.42u l=0.5u
X442 VSS.t163 sg13cmos5l_buf_8_2.A.t4 a_21531_13342# VSS.t2611 sg13_lv_nmos ad=0.1406p pd=1.12u as=0.2553p ps=2.17u w=0.74u l=0.13u
X443 a_16215_11460# sg13cmos5l_and2_1_5.X a_16101_11460# VDD.t0 sg13_lv_pmos ad=0.2128p pd=1.5u as=0.2464p ps=1.56u w=1.12u l=0.13u
X444 a_17604_11464# a_17578_11428# VSS.t232 VSS.t2205 sg13_lv_nmos ad=0.2516p pd=2.16u as=0.1626p ps=1.415u w=0.74u l=0.13u
X445 a_6958_19959# a_7073_19960# VDD.t2169 VDD.t270 sg13_lv_pmos ad=0.34p pd=2.68u as=0.2254p ps=1.53u w=1u l=0.5u
X446 a_16644_19770# sg13cmos5l_dlygate4sd3_1_82.X a_16550_19770# VSS.t166 sg13_lv_nmos ad=60.89999f pd=0.71u as=0.1428p ps=1.52u w=0.42u l=0.13u
X447 a_7066_18226# sg13cmos5l_o21ai_1_14.Y VSS.t5 VSS.t1415 sg13_lv_nmos ad=0.1428p pd=1.52u as=79.8f ps=0.8u w=0.42u l=0.13u
X448 a_17604_11464# a_18123_11471# a_18863_11821# VSS.t171 sg13_lv_nmos ad=0.3473p pd=2.71u as=0.12665p ps=1.145u w=0.74u l=0.13u
X449 a_18948_5416# a_18922_5380# VSS.t11 VSS.t890 sg13_lv_nmos ad=0.2516p pd=2.16u as=0.1626p ps=1.415u w=0.74u l=0.13u
X450 VDD.t1071 a_13670_15238# a_13782_15302# VDD.t16 sg13_lv_pmos ad=0.2254p pd=1.53u as=0.34p ps=2.68u w=1u l=0.5u
X451 VSS.t812 sg13cmos5l_dfrbpq_1_17.Q a_7736_7678# VSS.t1002 sg13_lv_nmos ad=79.8f pd=0.8u as=0.1428p ps=1.52u w=0.42u l=0.13u
X452 VSS.t373 a_15023_16357# a_15690_15996# VSS.t372 sg13_lv_nmos ad=0.1406p pd=1.12u as=0.2516p ps=2.16u w=0.74u l=0.13u
X453 VSS.t260 a_7507_9380# sg13cmos5l_dlygate4sd3_1_42.A VSS.t1033 sg13_lv_nmos ad=0.15745p pd=1.175u as=0.2351p ps=2.16u w=0.74u l=0.13u
X454 VDD.t1653 a_11558_19020# a_11670_19044# VDD.t231 sg13_lv_pmos ad=0.2254p pd=1.53u as=0.34p ps=2.68u w=1u l=0.5u
X455 VSS.t500 a_18287_15311# a_18954_15532# VSS.t392 sg13_lv_nmos ad=0.1406p pd=1.12u as=0.2516p ps=2.16u w=0.74u l=0.13u
X456 a_13596_13686# a_13727_13992# a_13015_13686# VDD.t19 sg13_lv_pmos ad=0.34p pd=2.68u as=0.2048p ps=1.63u w=1u l=0.13u
X457 a_19282_11898# sg13cmos5l_buf_1_13.X VSS.t7 VSS.t592 sg13_lv_nmos ad=37.8f pd=0.6u as=79.8f ps=0.8u w=0.42u l=0.13u
X458 a_21254_10702# a_20984_10702# VDD.t1004 VDD.t0 sg13_lv_pmos ad=0.34p pd=2.68u as=0.1523p ps=1.38u w=1u l=0.5u
X459 a_20294_8874# a_21099_8447# a_20554_8404# VDD.t8 sg13_lv_pmos ad=0.1428p pd=1.52u as=79.8f ps=0.8u w=0.42u l=0.13u
X460 VDD.t1558 sg13cmos5l_dfrbpq_1_13.RESET_B a_9610_12433# VDD.t83 sg13_lv_pmos ad=0.1563p pd=1.22u as=0.147p ps=1.54u w=0.42u l=0.13u
X461 VDD.t443 VSS.t569 VDD.t442 VDD.t8 sg13_lv_pmos ad=0.34p pd=2.68u as=0 ps=0 w=1u l=1u
X462 a_7484_15976# sg13cmos5l_a21oi_1_12.Y sg13cmos5l_o21ai_1_11.A2 VDD.t16 sg13_lv_pmos ad=0.2128p pd=1.5u as=0.2128p ps=1.5u w=1.12u l=0.15u
X463 VSS.t498 sg13cmos5l_nor2_1_3.Y a_11770_11830# VSS.t497 sg13_lv_nmos ad=0.2516p pd=2.16u as=0.1406p ps=1.12u w=0.74u l=0.13u
X464 VDD.t13 VSS.t1966 VDD.t13 VDD.t13 sg13_lv_pmos ad=0.34p pd=2.68u as=0 ps=0 w=1u l=1u
X465 a_21754_5376# sg13cmos5l_dlygate4sd3_1_2.A VSS.t479 VSS.t10 sg13_lv_nmos ad=0.1428p pd=1.52u as=79.8f ps=0.8u w=0.42u l=0.13u
X466 a_18832_8678# sg13cmos5l_buf_1_13.X VDD.t8 VDD.t8 sg13_lv_pmos ad=79.8f pd=0.8u as=1.8716p ps=12.115u w=0.42u l=0.13u
X467 VSS.t293 a_10042_6130# a_9761_6352# VSS.t803 sg13_lv_nmos ad=79.8f pd=0.8u as=0.1428p ps=1.52u w=0.42u l=0.5u
X468 a_4727_16043# sg13cmos5l_dfrbpq_1_24.RESET_B VDD.t707 VDD.t16 sg13_lv_pmos ad=79.8f pd=0.8u as=0.36237p ps=2.605u w=0.42u l=0.13u
X469 a_4932_9186# sg13cmos5l_dlygate4sd3_1_42.X a_4838_9186# VSS.t88 sg13_lv_nmos ad=60.89999f pd=0.71u as=0.1428p ps=1.52u w=0.42u l=0.13u
X470 a_9368_7682# sg13cmos5l_nand2b_1_4.B a_9266_7682# VSS.t1050 sg13_lv_nmos ad=0.1406p pd=1.12u as=0.1406p ps=1.12u w=0.74u l=0.13u
X471 sg13cmos5l_nor2_1_10.Y sg13cmos5l_nand4_1_1.B VSS.t402 VSS.t1188 sg13_lv_nmos ad=0.1406p pd=1.12u as=0.2516p ps=2.16u w=0.74u l=0.13u
X472 a_22096_14726# sg13cmos5l_dfrbpq_1_28.RESET_B.t5 VDD.t19 VDD.t19 sg13_lv_pmos ad=79.8f pd=0.8u as=2.07625p ps=13.51u w=0.42u l=0.13u
X473 bp7 a_20104_3176# VSS.t122 VSS.t121 sg13_lv_nmos ad=0.2886p pd=2.26u as=0.14875p ps=1.16u w=0.74u l=0.13u
X474 a_14446_11727# a_14561_11726# VDD.t1410 VDD.t0 sg13_lv_pmos ad=0.34p pd=2.68u as=0.2254p ps=1.53u w=1u l=0.5u
X475 VDD.t189 VSS.t2162 VDD.t222 VDD.t13 sg13_lv_pmos ad=0.34p pd=2.68u as=0 ps=0 w=1u l=1u
X476 a_8698_16366# sg13cmos5l_a21o_1_2.B1 sg13cmos5l_nand2_1_9.Y VSS.t181 sg13_lv_nmos ad=0.1406p pd=1.12u as=0.2516p ps=2.16u w=0.74u l=0.13u
X477 VDD.t1694 sg13cmos5l_a21oi_1_13.A2 a_19829_14020# VDD.t19 sg13_lv_pmos ad=0.2128p pd=1.5u as=0.3808p ps=2.92u w=1.12u l=0.13u
X478 a_22522_3864# sg13cmos5l_dlygate4sd3_1_3.A VSS.t22 VSS.t193 sg13_lv_nmos ad=0.1428p pd=1.52u as=79.8f ps=0.8u w=0.42u l=0.13u
X479 VDD.t2147 sg13cmos5l_inv_1_18.Y a_13566_8412# VDD.t8 sg13_lv_pmos ad=0.3808p pd=2.92u as=0.2716p ps=1.605u w=1.12u l=0.13u
X480 VDD.t1135 a_21839_14845# a_22506_14484# VDD.t19 sg13_lv_pmos ad=0.2128p pd=1.5u as=0.3864p ps=2.93u w=1.12u l=0.13u
X481 a_8026_14854# sg13cmos5l_a21oi_1_4.A1 sg13cmos5l_o21ai_1_9.A2 VSS.t142 sg13_lv_nmos ad=0.1406p pd=1.12u as=0.2516p ps=2.16u w=0.74u l=0.13u
X482 VSS.t396 a_20398_13239# sg13cmos5l_dlygate4sd3_1_76.X VSS.t128 sg13_lv_nmos ad=0.1426p pd=1.16u as=0.2516p ps=2.16u w=0.74u l=0.13u
X483 VDD.t889 sg13cmos5l_buf_1_45.X.t15 a_14218_19993# VDD.t270 sg13_lv_pmos ad=0.1563p pd=1.22u as=0.147p ps=1.54u w=0.42u l=0.13u
X484 VSS.t169 a_5349_19031# a_5451_19031# VSS.t1302 sg13_lv_nmos ad=3.91182p pd=24.955u as=0.2516p ps=2.16u w=0.74u l=0.13u
X485 a_18756_17512# a_18730_17476# VDD.t1062 VDD.t310 sg13_lv_pmos ad=0.34p pd=2.68u as=0.36237p ps=2.605u w=1u l=0.13u
X486 a_20294_14922# a_21099_14495# a_20554_14452# VDD.t19 sg13_lv_pmos ad=0.1428p pd=1.52u as=79.8f ps=0.8u w=0.42u l=0.13u
X487 VSS.t291 VDD.t2410 VSS.t291 VSS.t2040 sg13_lv_nmos ad=0.1428p pd=1.52u as=0 ps=0 w=0.42u l=1u
X488 VSS.t1842 VDD.t2482 VSS.t1830 VSS.t88 sg13_lv_nmos ad=79.8f pd=0.8u as=0 ps=0 w=0.42u l=1u
X489 a_21646_15423# a_21761_15424# VSS.t72 VSS.t197 sg13_lv_nmos ad=0.1428p pd=1.52u as=0.1426p ps=1.16u w=0.42u l=0.5u
X490 VSS.t937 a_10864_19990# a_10513_19847# VSS.t2423 sg13_lv_nmos ad=79.8f pd=0.8u as=0.1428p ps=1.52u w=0.42u l=0.13u
X491 a_18982_17933# sg13cmos5l_dfrbpq_1_28.RESET_B.t10 VSS.t117 VSS.t866 sg13_lv_nmos ad=37.8f pd=0.6u as=0.1701p ps=1.65u w=0.42u l=0.13u
X492 a_6394_13690# sg13cmos5l_o21ai_1_9.Y VDD.t1764 VDD.t19 sg13_lv_pmos ad=0.1428p pd=1.52u as=0.1523p ps=1.38u w=0.42u l=0.13u
X493 VSS.t1805 VDD.t2498 VSS.t1058 VSS.t1807 sg13_lv_nmos ad=79.8f pd=0.8u as=0 ps=0 w=0.42u l=1u
X494 a_14761_15238# sg13cmos5l_buf_1_21.A VSS.t201 VSS.t1477 sg13_lv_nmos ad=0.198p pd=1.27u as=0.1045p ps=0.93u w=0.55u l=0.13u
X495 a_10365_7194# sg13cmos5l_dfrbpq_1_47.Q VDD.t1249 VDD.t2 sg13_lv_pmos ad=0.2856p pd=2.36u as=0.2198p ps=1.53u w=0.84u l=0.13u
X496 VDD.t2239 sg13cmos5l_nand2_1_6.A sg13cmos5l_a22oi_1_1.B2 VDD.t8 sg13_lv_pmos ad=0.3808p pd=2.92u as=0.2128p ps=1.5u w=1.12u l=0.13u
X497 VDD.t642 VSS.t1787 VDD.t78 VDD.t52 sg13_lv_pmos ad=0.19p pd=1.38u as=0 ps=0 w=1u l=1u
X498 VDD.t237 VSS.t1832 VDD.t236 VDD.t52 sg13_lv_pmos ad=0.19p pd=1.38u as=0 ps=0 w=1u l=1u
X499 VDD.t52 a_6383_9263# a_6640_9406# VDD.t52 sg13_lv_pmos ad=1.8716p pd=12.115u as=79.8f ps=0.8u w=0.42u l=0.13u
X500 VSS.t479 sg13cmos5l_inv_1_17.A sg13cmos5l_inv_1_17.Y VSS.t258 sg13_lv_nmos ad=0.2516p pd=2.16u as=0.2516p ps=2.16u w=0.74u l=0.13u
X501 sg13cmos5l_o21ai_1_6.Y sg13cmos5l_o21ai_1_6.B1 VDD.t2111 VDD.t8 sg13_lv_pmos ad=0.2128p pd=1.5u as=0.3808p ps=2.92u w=1.12u l=0.15u
X502 VSS.t382 a_11770_17472# a_11489_17774# VSS.t1558 sg13_lv_nmos ad=79.8f pd=0.8u as=0.1428p ps=1.52u w=0.42u l=0.5u
X503 VSS.t1966 VDD.t2439 VSS.t1966 VSS.t1965 sg13_lv_nmos ad=0.1428p pd=1.52u as=0 ps=0 w=0.42u l=1u
X504 sg13cmos5l_nand2b_1_3.B a_16650_6460# VSS.t13 VSS.t2198 sg13_lv_nmos ad=0.2516p pd=2.16u as=0.1406p ps=1.12u w=0.74u l=0.13u
X505 a_10316_12936# sg13cmos5l_buf_1_22.A VDD.t804 VDD.t83 sg13_lv_pmos ad=0.2856p pd=2.36u as=0.2114p ps=1.54u w=0.84u l=0.13u
X506 VSS.t1623 VDD.t2554 VSS.t1625 VSS.t1624 sg13_lv_nmos ad=79.8f pd=0.8u as=0 ps=0 w=0.42u l=1u
X507 VSS.t48 sg13cmos5l_or4_1_1.X a_9526_16742# VSS.t1329 sg13_lv_nmos ad=0.1406p pd=1.12u as=0.2516p ps=2.16u w=0.74u l=0.15u
X508 sg13cmos5l_dlygate4sd3_1_55.X a_11670_19044# VSS.t107 VSS.t1296 sg13_lv_nmos ad=0.2516p pd=2.16u as=0.1426p ps=1.16u w=0.74u l=0.13u
X509 VDD.t498 VSS.t1632 VDD.t497 VDD.t231 sg13_lv_pmos ad=0.34p pd=2.68u as=0 ps=0 w=1u l=1u
X510 VDD.t338 VSS.t1682 VDD.t630 VDD.t19 sg13_lv_pmos ad=0.34p pd=2.68u as=0 ps=0 w=1u l=1u
X511 a_15783_7892# a_15935_7944# VSS.t253 VSS.t829 sg13_lv_nmos ad=0.2516p pd=2.16u as=4.7455p ps=30.71u w=0.74u l=0.13u
X512 VSS.t190 sg13cmos5l_nand4_1_0.C sg13cmos5l_o21ai_1_6.B1 VSS.t1004 sg13_lv_nmos ad=0.2516p pd=2.16u as=0.2516p ps=2.16u w=0.74u l=0.13u
X513 a_14855_15532# sg13cmos5l_a21oi_1_4.A2 a_14761_15238# VDD.t16 sg13_lv_pmos ad=0.19p pd=1.38u as=0.34p ps=2.68u w=1u l=0.13u
X514 a_15226_12214# sg13cmos5l_inv_1_36.Y sg13cmos5l_o21ai_1_1.B1 VSS.t1451 sg13_lv_nmos ad=0.1406p pd=1.12u as=0.2516p ps=2.16u w=0.74u l=0.13u
X515 VSS.t1997 VDD.t2425 VSS.t1999 VSS.t1998 sg13_lv_nmos ad=79.8f pd=0.8u as=0 ps=0 w=0.42u l=1u
X516 VSS.t702 a_6766_7191# sg13cmos5l_dlygate4sd3_1_43.X VSS.t2263 sg13_lv_nmos ad=0.1426p pd=1.16u as=0.2516p ps=2.16u w=0.74u l=0.13u
X517 a_11678_7972# sg13cmos5l_and4_1_0.D a_11576_7972# VDD.t8 sg13_lv_pmos ad=0.2128p pd=1.5u as=0.2128p ps=1.5u w=1.12u l=0.13u
X518 VDD.t766 a_6286_8703# sg13cmos5l_dlygate4sd3_1_42.X VDD.t8 sg13_lv_pmos ad=0.2254p pd=1.53u as=0.4256p ps=3u w=1.12u l=0.13u
X519 a_16766_13730# sg13cmos5l_nand4_1_8.B a_16664_13730# VSS.t128 sg13_lv_nmos ad=0.1406p pd=1.12u as=0.1406p ps=1.12u w=0.74u l=0.13u
X520 a_7044_11885# a_7275_11471# a_6730_11428# VSS.t0 sg13_lv_nmos ad=0.2373p pd=1.97u as=79.8f ps=0.8u w=0.42u l=0.13u
X521 VSS.t2010 VDD.t2420 VSS.t2010 VSS.t2009 sg13_lv_nmos ad=0.1428p pd=1.52u as=0 ps=0 w=0.42u l=1u
X522 bn9 a_21640_3176# VSS.t210 VSS.t2389 sg13_lv_nmos ad=0.2886p pd=2.26u as=0.14875p ps=1.16u w=0.74u l=0.13u
X523 VDD.t2241 sg13cmos5l_nand2_1_6.A sg13cmos5l_a21oi_1_8.A2 VDD.t2 sg13_lv_pmos ad=0.3808p pd=2.92u as=0.2128p ps=1.5u w=1.12u l=0.13u
X524 VDD.t21 VSS.t653 VDD.t20 VDD.t19 sg13_lv_pmos ad=0.19p pd=1.38u as=0 ps=0 w=1u l=1u
X525 VDD.t1232 sg13cmos5l_buf_1_66.X a_8540_17488# VDD.t310 sg13_lv_pmos ad=0.3808p pd=2.92u as=0.2128p ps=1.5u w=1.12u l=0.15u
X526 VSS.t1987 VDD.t2413 VSS.t1987 VSS.t1988 sg13_lv_nmos ad=0.1428p pd=1.52u as=0 ps=0 w=0.42u l=1u
X527 a_22126_9375# a_22241_9376# VDD.t2195 VDD.t52 sg13_lv_pmos ad=0.34p pd=2.68u as=0.2254p ps=1.53u w=1u l=0.5u
X528 a_18660_11016# a_18634_10921# VDD.t1036 VDD.t0 sg13_lv_pmos ad=0.34p pd=2.68u as=0.36237p ps=2.605u w=1u l=0.13u
X529 a_10330_9154# sg13cmos5l_or4_1_0.C VDD.t1015 VDD.t52 sg13_lv_pmos ad=0.1428p pd=1.52u as=0.1523p ps=1.38u w=0.42u l=0.13u
X530 a_20868_7349# a_20580_6928# a_20806_7349# VSS.t2508 sg13_lv_nmos ad=0.1428p pd=1.52u as=37.8f ps=0.6u w=0.42u l=0.13u
X531 a_16942_19287# a_17057_19286# VDD.t1612 VDD.t231 sg13_lv_pmos ad=0.34p pd=2.68u as=0.2254p ps=1.53u w=1u l=0.5u
X532 a_7498_18226# sg13cmos5l_buf_8_2.A.t7 VSS.t5 VSS.t1374 sg13_lv_nmos ad=0.1406p pd=1.12u as=0.1406p ps=1.12u w=0.74u l=0.13u
X533 VSS.t1132 a_6490_19738# a_6209_19960# VSS.t2439 sg13_lv_nmos ad=79.8f pd=0.8u as=0.1428p ps=1.52u w=0.42u l=0.5u
X534 a_20434_19458# sg13cmos5l_dfrbpq_1_28.RESET_B.t13 VSS.t1099 VSS.t1098 sg13_lv_nmos ad=37.8f pd=0.6u as=79.8f ps=0.8u w=0.42u l=0.13u
X535 a_20554_13945# a_20997_13701# a_20294_13722# VSS.t128 sg13_lv_nmos ad=79.8f pd=0.8u as=0.1296p ps=1.52u w=0.42u l=0.13u
X536 sg13cmos5l_nand4_1_1.A a_15976_12972# VDD.t1594 VDD.t83 sg13_lv_pmos ad=0.42p pd=2.99u as=0.2114p ps=1.54u w=1.12u l=0.13u
X537 VSS.t1829 VDD.t2487 VSS.t1830 VSS.t88 sg13_lv_nmos ad=79.8f pd=0.8u as=0 ps=0 w=0.42u l=1u
X538 a_7078_14044# sg13cmos5l_a21o_1_2.B1 a_6835_13916# VDD.t19 sg13_lv_pmos ad=0.2125p pd=1.425u as=0.35p ps=2.7u w=1u l=0.13u
X539 VSS.t159 a_11278_13239# sg13cmos5l_buf_1_22.A VSS.t149 sg13_lv_nmos ad=0.1426p pd=1.16u as=0.2516p ps=2.16u w=0.74u l=0.13u
X540 sg13cmos5l_dfrbpq_1_28.D sg13cmos5l_inv_1_12.Y a_17715_13320# VSS.t128 sg13_lv_nmos ad=0.1406p pd=1.12u as=0.1406p ps=1.12u w=0.74u l=0.13u
X541 VDD.t661 a_15104_7849# sg13cmos5l_dlygate4sd3_1_9.A VDD.t8 sg13_lv_pmos ad=0.2128p pd=1.5u as=0.3808p ps=2.92u w=1.12u l=0.13u
X542 a_7260_8802# sg13cmos5l_dfrbpq_1_17.Q a_7158_8802# VSS.t1000 sg13_lv_nmos ad=0.1406p pd=1.12u as=0.1406p ps=1.12u w=0.74u l=0.13u
X543 VDD.t968 a_16558_11727# sg13cmos5l_nand3_1_0.B VDD.t0 sg13_lv_pmos ad=0.2254p pd=1.53u as=0.4256p ps=3u w=1.12u l=0.13u
X544 VDD.t1995 VSS.t1928 VDD.t1395 VDD.t2 sg13_lv_pmos ad=0.19p pd=1.38u as=0 ps=0 w=1u l=1u
X545 VSS.t759 sg13cmos5l_and4_1_0.D a_10896_8052# VSS.t1015 sg13_lv_nmos ad=0.1469p pd=1.155u as=0.1045p ps=0.93u w=0.55u l=0.13u
X546 VDD.t902 a_14926_16935# sg13cmos5l_buf_1_59.A VDD.t310 sg13_lv_pmos ad=0.2254p pd=1.53u as=0.4256p ps=3u w=1.12u l=0.13u
X547 a_20974_19959# a_21089_19960# VDD.t1538 VDD.t270 sg13_lv_pmos ad=0.34p pd=2.68u as=0.2254p ps=1.53u w=1u l=0.5u
X548 a_18660_11016# a_19179_10820# a_19919_10775# VSS.t2453 sg13_lv_nmos ad=0.3473p pd=2.71u as=0.12665p ps=1.145u w=0.74u l=0.13u
X549 VSS.t571 a_10330_9154# a_10049_9376# VSS.t570 sg13_lv_nmos ad=79.8f pd=0.8u as=0.1428p ps=1.52u w=0.42u l=0.5u
X550 a_8061_7194# sg13cmos5l_nand2b_1_1.A_N VSS.t1053 VSS.t2224 sg13_lv_nmos ad=0.187p pd=1.78u as=0.14505p ps=1.15u w=0.55u l=0.13u
X551 a_9924_12223# a_10155_12332# a_9610_12433# VSS.t638 sg13_lv_nmos ad=0.2373p pd=1.97u as=79.8f ps=0.8u w=0.42u l=0.13u
X552 sg13cmos5l_a21oi_1_4.A1 a_15592_10736# VDD.t742 VDD.t0 sg13_lv_pmos ad=0.42p pd=2.99u as=0.2114p ps=1.54u w=1.12u l=0.13u
X553 a_15622_8412# sg13cmos5l_nor2b_1_2.Y VDD.t815 VDD.t8 sg13_lv_pmos ad=0.1596p pd=1.22u as=0.2226p ps=1.535u w=0.84u l=0.13u
X554 VDD.t1775 a_20506_19738# a_20225_19960# VDD.t270 sg13_lv_pmos ad=0.1523p pd=1.38u as=0.34p ps=2.68u w=1u l=0.5u
X555 VDD.t2014 sg13cmos5l_mux2_1_0.S a_7742_12508# VDD.t83 sg13_lv_pmos ad=0.253p pd=1.53u as=0.3325p ps=1.665u w=1u l=0.13u
X556 VSS.t2002 VDD.t2405 VSS.t2002 VSS.t2051 sg13_lv_nmos ad=0.1428p pd=1.52u as=0 ps=0 w=0.42u l=1u
X557 a_19044_19445# a_18756_19024# a_18982_19445# VSS.t1390 sg13_lv_nmos ad=0.1428p pd=1.52u as=37.8f ps=0.6u w=0.42u l=0.13u
X558 VSS.t9 sg13cmos5l_dfrbpq_1_28.RESET_B.t2 a_20388_12210# VSS.t8 sg13_lv_nmos ad=0.1626p pd=1.415u as=60.89999f ps=0.71u w=0.42u l=0.13u
X559 VDD.t379 sg13cmos5l_buf_1_7.X a_18662_5850# VDD.t5 sg13_lv_pmos ad=0.36237p pd=2.605u as=79.8f ps=0.8u w=0.42u l=0.13u
X560 VSS.t636 a_21839_14845# a_22506_14484# VSS.t394 sg13_lv_nmos ad=0.1406p pd=1.12u as=0.2516p ps=2.16u w=0.74u l=0.13u
X561 a_17615_5773# a_16773_5423# a_17521_5773# VSS.t38 sg13_lv_nmos ad=0.12665p pd=1.145u as=0.1428p ps=1.52u w=0.42u l=0.13u
X562 a_14235_5459# a_13343_5383# a_14133_5459# VDD.t5 sg13_lv_pmos ad=63f pd=0.72u as=79.8f ps=0.8u w=0.42u l=0.13u
X563 sg13cmos5l_dfrbpq_1_28.RESET_B.t0 a_15784_15272# VDD.t1301 VDD.t16 sg13_lv_pmos ad=0.42p pd=2.99u as=0.2114p ps=1.54u w=1.12u l=0.13u
X564 a_10500_9952# a_10474_9916# VDD.t1569 VDD.t52 sg13_lv_pmos ad=0.34p pd=2.68u as=0.36237p ps=2.605u w=1u l=0.13u
X565 sg13cmos5l_o21ai_1_25.Y sg13cmos5l_o21ai_1_25.B1 a_14038_16742# VSS.t2520 sg13_lv_nmos ad=0.2516p pd=2.16u as=0.1406p ps=1.12u w=0.74u l=0.15u
X566 sg13cmos5l_dfrbpq_1_13.CLK a_12987_10318# VSS.t86 VSS.t1092 sg13_lv_nmos ad=0.1406p pd=1.12u as=0.1406p ps=1.12u w=0.74u l=0.13u
X567 a_7895_6553# sg13cmos5l_a21oi_1_8.Y a_8642_6162# VSS.t138 sg13_lv_nmos ad=0.1428p pd=1.52u as=60.89999f ps=0.71u w=0.42u l=0.13u
X568 a_20503_15960# a_21063_16083# a_20974_16119# VDD.t16 sg13_lv_pmos ad=0.2048p pd=1.63u as=93.45f ps=0.865u w=0.42u l=0.13u
X569 VSS.t22 sg13cmos5l_buf_1_9.A a_21256_3900# VSS.t295 sg13_lv_nmos ad=0.14875p pd=1.16u as=0.187p ps=1.78u w=0.55u l=0.13u
X570 a_14938_6888# sg13cmos5l_o21ai_1_4.Y VSS.t99 VSS.t2311 sg13_lv_nmos ad=0.1428p pd=1.52u as=79.8f ps=0.8u w=0.42u l=0.13u
X571 a_12902_8436# a_12632_8477# VDD.t1263 VDD.t8 sg13_lv_pmos ad=0.34p pd=2.68u as=0.1523p ps=1.38u w=1u l=0.5u
X572 VDD.t214 VSS.t1805 VDD.t213 VDD.t52 sg13_lv_pmos ad=0.34p pd=2.68u as=0 ps=0 w=1u l=1u
X573 VSS.t571 sg13cmos5l_a21o_1_0.A2 a_11150_9232# VSS.t2330 sg13_lv_nmos ad=0.2176p pd=1.96u as=81.6f ps=0.895u w=0.64u l=0.13u
X574 VDD.t1049 sg13cmos5l_nand3b_1_0.C sg13cmos5l_inv_1_8.A VDD.t52 sg13_lv_pmos ad=0.2198p pd=1.53u as=0.2128p ps=1.5u w=1.12u l=0.13u
X575 VDD.t269 VSS.t1973 VDD.t268 VDD.t13 sg13_lv_pmos ad=0.34p pd=2.68u as=0 ps=0 w=1u l=1u
X576 VDD.t1290 a_21839_7285# a_22506_6924# VDD.t2 sg13_lv_pmos ad=0.2128p pd=1.5u as=0.3864p ps=2.93u w=1.12u l=0.13u
X577 sg13cmos5l_o21ai_1_18.A2 sg13cmos5l_a21oi_1_27.B1 VSS.t48 VSS.t2289 sg13_lv_nmos ad=0.1406p pd=1.12u as=0.2516p ps=2.16u w=0.74u l=0.13u
X578 a_13228_13722# a_13015_13686# VDD.t19 VDD.t19 sg13_lv_pmos ad=79.8f pd=0.8u as=2.1916p ps=14.26u w=0.42u l=0.13u
X579 VDD.t339 VSS.t1682 VDD.t631 VDD.t83 sg13_lv_pmos ad=0.34p pd=2.68u as=0 ps=0 w=1u l=1u
X580 VSS.t201 sg13cmos5l_buf_1_45.X.t3 a_15784_15272# VSS.t924 sg13_lv_nmos ad=0.14875p pd=1.16u as=0.187p ps=1.78u w=0.55u l=0.13u
X581 a_7238_17508# a_6968_17549# VSS.t5 VSS.t1503 sg13_lv_nmos ad=0.1428p pd=1.52u as=79.8f ps=0.8u w=0.42u l=0.5u
X582 VDD.t746 a_1690_15202# a_1409_15424# VDD.t16 sg13_lv_pmos ad=0.1523p pd=1.38u as=0.34p ps=2.68u w=1u l=0.5u
X583 a_16558_11727# a_16673_11726# VDD.t968 VDD.t0 sg13_lv_pmos ad=0.34p pd=2.68u as=0.2254p ps=1.53u w=1u l=0.5u
X584 a_17673_8483# a_17316_8440# VDD.t1043 VDD.t8 sg13_lv_pmos ad=63f pd=0.72u as=0.1563p ps=1.22u w=0.42u l=0.13u
X585 VDD.t19 a_20997_13701# a_21099_13844# VDD.t19 sg13_lv_pmos ad=2.1916p pd=14.26u as=0.3864p ps=2.93u w=1.12u l=0.13u
X586 VSS.t2123 VDD.t2391 VSS.t2125 VSS.t2124 sg13_lv_nmos ad=79.8f pd=0.8u as=0 ps=0 w=0.42u l=1u
X587 VDD.t1503 sg13cmos5l_dfrbpq_1_24.RESET_B a_7498_18988# VDD.t231 sg13_lv_pmos ad=0.1563p pd=1.22u as=0.147p ps=1.54u w=0.42u l=0.13u
X588 sg13cmos5l_inv_1_8.Y sg13cmos5l_inv_1_8.A VDD.t755 VDD.t5 sg13_lv_pmos ad=0.3808p pd=2.92u as=0.3808p ps=2.92u w=1.12u l=0.13u
X589 sg13cmos5l_a21oi_1_13.Y sg13cmos5l_a21oi_1_18.B1 a_19829_14020# VDD.t19 sg13_lv_pmos ad=0.3808p pd=2.92u as=0.2128p ps=1.5u w=1.12u l=0.13u
X590 VDD.t1568 sg13cmos5l_dfrbpq_1_13.RESET_B a_10474_9916# VDD.t52 sg13_lv_pmos ad=0.1563p pd=1.22u as=0.147p ps=1.54u w=0.42u l=0.13u
X591 a_5943_8436# sg13cmos5l_nor3_1_2.B a_5829_8436# VDD.t8 sg13_lv_pmos ad=0.2128p pd=1.5u as=0.2464p ps=1.56u w=1.12u l=0.13u
X592 VDD.t636 VSS.t1749 VDD.t635 VDD.t83 sg13_lv_pmos ad=0.19p pd=1.38u as=0 ps=0 w=1u l=1u
X593 bp4 a_20488_3176# VDD.t812 VDD.t13 sg13_lv_pmos ad=0.42p pd=2.99u as=0.2114p ps=1.54u w=1.12u l=0.13u
X594 VDD.t1382 a_10878_7180# sg13cmos5l_nor2_1_2.B VDD.t2 sg13_lv_pmos ad=0.2044p pd=1.53u as=0.5376p ps=3.2u w=1.12u l=0.13u
X595 a_15783_7892# a_15935_7944# VDD.t8 VDD.t8 sg13_lv_pmos ad=0.3864p pd=2.93u as=1.8716p ps=12.115u w=1.12u l=0.13u
X596 VDD.t1279 a_17804_4614# sg13cmos5l_buf_1_13.X VDD.t5 sg13_lv_pmos ad=0.2114p pd=1.54u as=0.42p ps=2.99u w=1.12u l=0.13u
X597 VSS.t2002 VDD.t2423 VSS.t2002 VSS.t2001 sg13_lv_nmos ad=0.1428p pd=1.52u as=0 ps=0 w=0.42u l=1u
X598 a_10864_5654# sg13cmos5l_dfrbpq_1_13.RESET_B VDD.t5 VDD.t5 sg13_lv_pmos ad=79.8f pd=0.8u as=1.96072p ps=12.69u w=0.42u l=0.13u
X599 VDD.t310 a_19173_17519# a_19275_17519# VDD.t310 sg13_lv_pmos ad=2.1916p pd=14.26u as=0.3864p ps=2.93u w=1.12u l=0.13u
X600 VDD.t1985 a_6383_9263# a_7050_9484# VDD.t52 sg13_lv_pmos ad=0.2128p pd=1.5u as=0.3864p ps=2.93u w=1.12u l=0.13u
X601 a_17829_6935# sg13cmos5l_inv_1_5.A VDD.t2 VDD.t2 sg13_lv_pmos ad=0.4088p pd=2.97u as=2.07625p ps=13.51u w=1.12u l=0.13u
X602 VSS.t1832 VDD.t2481 VSS.t1833 VSS.t88 sg13_lv_nmos ad=79.8f pd=0.8u as=0 ps=0 w=0.42u l=1u
X603 a_17526_16362# sg13cmos5l_buf_1_42.A sg13cmos5l_a21oi_1_19.A2 VSS.t1235 sg13_lv_nmos ad=0.1406p pd=1.12u as=0.2516p ps=2.16u w=0.74u l=0.13u
X604 sg13cmos5l_dfrbpq_1_13.CLK a_12987_10318# VSS.t86 VSS.t1088 sg13_lv_nmos ad=0.1406p pd=1.12u as=0.1406p ps=1.12u w=0.74u l=0.13u
X605 VSS.t1981 VDD.t2416 VSS.t1973 VSS.t1980 sg13_lv_nmos ad=0.1428p pd=1.52u as=0 ps=0 w=0.42u l=1u
X606 a_8878_7191# a_8993_7190# VDD.t2251 VDD.t2 sg13_lv_pmos ad=0.34p pd=2.68u as=0.2254p ps=1.53u w=1u l=0.5u
X607 a_18297_20085# a_17355_19892# a_18095_19847# VDD.t270 sg13_lv_pmos ad=93.45f pd=0.865u as=0.2048p ps=1.63u w=0.42u l=0.13u
X608 VSS.t113 a_14218_18226# sg13cmos5l_dfrbpq_1_41.CLK VSS.t1424 sg13_lv_nmos ad=0.1406p pd=1.12u as=0.1406p ps=1.12u w=0.74u l=0.13u
X609 VDD.t1037 sg13cmos5l_buf_1_13.X a_20294_10386# VDD.t52 sg13_lv_pmos ad=0.36237p pd=2.605u as=79.8f ps=0.8u w=0.42u l=0.13u
X610 a_22235_5412# sg13cmos5l_a21oi_1_2.B1 sg13cmos5l_dlygate4sd3_1_2.A VDD.t5 sg13_lv_pmos ad=0.2128p pd=1.5u as=0.3808p ps=2.92u w=1.12u l=0.13u
X611 a_12428_12936# sg13cmos5l_nand3_1_2.Y VDD.t1691 VDD.t83 sg13_lv_pmos ad=0.2856p pd=2.36u as=0.2114p ps=1.54u w=0.84u l=0.13u
X612 VDD.t2095 sg13cmos5l_a21oi_1_9.B1 a_10878_7180# VDD.t2 sg13_lv_pmos ad=0.1596p pd=1.22u as=0.1848p ps=1.28u w=0.84u l=0.13u
X613 VDD.t547 VSS.t1902 VDD.t546 VDD.t2 sg13_lv_pmos ad=0.34p pd=2.68u as=0 ps=0 w=1u l=1u
X614 a_6756_11464# a_7275_11471# a_8015_11821# VSS.t681 sg13_lv_nmos ad=0.3473p pd=2.71u as=0.12665p ps=1.145u w=0.74u l=0.13u
X615 sg13cmos5l_buf_1_21.A sg13cmos5l_nand2_1_18.A VDD.t697 VDD.t0 sg13_lv_pmos ad=0.2128p pd=1.5u as=0.3808p ps=2.92u w=1.12u l=0.13u
X616 a_15503_19847# a_14661_19749# a_15409_19847# VSS.t166 sg13_lv_nmos ad=0.12665p pd=1.145u as=0.1428p ps=1.52u w=0.42u l=0.13u
X617 a_11202_16362# sg13cmos5l_nor4_1_4.C a_11100_16362# VSS.t2576 sg13_lv_nmos ad=0.1406p pd=1.12u as=0.1406p ps=1.12u w=0.74u l=0.13u
X618 sg13cmos5l_dfrbpq_1_27.Q a_22506_14020# VDD.t735 VDD.t19 sg13_lv_pmos ad=0.3808p pd=2.92u as=0.2128p ps=1.5u w=1.12u l=0.13u
X619 a_5318_13410# a_6123_12983# a_5578_12940# VDD.t83 sg13_lv_pmos ad=0.1428p pd=1.52u as=79.8f ps=0.8u w=0.42u l=0.13u
X620 a_18872_13338# sg13cmos5l_nand4_1_18.C a_18770_13338# VSS.t128 sg13_lv_nmos ad=0.1406p pd=1.12u as=0.1406p ps=1.12u w=0.74u l=0.13u
X621 a_9574_19783# sg13cmos5l_buf_1_15.A.t6 VSS.t1155 VSS.t1176 sg13_lv_nmos ad=37.8f pd=0.6u as=0.1701p ps=1.65u w=0.42u l=0.13u
X622 a_20868_4663# a_21099_4772# a_20554_4873# VSS.t21 sg13_lv_nmos ad=0.2373p pd=1.97u as=79.8f ps=0.8u w=0.42u l=0.13u
X623 a_20974_18573# a_20716_18258# VDD.t231 VDD.t231 sg13_lv_pmos ad=93.45f pd=0.865u as=1.54512p ps=9.865u w=0.42u l=0.13u
X624 VSS.t493 a_17445_15213# a_17547_15356# VSS.t2632 sg13_lv_nmos ad=6.40482p pd=41.475u as=0.2516p ps=2.16u w=0.74u l=0.13u
X625 a_16179_12236# sg13cmos5l_o21ai_1_5.A2 VSS.t222 VSS.t1024 sg13_lv_nmos ad=0.1406p pd=1.12u as=0.2516p ps=2.16u w=0.74u l=0.13u
X626 VDD.t640 VSS.t1787 VDD.t76 VDD.t0 sg13_lv_pmos ad=0.19p pd=1.38u as=0 ps=0 w=1u l=1u
X627 a_17872_5654# a_17615_5773# a_18034_5850# VSS.t38 sg13_lv_nmos ad=0.1428p pd=1.52u as=37.8f ps=0.6u w=0.42u l=0.13u
X628 VDD.t255 VSS.t663 VDD.t507 VDD.t83 sg13_lv_pmos ad=0.19p pd=1.38u as=0 ps=0 w=1u l=1u
X629 VDD.t588 VSS.t1913 VDD.t519 VDD.t2 sg13_lv_pmos ad=0.19p pd=1.38u as=0 ps=0 w=1u l=1u
X630 sg13cmos5l_nand4_1_15.B sg13cmos5l_mux2_1_1.A1 VSS.t196 VSS.t66 sg13_lv_nmos ad=0.1406p pd=1.12u as=0.1406p ps=1.12u w=0.74u l=0.13u
X631 VSS.t271 a_15141_6141# a_15243_6284# VSS.t2539 sg13_lv_nmos ad=4.02307p pd=25.55u as=0.2516p ps=2.16u w=0.74u l=0.13u
X632 a_4917_16904# a_3975_16964# a_4778_16904# VSS.t454 sg13_lv_nmos ad=79.8f pd=0.8u as=0.2373p ps=1.97u w=0.42u l=0.13u
X633 a_8520_8436# sg13cmos5l_or4_1_0.D VSS.t190 VSS.t1581 sg13_lv_nmos ad=0.1045p pd=0.93u as=0.187p ps=1.78u w=0.55u l=0.13u
X634 VDD.t232 VSS.t1609 VDD.t501 VDD.t231 sg13_lv_pmos ad=0.34p pd=2.68u as=0 ps=0 w=1u l=1u
X635 a_21084_16357# a_21215_15967# a_20503_15960# VDD.t16 sg13_lv_pmos ad=0.34p pd=2.68u as=0.2048p ps=1.63u w=1u l=0.13u
X636 VDD.t437 VSS.t1206 VDD.t80 VDD.t0 sg13_lv_pmos ad=0.19p pd=1.38u as=0 ps=0 w=1u l=1u
X637 a_17002_15457# a_17445_15213# a_17385_15625# VDD.t16 sg13_lv_pmos ad=79.8f pd=0.8u as=63f ps=0.72u w=0.42u l=0.13u
X638 a_8898_14020# sg13cmos5l_mux2_1_1.A1 a_8796_14020# VDD.t19 sg13_lv_pmos ad=0.2128p pd=1.5u as=0.2128p ps=1.5u w=1.12u l=0.13u
X639 VSS.t477 sg13cmos5l_mux2_1_0.S a_10543_11830# VSS.t578 sg13_lv_nmos ad=0.14505p pd=1.15u as=0.1406p ps=1.12u w=0.74u l=0.13u
X640 sg13cmos5l_a21oi_1_8.Y sg13cmos5l_a21oi_1_8.A1 a_8115_5760# VSS.t2293 sg13_lv_nmos ad=0.1406p pd=1.12u as=0.1406p ps=1.12u w=0.74u l=0.13u
X641 sg13cmos5l_o21ai_1_19.B1 sg13cmos5l_o21ai_1_18.B1 VDD.t2070 VDD.t310 sg13_lv_pmos ad=0.2128p pd=1.5u as=0.3808p ps=2.92u w=1.12u l=0.15u
X642 VDD.t1030 a_22126_17775# sg13cmos5l_inv_1_17.A VDD.t310 sg13_lv_pmos ad=0.2254p pd=1.53u as=0.4256p ps=3u w=1.12u l=0.13u
X643 sg13cmos5l_a21oi_1_24.A2 sg13cmos5l_buf_1_43.X VDD.t1546 VDD.t310 sg13_lv_pmos ad=0.2128p pd=1.5u as=0.2128p ps=1.5u w=1.12u l=0.13u
X644 a_3319_15960# a_3879_16083# a_3790_16119# VDD.t16 sg13_lv_pmos ad=0.2048p pd=1.63u as=93.45f ps=0.865u w=0.42u l=0.13u
X645 VSS.t174 sg13cmos5l_o21ai_1_3.Y a_16568_9989# VSS.t2346 sg13_lv_nmos ad=79.8f pd=0.8u as=0.1428p ps=1.52u w=0.42u l=0.13u
X646 a_14446_9375# a_14561_9376# VSS.t97 VSS.t2373 sg13_lv_nmos ad=0.1428p pd=1.52u as=0.1426p ps=1.16u w=0.42u l=0.5u
X647 a_19534_16263# a_19649_16262# VSS.t132 VSS.t186 sg13_lv_nmos ad=0.1428p pd=1.52u as=0.1426p ps=1.16u w=0.42u l=0.5u
X648 VDD.t1636 sg13cmos5l_nor4_1_2.Y sg13cmos5l_a21oi_1_15.A2 VDD.t19 sg13_lv_pmos ad=0.2128p pd=1.5u as=0.2128p ps=1.5u w=1.12u l=0.13u
X649 sg13cmos5l_dlygate4sd3_1_25.A sg13cmos5l_nand2_1_2.Y a_16440_11016# VDD.t0 sg13_lv_pmos ad=0.2128p pd=1.5u as=0.2128p ps=1.5u w=1.12u l=0.15u
X650 a_22522_17472# sg13cmos5l_dfrbpq_1_29.Q VDD.t922 VDD.t310 sg13_lv_pmos ad=0.1428p pd=1.52u as=0.1523p ps=1.38u w=0.42u l=0.13u
X651 a_5157_14495# sg13cmos5l_dfrbpq_1_15.CLK VSS.t493 VSS.t2549 sg13_lv_nmos ad=0.2516p pd=2.16u as=6.40482p ps=41.475u w=0.74u l=0.13u
X652 a_13958_19770# sg13cmos5l_inv_1_32.Y VDD.t1462 VDD.t270 sg13_lv_pmos ad=79.8f pd=0.8u as=0.1428p ps=1.52u w=0.42u l=0.13u
X653 sg13cmos5l_dfrbpq_1_37.D a_21462_19044# VSS.t1056 VSS.t1098 sg13_lv_nmos ad=0.2516p pd=2.16u as=0.1426p ps=1.16u w=0.74u l=0.13u
X654 VDD.t1791 a_14218_18226# sg13cmos5l_dfrbpq_1_41.CLK VDD.t231 sg13_lv_pmos ad=0.2128p pd=1.5u as=0.2128p ps=1.5u w=1.12u l=0.13u
X655 VSS.t271 a_19365_5423# a_19467_5423# VSS.t1588 sg13_lv_nmos ad=4.02307p pd=25.55u as=0.2516p ps=2.16u w=0.74u l=0.13u
X656 VSS.t726 a_13574_18262# a_13686_18326# VSS.t725 sg13_lv_nmos ad=0.1426p pd=1.16u as=0.1428p ps=1.52u w=0.42u l=0.5u
X657 a_13764_17512# a_14283_17519# a_15023_17869# VSS.t658 sg13_lv_nmos ad=0.3473p pd=2.71u as=0.12665p ps=1.145u w=0.74u l=0.13u
X658 sg13cmos5l_nand4_1_6.B sg13cmos5l_nor4_1_4.C VSS.t199 VSS.t2577 sg13_lv_nmos ad=0.1406p pd=1.12u as=0.1406p ps=1.12u w=0.74u l=0.13u
X659 VSS.t1830 VDD.t2486 VSS.t1832 VSS.t88 sg13_lv_nmos ad=79.8f pd=0.8u as=0 ps=0 w=0.42u l=1u
X660 VSS.t97 a_15488_9361# sg13cmos5l_nor2b_1_0.B_N VSS.t877 sg13_lv_nmos ad=0.1406p pd=1.12u as=0.2516p ps=2.16u w=0.74u l=0.13u
X661 VSS.t201 sg13cmos5l_a21oi_1_4.A2 a_15358_14850# VSS.t1072 sg13_lv_nmos ad=0.18575p pd=1.26u as=0.187p ps=1.78u w=0.55u l=0.13u
X662 a_20580_11464# a_20554_11428# VSS.t9 VSS.t177 sg13_lv_nmos ad=0.2516p pd=2.16u as=0.1626p ps=1.415u w=0.74u l=0.13u
X663 a_20580_11464# a_21099_11471# a_21839_11821# VSS.t16 sg13_lv_nmos ad=0.3473p pd=2.71u as=0.12665p ps=1.145u w=0.74u l=0.13u
X664 VDD.t13 VSS.t1966 VDD.t13 VDD.t13 sg13_lv_pmos ad=0.34p pd=2.68u as=0 ps=0 w=1u l=1u
X665 VSS.t1208 VDD.t2478 VSS.t1215 VSS.t1851 sg13_lv_nmos ad=0.1428p pd=1.52u as=0 ps=0 w=0.42u l=1u
X666 a_7954_17886# sg13cmos5l_nand3b_1_1.Y VSS.t5 VSS.t2415 sg13_lv_nmos ad=0.2516p pd=2.16u as=0.1406p ps=1.12u w=0.74u l=0.15u
X667 a_11558_19020# a_11288_19061# VDD.t1639 VDD.t231 sg13_lv_pmos ad=0.34p pd=2.68u as=0.1523p ps=1.38u w=1u l=0.5u
X668 VSS.t52 a_12812_15960# sg13cmos5l_buf_1_47.X VSS.t1483 sg13_lv_nmos ad=0.14875p pd=1.16u as=0.2886p ps=2.26u w=0.74u l=0.13u
X669 VDD.t647 a_20890_15202# a_20609_15424# VDD.t16 sg13_lv_pmos ad=0.1523p pd=1.38u as=0.34p ps=2.68u w=1u l=0.5u
X670 a_7726_10887# a_7841_10888# VDD.t1949 VDD.t0 sg13_lv_pmos ad=0.34p pd=2.68u as=0.2254p ps=1.53u w=1u l=0.5u
X671 a_3500_19734# sg13cmos5l_dlygate4sd3_1_50.X VSS.t468 VSS.t467 sg13_lv_nmos ad=0.187p pd=1.78u as=0.14875p ps=1.16u w=0.55u l=0.13u
X672 a_22258_11898# sg13cmos5l_buf_1_7.X VSS.t17 VSS.t16 sg13_lv_nmos ad=37.8f pd=0.6u as=79.8f ps=0.8u w=0.42u l=0.13u
X673 sg13cmos5l_dfrbpq_1_15.CLK a_6442_10666# VSS.t362 VSS.t2400 sg13_lv_nmos ad=0.1406p pd=1.12u as=0.1406p ps=1.12u w=0.74u l=0.13u
X674 VSS.t2108 VDD.t2394 VSS.t2110 VSS.t2109 sg13_lv_nmos ad=79.8f pd=0.8u as=0 ps=0 w=0.42u l=1u
X675 VSS.t279 a_11674_6130# a_11393_6352# VSS.t2375 sg13_lv_nmos ad=79.8f pd=0.8u as=0.1428p ps=1.52u w=0.42u l=0.5u
X676 VSS.t293 sg13cmos5l_dfrbpq_1_13.RESET_B a_8246_6175# VSS.t1199 sg13_lv_nmos ad=0.1701p pd=1.65u as=37.8f ps=0.6u w=0.42u l=0.13u
X677 sg13cmos5l_inv_1_31.A a_19035_16750# VDD.t912 VDD.t310 sg13_lv_pmos ad=0.2128p pd=1.5u as=0.2128p ps=1.5u w=1.12u l=0.13u
X678 a_3200_16283# a_3319_15960# VDD.t801 VDD.t16 sg13_lv_pmos ad=0.3864p pd=2.93u as=0.2128p ps=1.5u w=1.12u l=0.13u
X679 VSS.t2002 VDD.t2404 VSS.t2002 VSS.t2053 sg13_lv_nmos ad=0.1428p pd=1.52u as=0 ps=0 w=0.42u l=1u
X680 sg13cmos5l_dlygate4sd3_1_98.A sg13cmos5l_inv_1_1.Y a_19923_18284# VSS.t118 sg13_lv_nmos ad=0.1406p pd=1.12u as=0.1406p ps=1.12u w=0.74u l=0.13u
X681 a_19733_6924# sg13cmos5l_inv_1_14.Y VDD.t655 VDD.t2 sg13_lv_pmos ad=0.2128p pd=1.5u as=0.2128p ps=1.5u w=1.12u l=0.13u
X682 a_12652_6924# a_12430_6980# VDD.t662 VDD.t2 sg13_lv_pmos ad=0.1176p pd=1.33u as=0.2618p ps=1.63u w=1.12u l=0.13u
X683 VDD.t2195 a_22126_9375# sg13cmos5l_buf_1_10.A VDD.t52 sg13_lv_pmos ad=0.2254p pd=1.53u as=0.4256p ps=3u w=1.12u l=0.13u
X684 sg13cmos5l_a21o_1_1.A2 sg13cmos5l_nand2b_1_5.Y VDD.t2348 VDD.t52 sg13_lv_pmos ad=0.2128p pd=1.5u as=0.3808p ps=2.92u w=1.12u l=0.13u
X685 VSS.t204 sg13cmos5l_buf_1_47.X a_14038_16742# VSS.t1290 sg13_lv_nmos ad=0.1406p pd=1.12u as=0.2516p ps=2.16u w=0.74u l=0.15u
X686 a_20503_16710# a_21063_16964# a_20974_17061# VDD.t310 sg13_lv_pmos ad=0.2048p pd=1.63u as=93.45f ps=0.865u w=0.42u l=0.13u
X687 VDD.t1496 sg13cmos5l_dfrbpq_1_24.RESET_B a_4454_14922# VDD.t19 sg13_lv_pmos ad=0.36237p pd=2.605u as=79.8f ps=0.8u w=0.42u l=0.13u
X688 a_16085_12508# sg13cmos5l_a21oi_1_4.A1 VDD.t693 VDD.t83 sg13_lv_pmos ad=0.2128p pd=1.5u as=0.2128p ps=1.5u w=1.12u l=0.13u
X689 VDD.t1395 VSS.t1925 VDD.t1394 VDD.t2 sg13_lv_pmos ad=0.34p pd=2.68u as=0 ps=0 w=1u l=1u
X690 VSS.t15 a_19995_9190# sg13cmos5l_inv_1_2.A VSS.t348 sg13_lv_nmos ad=0.1406p pd=1.12u as=0.1406p ps=1.12u w=0.74u l=0.13u
X691 VDD.t1332 sg13cmos5l_nor2b_1_0.B_N a_15299_10996# VDD.t0 sg13_lv_pmos ad=0.3808p pd=2.92u as=0.2464p ps=1.56u w=1.12u l=0.13u
X692 VSS.t762 sg13cmos5l_buf_1_0.A a_21256_3176# VSS.t761 sg13_lv_nmos ad=0.14875p pd=1.16u as=0.187p ps=1.78u w=0.55u l=0.13u
X693 VDD.t549 VSS.t1964 VDD.t548 VDD.t5 sg13_lv_pmos ad=0.19p pd=1.38u as=0 ps=0 w=1u l=1u
X694 a_16836_20088# a_16810_19993# VSS.t423 VSS.t166 sg13_lv_nmos ad=0.2516p pd=2.16u as=0.1626p ps=1.415u w=0.74u l=0.13u
X695 VDD.t1904 a_9260_11424# sg13cmos5l_mux2_1_0.S VDD.t0 sg13_lv_pmos ad=0.2114p pd=1.54u as=0.42p ps=2.99u w=1.12u l=0.13u
X696 a_17386_6892# a_17829_6935# a_17126_7362# VSS.t878 sg13_lv_nmos ad=79.8f pd=0.8u as=0.1296p ps=1.52u w=0.42u l=0.13u
X697 VSS.t67 sg13cmos5l_dfrbpq_1_24.Q a_7736_13726# VSS.t66 sg13_lv_nmos ad=79.8f pd=0.8u as=0.1428p ps=1.52u w=0.42u l=0.13u
X698 VDD.t0 a_19919_10775# a_20176_10918# VDD.t0 sg13_lv_pmos ad=2.1916p pd=14.26u as=79.8f ps=0.8u w=0.42u l=0.13u
X699 VSS.t190 a_8602_9154# a_8321_9376# VSS.t189 sg13_lv_nmos ad=79.8f pd=0.8u as=0.1428p ps=1.52u w=0.42u l=0.5u
X700 a_14438_6162# sg13cmos5l_dlygate4sd3_1_7.X VDD.t1423 VDD.t2 sg13_lv_pmos ad=79.8f pd=0.8u as=0.1428p ps=1.52u w=0.42u l=0.13u
X701 a_9646_6351# a_9761_6352# VDD.t1007 VDD.t2 sg13_lv_pmos ad=0.34p pd=2.68u as=0.2254p ps=1.53u w=1u l=0.5u
X702 a_8272_11702# sg13cmos5l_dfrbpq_1_13.RESET_B VDD.t0 VDD.t0 sg13_lv_pmos ad=79.8f pd=0.8u as=2.1916p ps=14.26u w=0.42u l=0.13u
X703 VDD.t706 sg13cmos5l_dlygate4sd3_1_13.A a_17240_10702# VDD.t0 sg13_lv_pmos ad=0.1523p pd=1.38u as=0.1428p ps=1.52u w=0.42u l=0.13u
X704 a_7524_19024# a_8043_19031# a_8783_19381# VSS.t1288 sg13_lv_nmos ad=0.3473p pd=2.71u as=0.12665p ps=1.145u w=0.74u l=0.13u
X705 VSS.t136 sg13cmos5l_a21oi_1_18.B1 sg13cmos5l_a21oi_1_20.Y VSS.t1435 sg13_lv_nmos ad=0.2516p pd=2.16u as=0.1406p ps=1.12u w=0.74u l=0.13u
X706 a_8533_13362# sg13cmos5l_mux2_1_0.S a_8431_13362# VSS.t149 sg13_lv_nmos ad=0.1216p pd=1.02u as=0.1216p ps=1.02u w=0.64u l=0.13u
X707 bp9 a_19048_3900# VSS.t273 VSS.t2339 sg13_lv_nmos ad=0.2886p pd=2.26u as=0.14875p ps=1.16u w=0.74u l=0.13u
X708 VSS.t1997 sg13cmos5l_a21oi_1_9.A2 a_10913_4676# VSS.t2336 sg13_lv_nmos ad=0.2516p pd=2.16u as=0.1406p ps=1.12u w=0.74u l=0.13u
X709 VSS.t1053 sg13cmos5l_nand2b_1_4.B a_8143_7294# VSS.t1052 sg13_lv_nmos ad=0.14505p pd=1.15u as=0.1406p ps=1.12u w=0.74u l=0.13u
X710 a_19995_9190# sg13cmos5l_buf_8_2.A.t2 VSS.t15 VSS.t1384 sg13_lv_nmos ad=0.1406p pd=1.12u as=0.1406p ps=1.12u w=0.74u l=0.13u
X711 sg13cmos5l_dfrbpq_1_15.CLK a_6442_10666# VDD.t2153 VDD.t0 sg13_lv_pmos ad=0.2128p pd=1.5u as=0.2128p ps=1.5u w=1.12u l=0.13u
X712 VSS.t839 sg13cmos5l_nor2_1_4.Y a_7938_16362# VSS.t1414 sg13_lv_nmos ad=0.2886p pd=2.26u as=0.1406p ps=1.12u w=0.74u l=0.13u
X713 VDD.t687 a_17434_14448# a_17153_14750# VDD.t19 sg13_lv_pmos ad=0.1523p pd=1.38u as=0.34p ps=2.68u w=1u l=0.5u
X714 VDD.t16 a_17445_15213# a_17547_15356# VDD.t16 sg13_lv_pmos ad=2.07625p pd=13.51u as=0.3864p ps=2.93u w=1.12u l=0.13u
X715 VDD.t1242 sg13cmos5l_buf_1_4.A sg13cmos5l_inv_1_4.Y VDD.t5 sg13_lv_pmos ad=0.3808p pd=2.92u as=0.3808p ps=2.92u w=1.12u l=0.13u
X716 VSS.t2093 VDD.t2397 VSS.t2095 VSS.t2094 sg13_lv_nmos ad=79.8f pd=0.8u as=0 ps=0 w=0.42u l=1u
X717 a_6671_7751# a_5829_7653# a_6577_7751# VSS.t2342 sg13_lv_nmos ad=0.12665p pd=1.145u as=0.1428p ps=1.52u w=0.42u l=0.13u
X718 a_10118_18262# a_9848_18262# VDD.t669 VDD.t231 sg13_lv_pmos ad=0.34p pd=2.68u as=0.1523p ps=1.38u w=1u l=0.5u
X719 VDD.t396 sg13cmos5l_dlygate4sd3_1_65.A a_9464_17549# VDD.t310 sg13_lv_pmos ad=0.1523p pd=1.38u as=0.1428p ps=1.52u w=0.42u l=0.13u
X720 sg13cmos5l_dlygate4sd3_1_13.A sg13cmos5l_nand2_1_1.Y VDD.t1020 VDD.t83 sg13_lv_pmos ad=0.2128p pd=1.5u as=0.3808p ps=2.92u w=1.12u l=0.13u
X721 a_6700_6162# a_6487_6126# VDD.t2 VDD.t2 sg13_lv_pmos ad=79.8f pd=0.8u as=2.1916p ps=14.26u w=0.42u l=0.13u
X722 sg13cmos5l_nand2b_1_4.B a_8118_7742# VSS.t1053 VSS.t2280 sg13_lv_nmos ad=0.2516p pd=2.16u as=0.1426p ps=1.16u w=0.74u l=0.13u
X723 sg13cmos5l_a21oi_1_24.Y sg13cmos5l_buf_1_16.A VSS.t1315 VSS.t179 sg13_lv_nmos ad=0.1406p pd=1.12u as=0.2516p ps=2.16u w=0.74u l=0.13u
X724 a_19017_11089# a_18660_11016# VDD.t1041 VDD.t0 sg13_lv_pmos ad=63f pd=0.72u as=0.1563p ps=1.22u w=0.42u l=0.13u
X725 VDD.t835 a_19995_9190# sg13cmos5l_inv_1_2.A VDD.t52 sg13_lv_pmos ad=0.2128p pd=1.5u as=0.2128p ps=1.5u w=1.12u l=0.13u
X726 sg13cmos5l_nand2b_1_1.A_N sg13cmos5l_nor3_1_0.Y a_14548_12236# VSS.t720 sg13_lv_nmos ad=0.2516p pd=2.16u as=0.1406p ps=1.12u w=0.74u l=0.13u
X727 VDD.t541 VSS.t1058 VDD.t540 VDD.t0 sg13_lv_pmos ad=0.34p pd=2.68u as=0 ps=0 w=1u l=1u
X728 VSS.t2005 VDD.t2422 VSS.t2005 VSS.t2004 sg13_lv_nmos ad=0.1428p pd=1.52u as=0 ps=0 w=0.42u l=1u
X729 a_8006_7678# a_7736_7678# VDD.t1370 VDD.t8 sg13_lv_pmos ad=0.34p pd=2.68u as=0.1523p ps=1.38u w=1u l=0.5u
X730 VDD.t1228 a_22005_18416# a_21084_18222# VDD.t231 sg13_lv_pmos ad=0.36237p pd=2.605u as=0.34p ps=2.68u w=1u l=0.13u
X731 a_12082_7302# sg13cmos5l_o21ai_1_4.A1 VSS.t101 VSS.t367 sg13_lv_nmos ad=0.2516p pd=2.16u as=0.1406p ps=1.12u w=0.74u l=0.15u
X732 VSS.t86 a_14350_10215# sg13cmos5l_nand2_1_0.A VSS.t666 sg13_lv_nmos ad=0.1426p pd=1.16u as=0.2516p ps=2.16u w=0.74u l=0.13u
X733 a_16582_5837# sg13cmos5l_buf_1_7.X VSS.t13 VSS.t12 sg13_lv_nmos ad=37.8f pd=0.6u as=0.1701p ps=1.65u w=0.42u l=0.13u
X734 VDD.t2200 sg13cmos5l_nand3_1_0.A sg13cmos5l_nand3_1_0.Y VDD.t2 sg13_lv_pmos ad=0.2128p pd=1.5u as=0.3808p ps=2.92u w=1.12u l=0.13u
X735 VDD.t231 a_13679_19381# a_13936_19262# VDD.t231 sg13_lv_pmos ad=1.54512p pd=9.865u as=79.8f ps=0.8u w=0.42u l=0.13u
X736 VSS.t1623 VDD.t2558 VSS.t1622 VSS.t1621 sg13_lv_nmos ad=0.1428p pd=1.52u as=0 ps=0 w=0.42u l=1u
X737 a_13390_7863# a_13505_7864# VSS.t284 VSS.t335 sg13_lv_nmos ad=0.1428p pd=1.52u as=0.1426p ps=1.16u w=0.42u l=0.5u
X738 VSS.t134 a_16556_15960# sg13cmos5l_nand4_1_5.D VSS.t1518 sg13_lv_nmos ad=0.14875p pd=1.16u as=0.2886p ps=2.26u w=0.74u l=0.13u
X739 VSS.t86 sg13cmos5l_dlygate4sd3_1_15.X sg13cmos5l_nand2_1_0.B VSS.t85 sg13_lv_nmos ad=0.2516p pd=2.16u as=0.1406p ps=1.12u w=0.74u l=0.13u
X740 a_7750_9508# sg13cmos5l_nor3_1_2.Y a_7507_9380# VDD.t52 sg13_lv_pmos ad=0.2125p pd=1.425u as=0.35p ps=2.7u w=1u l=0.13u
X741 VDD.t1704 a_6094_16935# sg13cmos5l_dfrbpq_1_19.D VDD.t310 sg13_lv_pmos ad=0.2254p pd=1.53u as=0.4256p ps=3u w=1.12u l=0.13u
X742 sg13cmos5l_nor3_1_7.Y sg13cmos5l_nand2_1_2.Y a_16215_11460# VDD.t0 sg13_lv_pmos ad=0.3808p pd=2.92u as=0.2128p ps=1.5u w=1.12u l=0.13u
X743 VDD.t1326 a_11374_17775# sg13cmos5l_o21ai_1_22.B1 VDD.t310 sg13_lv_pmos ad=0.2254p pd=1.53u as=0.4256p ps=3u w=1.12u l=0.13u
X744 VSS.t344 VDD.t2514 VSS.t344 VSS.t1762 sg13_lv_nmos ad=79.8f pd=0.8u as=0 ps=0 w=0.42u l=1u
X745 sg13cmos5l_inv_1_2.A a_19995_9190# VDD.t831 VDD.t52 sg13_lv_pmos ad=0.2128p pd=1.5u as=0.2128p ps=1.5u w=1.12u l=0.13u
X746 VDD.t474 VSS.t1625 VDD.t425 VDD.t310 sg13_lv_pmos ad=0.19p pd=1.38u as=0 ps=0 w=1u l=1u
X747 VDD.t679 sg13cmos5l_a21oi_1_17.Y sg13cmos5l_a21oi_1_20.A2 VDD.t16 sg13_lv_pmos ad=0.3808p pd=2.92u as=0.2128p ps=1.5u w=1.12u l=0.13u
X748 a_16954_11424# sg13cmos5l_nand2_1_13.Y VSS.t232 VSS.t1336 sg13_lv_nmos ad=0.1428p pd=1.52u as=79.8f ps=0.8u w=0.42u l=0.13u
X749 sg13cmos5l_o21ai_1_23.B1 a_15690_15996# VSS.t373 VSS.t1524 sg13_lv_nmos ad=0.2516p pd=2.16u as=0.1406p ps=1.12u w=0.74u l=0.13u
X750 sg13cmos5l_nor4_1_2.Y sg13cmos5l_mux2_1_1.A1 VSS.t159 VSS.t66 sg13_lv_nmos ad=0.1406p pd=1.12u as=0.1406p ps=1.12u w=0.74u l=0.13u
X751 VDD.t54 VSS.t1789 VDD.t53 VDD.t52 sg13_lv_pmos ad=0.34p pd=2.68u as=0 ps=0 w=1u l=1u
X752 VSS.t569 a_12430_9375# sg13cmos5l_o21ai_1_0.A2 VSS.t2201 sg13_lv_nmos ad=0.1426p pd=1.16u as=0.2516p ps=2.16u w=0.74u l=0.13u
X753 VDD.t158 VSS.t1833 VDD.t238 VDD.t52 sg13_lv_pmos ad=0.34p pd=2.68u as=0 ps=0 w=1u l=1u
X754 code6 a_4744_19808# VDD.t852 VDD.t270 sg13_lv_pmos ad=0.42p pd=2.99u as=0.2114p ps=1.54u w=1.12u l=0.13u
X755 VSS.t1997 VDD.t2407 VSS.t1997 VSS.t2047 sg13_lv_nmos ad=0.1428p pd=1.52u as=0 ps=0 w=0.42u l=1u
X756 VDD.t165 VSS.t1836 VDD.t164 VDD.t8 sg13_lv_pmos ad=0.19p pd=1.38u as=0 ps=0 w=1u l=1u
X757 a_16342_10694# sg13cmos5l_nand2_1_2.Y VSS.t120 VSS.t429 sg13_lv_nmos ad=0.1406p pd=1.12u as=0.1406p ps=1.12u w=0.74u l=0.15u
X758 sample a_19336_3176# VSS.t122 VSS.t539 sg13_lv_nmos ad=0.2886p pd=2.26u as=0.14875p ps=1.16u w=0.74u l=0.13u
X759 sg13cmos5l_dlygate4sd3_1_1.A a_18282_5412# VDD.t1150 VDD.t5 sg13_lv_pmos ad=0.3808p pd=2.92u as=0.2128p ps=1.5u w=1.12u l=0.13u
X760 VSS.t1800 VDD.t2500 VSS.t1799 VSS.t1798 sg13_lv_nmos ad=0.1428p pd=1.52u as=0 ps=0 w=0.42u l=1u
X761 a_16644_5837# a_16875_5423# a_16330_5380# VSS.t451 sg13_lv_nmos ad=0.2373p pd=1.97u as=79.8f ps=0.8u w=0.42u l=0.13u
X762 a_9435_15996# sg13cmos5l_o21ai_1_5.A2 a_9292_15996# VDD.t16 sg13_lv_pmos ad=0.19p pd=1.38u as=0.2925p ps=1.585u w=1u l=0.13u
X763 VDD.t231 a_9040_19262# a_8985_19143# VDD.t231 sg13_lv_pmos ad=1.54512p pd=9.865u as=93.45f ps=0.865u w=0.42u l=0.13u
X764 VDD.t517 VSS.t1938 VDD.t516 VDD.t5 sg13_lv_pmos ad=0.19p pd=1.38u as=0 ps=0 w=1u l=1u
X765 a_19090_7362# sg13cmos5l_buf_1_7.X VSS.t19 VSS.t18 sg13_lv_nmos ad=37.8f pd=0.6u as=79.8f ps=0.8u w=0.42u l=0.13u
X766 a_9636_12528# a_9610_12433# VSS.t50 VSS.t1407 sg13_lv_nmos ad=0.2516p pd=2.16u as=0.1626p ps=1.415u w=0.74u l=0.13u
X767 VDD.t830 sg13cmos5l_buf_8_2.A.t2 a_19995_9190# VDD.t52 sg13_lv_pmos ad=0.2128p pd=1.5u as=0.2128p ps=1.5u w=1.12u l=0.13u
X768 VSS.t74 a_9260_11424# sg13cmos5l_mux2_1_0.S VSS.t2316 sg13_lv_nmos ad=0.14875p pd=1.16u as=0.2886p ps=2.26u w=0.74u l=0.13u
X769 VDD.t654 sg13cmos5l_dlygate4sd3_1_15.X a_12940_10996# VDD.t0 sg13_lv_pmos ad=0.4032p pd=2.96u as=0.1176p ps=1.33u w=1.12u l=0.13u
X770 VSS.t1204 sg13cmos5l_dfrbpq_1_13.RESET_B a_6794_6162# VSS.t1203 sg13_lv_nmos ad=79.8f pd=0.8u as=37.8f ps=0.6u w=0.42u l=0.13u
X771 a_7354_19738# sg13cmos5l_o21ai_1_7.Y VDD.t2173 VDD.t270 sg13_lv_pmos ad=0.1428p pd=1.52u as=0.1523p ps=1.38u w=0.42u l=0.13u
X772 VDD.t1632 a_21084_16357# a_22107_16043# VDD.t16 sg13_lv_pmos ad=0.1563p pd=1.22u as=63f ps=0.72u w=0.42u l=0.13u
X773 a_15141_6141# sg13cmos5l_inv_1_5.A VDD.t2 VDD.t2 sg13_lv_pmos ad=0.4088p pd=2.97u as=2.07625p ps=13.51u w=1.12u l=0.13u
X774 a_9636_19783# a_9348_20088# a_9574_19783# VSS.t2279 sg13_lv_nmos ad=0.1428p pd=1.52u as=37.8f ps=0.6u w=0.42u l=0.13u
X775 VSS.t922 a_17296_18478# a_16945_18335# VSS.t92 sg13_lv_nmos ad=79.8f pd=0.8u as=0.1428p ps=1.52u w=0.42u l=0.13u
X776 VDD.t715 a_19534_16263# sg13cmos5l_buf_1_53.A VDD.t16 sg13_lv_pmos ad=0.2254p pd=1.53u as=0.4256p ps=3u w=1.12u l=0.13u
X777 VSS.t46 sg13cmos5l_a21oi_1_12.A2 a_8513_15260# VSS.t321 sg13_lv_nmos ad=0.2516p pd=2.16u as=0.1406p ps=1.12u w=0.74u l=0.13u
X778 sg13cmos5l_a21oi_1_4.B1 a_14646_10766# VSS.t120 VSS.t2259 sg13_lv_nmos ad=0.2516p pd=2.16u as=0.1426p ps=1.16u w=0.74u l=0.13u
X779 a_16330_5380# a_16773_5423# a_16713_5459# VDD.t5 sg13_lv_pmos ad=79.8f pd=0.8u as=63f ps=0.72u w=0.42u l=0.13u
X780 sg13cmos5l_o21ai_1_12.Y sg13cmos5l_dlygate4sd3_1_50.X a_5782_15230# VSS.t469 sg13_lv_nmos ad=0.2516p pd=2.16u as=0.1406p ps=1.12u w=0.74u l=0.15u
X781 VDD.t1060 sg13cmos5l_o21ai_1_28.B1 sg13cmos5l_o21ai_1_28.Y VDD.t16 sg13_lv_pmos ad=0.3808p pd=2.92u as=0.2128p ps=1.5u w=1.12u l=0.15u
X782 VSS.t1757 VDD.t2516 VSS.t1756 VSS.t1755 sg13_lv_nmos ad=0.1428p pd=1.52u as=0 ps=0 w=0.42u l=1u
X783 VSS.t569 sg13cmos5l_inv_1_18.A sg13cmos5l_inv_1_18.Y VSS.t613 sg13_lv_nmos ad=0.2516p pd=2.16u as=0.2516p ps=2.16u w=0.74u l=0.13u
X784 VDD.t846 sg13cmos5l_dfrbpq_1_13.RESET_B a_7334_10386# VDD.t52 sg13_lv_pmos ad=0.36237p pd=2.605u as=79.8f ps=0.8u w=0.42u l=0.13u
X785 a_19930_4618# sg13cmos5l_dlygate4sd3_1_1.A VSS.t192 VSS.t2512 sg13_lv_nmos ad=0.1428p pd=1.52u as=79.8f ps=0.8u w=0.42u l=0.13u
X786 VSS.t48 sg13cmos5l_nand3_1_5.Y a_8338_16742# VSS.t1531 sg13_lv_nmos ad=0.1406p pd=1.12u as=0.1406p ps=1.12u w=0.74u l=0.15u
X787 sg13cmos5l_buf_1_9.A a_21366_10766# VDD.t947 VDD.t0 sg13_lv_pmos ad=0.4256p pd=3u as=0.2254p ps=1.53u w=1.12u l=0.13u
X788 a_4727_16043# sg13cmos5l_dfrbpq_1_19.D a_5474_16434# VSS.t524 sg13_lv_nmos ad=0.1428p pd=1.52u as=60.89999f ps=0.71u w=0.42u l=0.13u
X789 a_8637_12214# sg13cmos5l_mux2_1_0.A1 VSS.t74 VSS.t218 sg13_lv_nmos ad=0.13135p pd=1.095u as=0.18945p ps=1.27u w=0.74u l=0.13u
X790 a_9394_8814# sg13cmos5l_o21ai_1_6.B1 sg13cmos5l_o21ai_1_6.Y VSS.t2352 sg13_lv_nmos ad=0.1406p pd=1.12u as=0.2516p ps=2.16u w=0.74u l=0.15u
X791 VSS.t1997 sg13cmos5l_a21oi_1_9.B1 a_11394_4658# VSS.t2498 sg13_lv_nmos ad=0.2886p pd=2.26u as=0.1406p ps=1.12u w=0.74u l=0.13u
X792 VSS.t2078 VDD.t13 VSS.t2080 VSS.t2079 sg13_lv_nmos ad=79.8f pd=0.8u as=0 ps=0 w=0.42u l=1u
X793 sg13cmos5l_a21oi_1_27.A1 a_10461_11730# VDD.t1022 VDD.t0 sg13_lv_pmos ad=0.2128p pd=1.5u as=0.3808p ps=2.92u w=1.12u l=0.13u
X794 VSS.t2005 VDD.t2403 VSS.t2005 VSS.t2055 sg13_lv_nmos ad=0.1428p pd=1.52u as=0 ps=0 w=0.42u l=1u
X795 a_20464_5654# a_20207_5773# a_20626_5850# VSS.t10 sg13_lv_nmos ad=0.1428p pd=1.52u as=37.8f ps=0.6u w=0.42u l=0.13u
X796 a_7068_6126# a_7199_6432# a_6487_6126# VDD.t2 sg13_lv_pmos ad=0.34p pd=2.68u as=0.2048p ps=1.63u w=1u l=0.13u
X797 sg13cmos5l_nand3b_1_3.C a_1192_19020# VDD.t1122 VDD.t231 sg13_lv_pmos ad=0.42p pd=2.99u as=0.2114p ps=1.54u w=1.12u l=0.13u
X798 sg13cmos5l_o21ai_1_23.A2 sg13cmos5l_a21oi_1_4.A2 a_14378_15532# VDD.t16 sg13_lv_pmos ad=0.3808p pd=2.92u as=0.1176p ps=1.33u w=1.12u l=0.13u
X799 VDD.t944 VSS.t1930 VDD.t943 VDD.t2 sg13_lv_pmos ad=0.34p pd=2.68u as=0 ps=0 w=1u l=1u
X800 VSS.t169 a_9765_19749# a_9867_19892# VSS.t2277 sg13_lv_nmos ad=3.91182p pd=24.955u as=0.2516p ps=2.16u w=0.74u l=0.13u
X801 a_21911_18649# a_21215_18528# a_22005_18416# VSS.t140 sg13_lv_nmos ad=0.1296p pd=1.52u as=79.8f ps=0.8u w=0.42u l=0.13u
X802 VSS.t19 sg13cmos5l_buf_1_7.X a_18468_7674# VSS.t23 sg13_lv_nmos ad=0.1626p pd=1.415u as=60.89999f ps=0.71u w=0.42u l=0.13u
X803 a_20294_11898# a_21099_11471# a_20554_11428# VDD.t0 sg13_lv_pmos ad=0.1428p pd=1.52u as=79.8f ps=0.8u w=0.42u l=0.13u
X804 a_11772_14484# sg13cmos5l_mux2_1_0.S a_11670_14484# VDD.t19 sg13_lv_pmos ad=0.2128p pd=1.5u as=0.2128p ps=1.5u w=1.12u l=0.13u
X805 sg13cmos5l_dlygate4sd3_1_13.A sg13cmos5l_nand3_1_0.B a_15706_13342# VSS.t128 sg13_lv_nmos ad=0.2516p pd=2.16u as=0.1406p ps=1.12u w=0.74u l=0.13u
X806 VDD.t2047 sg13cmos5l_buf_1_43.X sg13cmos5l_nand4_1_17.Y VDD.t16 sg13_lv_pmos ad=0.2128p pd=1.5u as=0.2128p ps=1.5u w=1.12u l=0.13u
X807 a_14957_15532# sg13cmos5l_buf_1_21.A a_14855_15532# VDD.t16 sg13_lv_pmos ad=0.1575p pd=1.315u as=0.19p ps=1.38u w=1u l=0.13u
X808 a_8332_15996# sg13cmos5l_a21oi_1_12.Y sg13cmos5l_nor2_1_4.Y VDD.t16 sg13_lv_pmos ad=0.1176p pd=1.33u as=0.3808p ps=2.92u w=1.12u l=0.13u
X809 VSS.t316 a_17615_5773# a_18282_5412# VSS.t38 sg13_lv_nmos ad=0.1406p pd=1.12u as=0.2516p ps=2.16u w=0.74u l=0.13u
X810 VSS.t81 sg13cmos5l_buf_1_9.A sg13cmos5l_inv_1_9.Y VSS.t294 sg13_lv_nmos ad=0.2516p pd=2.16u as=0.2516p ps=2.16u w=0.74u l=0.13u
X811 VDD.t1616 a_22030_19287# sg13cmos5l_inv_1_15.A VDD.t231 sg13_lv_pmos ad=0.2254p pd=1.53u as=0.4256p ps=3u w=1.12u l=0.13u
X812 a_8434_17886# sg13cmos5l_buf_1_66.X VSS.t56 VSS.t832 sg13_lv_nmos ad=0.2516p pd=2.16u as=0.1406p ps=1.12u w=0.74u l=0.15u
X813 a_8620_4948# sg13cmos5l_nor2_1_2.B sg13cmos5l_nor2_1_2.Y VDD.t5 sg13_lv_pmos ad=0.1176p pd=1.33u as=0.3808p ps=2.92u w=1.12u l=0.13u
X814 sg13cmos5l_inv_1_5.A a_17098_6130# VSS.t13 VSS.t285 sg13_lv_nmos ad=0.1406p pd=1.12u as=0.1406p ps=1.12u w=0.74u l=0.13u
X815 VSS.t740 sg13cmos5l_dfrbpq_1_13.RESET_B a_10308_10386# VSS.t1214 sg13_lv_nmos ad=0.1626p pd=1.415u as=60.89999f ps=0.71u w=0.42u l=0.13u
X816 a_20384_18433# a_20503_18222# VSS.t117 VSS.t118 sg13_lv_nmos ad=0.2516p pd=2.16u as=0.1406p ps=1.12u w=0.74u l=0.13u
X817 a_20937_14113# a_20580_14040# VDD.t868 VDD.t19 sg13_lv_pmos ad=63f pd=0.72u as=0.1563p ps=1.22u w=0.42u l=0.13u
X818 a_12029_5412# sg13cmos5l_o21ai_1_0.A2 sg13cmos5l_nor3_1_1.Y VDD.t5 sg13_lv_pmos ad=0.2128p pd=1.5u as=0.3808p ps=2.92u w=1.12u l=0.13u
X819 VSS.t1860 VDD.t2467 VSS.t1862 VSS.t1861 sg13_lv_nmos ad=79.8f pd=0.8u as=0 ps=0 w=0.42u l=1u
X820 VSS.t853 VDD.t2562 VSS.t1609 VSS.t1608 sg13_lv_nmos ad=0.1428p pd=1.52u as=0 ps=0 w=0.42u l=1u
X821 a_6286_16263# a_6401_16262# VDD.t1327 VDD.t16 sg13_lv_pmos ad=0.34p pd=2.68u as=0.2254p ps=1.53u w=1u l=0.5u
X822 VDD.t1707 sg13cmos5l_nand4_1_1.C sg13cmos5l_a21oi_1_6.A2 VDD.t19 sg13_lv_pmos ad=0.2128p pd=1.5u as=0.2128p ps=1.5u w=1.12u l=0.13u
X823 a_10316_12936# sg13cmos5l_buf_1_22.A VSS.t196 VSS.t149 sg13_lv_nmos ad=0.187p pd=1.78u as=0.14875p ps=1.16u w=0.55u l=0.13u
X824 VSS.t50 sg13cmos5l_a21oi_1_27.B1 sg13cmos5l_mux2_1_1.A0 VSS.t2291 sg13_lv_nmos ad=0.2516p pd=2.16u as=0.1406p ps=1.12u w=0.74u l=0.13u
X825 VSS.t1781 VDD.t2504 VSS.t1206 VSS.t1782 sg13_lv_nmos ad=79.8f pd=0.8u as=0 ps=0 w=0.42u l=1u
X826 a_7507_9380# sg13cmos5l_nor3_1_2.Y VSS.t260 VSS.t482 sg13_lv_nmos ad=0.1216p pd=1.02u as=0.15745p ps=1.175u w=0.64u l=0.13u
X827 VSS.t2098 VDD.t2396 VSS.t2100 VSS.t2099 sg13_lv_nmos ad=79.8f pd=0.8u as=0 ps=0 w=0.42u l=1u
X828 VDD.t1118 sg13cmos5l_a21oi_1_9.A1 sg13cmos5l_nand3_1_3.Y VDD.t5 sg13_lv_pmos ad=0.2128p pd=1.5u as=0.3808p ps=2.92u w=1.12u l=0.13u
X829 a_20806_13735# sg13cmos5l_dfrbpq_1_28.RESET_B.t4 VSS.t395 VSS.t128 sg13_lv_nmos ad=37.8f pd=0.6u as=0.1701p ps=1.65u w=0.42u l=0.13u
X830 VDD.t251 VSS.t1828 VDD.t242 VDD.t8 sg13_lv_pmos ad=0.19p pd=1.38u as=0 ps=0 w=1u l=1u
X831 a_20176_7894# sg13cmos5l_buf_1_7.X VDD.t8 VDD.t8 sg13_lv_pmos ad=79.8f pd=0.8u as=1.79022p ps=11.585u w=0.42u l=0.13u
X832 VDD.t581 VSS.t1915 VDD.t585 VDD.t2 sg13_lv_pmos ad=0.34p pd=2.68u as=0 ps=0 w=1u l=1u
X833 VDD.t1818 sg13cmos5l_o21ai_1_1.B1 sg13cmos5l_o21ai_1_1.Y VDD.t8 sg13_lv_pmos ad=0.3808p pd=2.92u as=0.2128p ps=1.5u w=1.12u l=0.15u
X834 VDD.t897 sg13cmos5l_buf_1_45.X.t9 a_15754_18481# VDD.t231 sg13_lv_pmos ad=0.1563p pd=1.22u as=0.147p ps=1.54u w=0.42u l=0.13u
X835 VDD.t1754 sg13cmos5l_o21ai_1_28.Y a_13400_15238# VDD.t16 sg13_lv_pmos ad=0.1523p pd=1.38u as=0.1428p ps=1.52u w=0.42u l=0.13u
X836 VDD.t1007 a_9646_6351# sg13cmos5l_dfrbpq_1_13.D VDD.t2 sg13_lv_pmos ad=0.2254p pd=1.53u as=0.4256p ps=3u w=1.12u l=0.13u
X837 VSS.t931 sg13cmos5l_buf_1_26.A sg13cmos5l_a21oi_1_26.A1 VSS.t1103 sg13_lv_nmos ad=0.2516p pd=2.16u as=0.2516p ps=2.16u w=0.74u l=0.13u
X838 VSS.t13 a_17098_6130# sg13cmos5l_inv_1_5.A VSS.t530 sg13_lv_nmos ad=0.1406p pd=1.12u as=0.1406p ps=1.12u w=0.74u l=0.13u
X839 a_16725_7832# a_15783_7892# a_16586_7832# VSS.t1061 sg13_lv_nmos ad=79.8f pd=0.8u as=0.2373p ps=1.97u w=0.42u l=0.13u
X840 a_16725_7832# sg13cmos5l_buf_1_13.A VDD.t1297 VDD.t8 sg13_lv_pmos ad=0.147p pd=1.54u as=0.1563p ps=1.22u w=0.42u l=0.13u
X841 sg13cmos5l_o21ai_1_18.A2 sg13cmos5l_nand4_1_15.B a_9290_17044# VDD.t310 sg13_lv_pmos ad=0.3808p pd=2.92u as=0.1176p ps=1.33u w=1.12u l=0.13u
X842 VSS.t239 sg13cmos5l_a21oi_1_4.A2 sg13cmos5l_o21ai_1_23.A2 VSS.t1069 sg13_lv_nmos ad=0.2516p pd=2.16u as=0.1406p ps=1.12u w=0.74u l=0.13u
X843 a_17316_15247# a_17547_15356# a_17002_15457# VSS.t135 sg13_lv_nmos ad=0.2373p pd=1.97u as=79.8f ps=0.8u w=0.42u l=0.13u
X844 a_17254_15247# sg13cmos5l_dfrbpq_1_28.RESET_B VSS.t136 VSS.t135 sg13_lv_nmos ad=37.8f pd=0.6u as=0.1701p ps=1.65u w=0.42u l=0.13u
X845 VDD.t1039 sg13cmos5l_buf_1_13.X a_17318_11898# VDD.t0 sg13_lv_pmos ad=0.36237p pd=2.605u as=79.8f ps=0.8u w=0.42u l=0.13u
X846 a_20176_10918# a_19919_10775# a_20338_10698# VSS.t108 sg13_lv_nmos ad=0.1428p pd=1.52u as=37.8f ps=0.6u w=0.42u l=0.13u
X847 VSS.t1936 VDD.t2452 VSS.t1935 VSS.t1934 sg13_lv_nmos ad=0.1428p pd=1.52u as=0 ps=0 w=0.42u l=1u
X848 sg13cmos5l_dlygate4sd3_1_50.X a_4950_15302# VSS.t585 VSS.t2249 sg13_lv_nmos ad=0.2516p pd=2.16u as=0.1426p ps=1.16u w=0.74u l=0.13u
X849 VDD.t305 VSS.t1660 VDD.t348 VDD.t19 sg13_lv_pmos ad=0.34p pd=2.68u as=0 ps=0 w=1u l=1u
X850 sg13cmos5l_nand3_1_1.Y sg13cmos5l_nor3_1_2.B VDD.t1000 VDD.t0 sg13_lv_pmos ad=0.2128p pd=1.5u as=0.3808p ps=2.92u w=1.12u l=0.13u
X851 a_6585_9501# a_5643_9308# a_6383_9263# VDD.t52 sg13_lv_pmos ad=93.45f pd=0.865u as=0.2048p ps=1.63u w=0.42u l=0.13u
X852 VDD.t210 VSS.t1805 VDD.t209 VDD.t0 sg13_lv_pmos ad=0.19p pd=1.38u as=0 ps=0 w=1u l=1u
X853 a_9096_15996# sg13cmos5l_a21oi_1_12.Y VSS.t48 VSS.t1339 sg13_lv_nmos ad=0.1045p pd=0.93u as=0.187p ps=1.78u w=0.55u l=0.13u
X854 VSS.t163 a_22096_13942# a_21745_13799# VSS.t769 sg13_lv_nmos ad=79.8f pd=0.8u as=0.1428p ps=1.52u w=0.42u l=0.13u
X855 a_15499_11808# sg13cmos5l_inv_1_36.Y a_15405_11808# VSS.t1452 sg13_lv_nmos ad=0.1216p pd=1.02u as=0.2176p ps=1.96u w=0.64u l=0.13u
X856 VSS.t845 VDD.t2495 VSS.t538 VSS.t1811 sg13_lv_nmos ad=0.1428p pd=1.52u as=0 ps=0 w=0.42u l=1u
X857 VDD.t689 sg13cmos5l_a21oi_1_4.A1 a_16091_9948# VDD.t52 sg13_lv_pmos ad=0.2128p pd=1.5u as=0.2128p ps=1.5u w=1.12u l=0.13u
X858 VSS.t206 sg13cmos5l_buf_1_13.A a_14532_6162# VSS.t205 sg13_lv_nmos ad=0.1626p pd=1.415u as=60.89999f ps=0.71u w=0.42u l=0.13u
X859 VSS.t2138 VDD.t2388 VSS.t2140 VSS.t2139 sg13_lv_nmos ad=79.8f pd=0.8u as=0 ps=0 w=0.42u l=1u
X860 a_18034_5850# sg13cmos5l_buf_1_7.X VSS.t39 VSS.t38 sg13_lv_nmos ad=37.8f pd=0.6u as=79.8f ps=0.8u w=0.42u l=0.13u
X861 VSS.t1835 VDD.t2480 VSS.t1834 VSS.t88 sg13_lv_nmos ad=0.1428p pd=1.52u as=0 ps=0 w=0.42u l=1u
X862 a_22030_19287# a_22145_19286# VDD.t1616 VDD.t231 sg13_lv_pmos ad=0.34p pd=2.68u as=0.2254p ps=1.53u w=1u l=0.5u
X863 a_8879_10309# a_8037_9959# a_8785_10309# VSS.t817 sg13_lv_nmos ad=0.12665p pd=1.145u as=0.1428p ps=1.52u w=0.42u l=0.13u
X864 a_8520_8436# sg13cmos5l_dfrbpq_1_17.Q VSS.t190 VSS.t1001 sg13_lv_nmos ad=0.1045p pd=0.93u as=0.16755p ps=1.165u w=0.55u l=0.13u
X865 sg13cmos5l_and2_1_3.X a_15597_12256# VDD.t1344 VDD.t83 sg13_lv_pmos ad=0.3808p pd=2.92u as=0.1918p ps=1.5u w=1.12u l=0.13u
X866 a_21839_8797# a_20997_8447# a_21745_8797# VSS.t14 sg13_lv_nmos ad=0.12665p pd=1.145u as=0.1428p ps=1.52u w=0.42u l=0.13u
X867 sg13cmos5l_nand4_1_1.A a_15976_12972# VSS.t519 VSS.t128 sg13_lv_nmos ad=0.2886p pd=2.26u as=0.14875p ps=1.16u w=0.74u l=0.13u
X868 VDD.t285 VSS.t1736 VDD.t284 VDD.t83 sg13_lv_pmos ad=0.34p pd=2.68u as=0 ps=0 w=1u l=1u
X869 a_14534_10702# a_14264_10702# VSS.t86 VSS.t1602 sg13_lv_nmos ad=0.1428p pd=1.52u as=79.8f ps=0.8u w=0.42u l=0.5u
X870 a_20997_9959# sg13cmos5l_inv_1_2.A VSS.t266 VSS.t265 sg13_lv_nmos ad=0.2516p pd=2.16u as=4.90217p ps=31.68u w=0.74u l=0.13u
X871 VDD.t163 VSS.t1836 VDD.t162 VDD.t52 sg13_lv_pmos ad=0.34p pd=2.68u as=0 ps=0 w=1u l=1u
X872 bp1 a_21640_3900# VSS.t22 VSS.t193 sg13_lv_nmos ad=0.2886p pd=2.26u as=0.14875p ps=1.16u w=0.74u l=0.13u
X873 VDD.t270 a_10864_19990# a_10809_20085# VDD.t270 sg13_lv_pmos ad=2.69447p pd=17.64u as=93.45f ps=0.865u w=0.42u l=0.13u
X874 a_18287_15311# a_17445_15213# a_17028_15552# VDD.t16 sg13_lv_pmos ad=0.2048p pd=1.63u as=0.34p ps=2.68u w=1u l=0.13u
X875 VSS.t1999 VDD.t2406 VSS.t1997 VSS.t2049 sg13_lv_nmos ad=0.1428p pd=1.52u as=0 ps=0 w=0.42u l=1u
X876 sg13cmos5l_dlygate4sd3_1_8.X a_13014_8460# VDD.t906 VDD.t8 sg13_lv_pmos ad=0.4256p pd=3u as=0.2254p ps=1.53u w=1.12u l=0.13u
X877 a_11014_9508# sg13cmos5l_a21o_1_0.A2 VDD.t2091 VDD.t52 sg13_lv_pmos ad=0.34p pd=2.68u as=0.19p ps=1.38u w=1u l=0.13u
X878 VDD.t685 sg13cmos5l_a21oi_1_20.A2 a_16469_14484# VDD.t19 sg13_lv_pmos ad=0.2128p pd=1.5u as=0.3808p ps=2.92u w=1.12u l=0.13u
X879 VDD.t310 a_15023_17869# a_15280_17750# VDD.t310 sg13_lv_pmos ad=2.1916p pd=14.26u as=79.8f ps=0.8u w=0.42u l=0.13u
X880 VDD.t386 a_10124_11424# sg13cmos5l_a21oi_1_27.B1 VDD.t0 sg13_lv_pmos ad=0.2114p pd=1.54u as=0.42p ps=2.99u w=1.12u l=0.13u
X881 sg13cmos5l_dlygate4sd3_1_0.A a_22506_4948# VDD.t768 VDD.t5 sg13_lv_pmos ad=0.3808p pd=2.92u as=0.2128p ps=1.5u w=1.12u l=0.13u
X882 VDD.t151 VSS.t256 VDD.t150 VDD.t5 sg13_lv_pmos ad=0.19p pd=1.38u as=0 ps=0 w=1u l=1u
X883 a_10954_18481# a_11397_18237# a_11337_18649# VDD.t231 sg13_lv_pmos ad=79.8f pd=0.8u as=63f ps=0.72u w=0.42u l=0.13u
X884 a_22096_8678# a_21839_8797# a_22258_8874# VSS.t14 sg13_lv_nmos ad=0.1428p pd=1.52u as=37.8f ps=0.6u w=0.42u l=0.13u
X885 a_12414_7656# sg13cmos5l_nand2_1_5.Y VSS.t101 VSS.t1047 sg13_lv_nmos ad=96.2f pd=1u as=0.2516p ps=2.16u w=0.74u l=0.13u
X886 VSS.t863 sg13cmos5l_dfrbpq_1_28.RESET_B.t8 a_20810_16746# VSS.t862 sg13_lv_nmos ad=79.8f pd=0.8u as=37.8f ps=0.6u w=0.42u l=0.13u
X887 a_13590_7282# sg13cmos5l_a21oi_1_9.A2 sg13cmos5l_o21ai_1_0.B1 VSS.t2333 sg13_lv_nmos ad=88.8f pd=0.98u as=0.1628p ps=1.18u w=0.74u l=0.13u
X888 a_12504_15552# sg13cmos5l_o21ai_1_28.A1 VDD.t651 VDD.t16 sg13_lv_pmos ad=0.2128p pd=1.5u as=0.3808p ps=2.92u w=1.12u l=0.15u
X889 a_8091_6553# a_7199_6432# a_7989_6320# VDD.t2 sg13_lv_pmos ad=63f pd=0.72u as=79.8f ps=0.8u w=0.42u l=0.13u
X890 VSS.t26 a_21466_7642# a_21185_7864# VSS.t2593 sg13_lv_nmos ad=79.8f pd=0.8u as=0.1428p ps=1.52u w=0.42u l=0.5u
X891 VSS.t56 a_9466_18226# a_9185_18448# VSS.t1097 sg13_lv_nmos ad=79.8f pd=0.8u as=0.1428p ps=1.52u w=0.42u l=0.5u
X892 a_6021_12983# sg13cmos5l_dfrbpq_1_15.CLK VDD.t83 VDD.t83 sg13_lv_pmos ad=0.4088p pd=2.97u as=2.51485p ps=16.46u w=1.12u l=0.13u
X893 VDD.t1413 a_18095_19847# a_18762_20068# VDD.t270 sg13_lv_pmos ad=0.2128p pd=1.5u as=0.3864p ps=2.93u w=1.12u l=0.13u
X894 VDD.t1475 a_20015_19381# a_20682_19020# VDD.t231 sg13_lv_pmos ad=0.2128p pd=1.5u as=0.3864p ps=2.93u w=1.12u l=0.13u
X895 a_18574_14751# a_18689_14750# VDD.t1803 VDD.t19 sg13_lv_pmos ad=0.34p pd=2.68u as=0.2254p ps=1.53u w=1u l=0.5u
X896 VDD.t1144 sg13cmos5l_nor3_1_0.Y sg13cmos5l_o21ai_1_1.B1 VDD.t83 sg13_lv_pmos ad=0.3808p pd=2.92u as=0.2128p ps=1.5u w=1.12u l=0.13u
X897 VSS.t1795 VDD.t2501 VSS.t1797 VSS.t1796 sg13_lv_nmos ad=79.8f pd=0.8u as=0 ps=0 w=0.42u l=1u
X898 VSS.t161 a_17510_10702# a_17622_10766# VSS.t450 sg13_lv_nmos ad=0.1426p pd=1.16u as=0.1428p ps=1.52u w=0.42u l=0.5u
X899 a_22096_12430# sg13cmos5l_dfrbpq_1_28.RESET_B.t1 VDD.t83 VDD.t83 sg13_lv_pmos ad=79.8f pd=0.8u as=2.51485p ps=16.46u w=0.42u l=0.13u
X900 sg13cmos5l_dfrbpq_1_17.Q a_7338_7972# VSS.t702 VSS.t810 sg13_lv_nmos ad=0.2516p pd=2.16u as=0.1406p ps=1.12u w=0.74u l=0.13u
X901 VDD.t1309 sg13cmos5l_buf_1_45.X.t7 a_13738_17476# VDD.t310 sg13_lv_pmos ad=0.1563p pd=1.22u as=0.147p ps=1.54u w=0.42u l=0.13u
X902 VSS.t2085 VDD.t269 VSS.t2083 VSS.t2084 sg13_lv_nmos ad=79.8f pd=0.8u as=0 ps=0 w=0.42u l=1u
X903 VDD.t958 sg13cmos5l_inv_1_17.A sg13cmos5l_inv_1_17.Y VDD.t2 sg13_lv_pmos ad=0.3808p pd=2.92u as=0.3808p ps=2.92u w=1.12u l=0.13u
X904 VDD.t1506 a_5397_18416# a_4476_18222# VDD.t231 sg13_lv_pmos ad=0.36237p pd=2.605u as=0.34p ps=2.68u w=1u l=0.13u
X905 a_9040_19262# a_8783_19381# a_9202_19458# VSS.t1275 sg13_lv_nmos ad=0.1428p pd=1.52u as=37.8f ps=0.6u w=0.42u l=0.13u
X906 sg13cmos5l_nand2_1_15.B sg13cmos5l_o21ai_1_5.A2 VDD.t2356 VDD.t19 sg13_lv_pmos ad=0.2128p pd=1.5u as=0.3808p ps=2.92u w=1.12u l=0.13u
X907 sg13cmos5l_inv_1_18.A a_13590_11484# VDD.t740 VDD.t0 sg13_lv_pmos ad=0.4256p pd=3u as=0.2254p ps=1.53u w=1.12u l=0.13u
X908 VSS.t1132 a_6958_19959# sg13cmos5l_o21ai_1_20.B1 VSS.t2438 sg13_lv_nmos ad=0.1426p pd=1.16u as=0.2516p ps=2.16u w=0.74u l=0.13u
X909 VDD.t1741 sg13cmos5l_buf_8_2.A.t7 a_7498_18226# VDD.t231 sg13_lv_pmos ad=0.2128p pd=1.5u as=0.2128p ps=1.5u w=1.12u l=0.13u
X910 VSS.t435 sg13cmos5l_dlygate4sd3_1_98.A a_21080_17549# VSS.t225 sg13_lv_nmos ad=79.8f pd=0.8u as=0.1428p ps=1.52u w=0.42u l=0.13u
X911 VSS.t122 sg13cmos5l_buf_1_6.A a_18952_3176# VSS.t366 sg13_lv_nmos ad=0.14875p pd=1.16u as=0.187p ps=1.78u w=0.55u l=0.13u
X912 a_17733_8447# sg13cmos5l_inv_1_5.A VDD.t8 VDD.t8 sg13_lv_pmos ad=0.4088p pd=2.97u as=1.79022p ps=11.585u w=1.12u l=0.13u
X913 a_16550_19770# sg13cmos5l_dlygate4sd3_1_82.X VDD.t2218 VDD.t270 sg13_lv_pmos ad=79.8f pd=0.8u as=0.1428p ps=1.52u w=0.42u l=0.13u
X914 VDD.t331 VSS.t1741 VDD.t330 VDD.t0 sg13_lv_pmos ad=0.34p pd=2.68u as=0 ps=0 w=1u l=1u
X915 a_16982_7687# a_15804_7638# a_16586_7832# VSS.t920 sg13_lv_nmos ad=37.8f pd=0.6u as=0.1428p ps=1.52u w=0.42u l=0.13u
X916 VSS.t196 sg13cmos5l_nor4_1_1.D sg13cmos5l_nand4_1_15.B VSS.t66 sg13_lv_nmos ad=0.23757p pd=2.16u as=0.1406p ps=1.12u w=0.74u l=0.13u
X917 VDD.t231 a_7941_19031# a_8043_19031# VDD.t231 sg13_lv_pmos ad=1.54512p pd=9.865u as=0.3864p ps=2.93u w=1.12u l=0.13u
X918 VSS.t58 sg13cmos5l_nand3b_1_1.C a_10530_17874# VSS.t57 sg13_lv_nmos ad=0.2886p pd=2.26u as=0.1406p ps=1.12u w=0.74u l=0.13u
X919 VSS.t228 sg13cmos5l_dfrbpq_1_24.RESET_B a_3722_16746# VSS.t642 sg13_lv_nmos ad=79.8f pd=0.8u as=37.8f ps=0.6u w=0.42u l=0.13u
X920 sg13cmos5l_nand4_1_17.Y sg13cmos5l_buf_1_42.A a_18302_16362# VSS.t1236 sg13_lv_nmos ad=0.2516p pd=2.16u as=0.1406p ps=1.12u w=0.74u l=0.13u
X921 VSS.t46 a_9716_15202# sg13cmos5l_a21oi_1_12.A2 VSS.t130 sg13_lv_nmos ad=0.17255p pd=1.25u as=0.1406p ps=1.12u w=0.74u l=0.13u
X922 VSS.t1206 a_11152_12430# a_10801_12287# VSS.t1514 sg13_lv_nmos ad=79.8f pd=0.8u as=0.1428p ps=1.52u w=0.42u l=0.13u
X923 a_17542_8861# sg13cmos5l_buf_1_13.X VSS.t81 VSS.t603 sg13_lv_nmos ad=37.8f pd=0.6u as=0.1701p ps=1.65u w=0.42u l=0.13u
X924 a_12496_18478# sg13cmos5l_dfrbpq_1_24.RESET_B VDD.t231 VDD.t231 sg13_lv_pmos ad=79.8f pd=0.8u as=1.4953p ps=9.545u w=0.42u l=0.13u
X925 sg13cmos5l_o21ai_1_21.A2 sg13cmos5l_a21oi_1_27.B1 VSS.t54 VSS.t2288 sg13_lv_nmos ad=0.1406p pd=1.12u as=0.2516p ps=2.16u w=0.74u l=0.13u
X926 VSS.t81 sg13cmos5l_a21oi_1_3.Y a_16184_8477# VSS.t789 sg13_lv_nmos ad=79.8f pd=0.8u as=0.1428p ps=1.52u w=0.42u l=0.13u
X927 a_8434_17886# sg13cmos5l_o21ai_1_18.B1 sg13cmos5l_o21ai_1_19.B1 VSS.t2309 sg13_lv_nmos ad=0.1406p pd=1.12u as=0.2516p ps=2.16u w=0.74u l=0.15u
X928 VDD.t790 sg13cmos5l_nor3_1_0.Y a_15405_11808# VDD.t0 sg13_lv_pmos ad=0.1918p pd=1.5u as=0.1596p ps=1.22u w=0.84u l=0.13u
X929 a_11961_10071# a_11019_9959# a_11759_10309# VDD.t52 sg13_lv_pmos ad=93.45f pd=0.865u as=0.2048p ps=1.63u w=0.42u l=0.13u
X930 VDD.t2220 a_8218_19738# a_7937_19960# VDD.t270 sg13_lv_pmos ad=0.1523p pd=1.38u as=0.34p ps=2.68u w=1u l=0.5u
X931 a_17338_18984# sg13cmos5l_dlygate4sd3_1_82.A VDD.t842 VDD.t231 sg13_lv_pmos ad=0.1428p pd=1.52u as=0.1523p ps=1.38u w=0.42u l=0.13u
X932 VSS.t1628 VDD.t2557 VSS.t1627 VSS.t1626 sg13_lv_nmos ad=0.1428p pd=1.52u as=0 ps=0 w=0.42u l=1u
X933 VDD.t877 a_6682_15960# a_6401_16262# VDD.t16 sg13_lv_pmos ad=0.1523p pd=1.38u as=0.34p ps=2.68u w=1u l=0.5u
X934 a_10245_14020# sg13cmos5l_nor3_1_4.A VDD.t1083 VDD.t19 sg13_lv_pmos ad=0.2464p pd=1.56u as=0.3808p ps=2.92u w=1.12u l=0.13u
X935 VSS.t850 a_18188_4614# sg13cmos5l_a21oi_1_2.B1 VSS.t2358 sg13_lv_nmos ad=0.14875p pd=1.16u as=0.2886p ps=2.26u w=0.74u l=0.13u
X936 VSS.t309 a_3200_16283# sg13cmos5l_dlygate4sd3_1_50.A VSS.t227 sg13_lv_nmos ad=0.1406p pd=1.12u as=0.2516p ps=2.16u w=0.74u l=0.13u
X937 a_17804_4614# sg13cmos5l_buf_1_13.A VDD.t1279 VDD.t5 sg13_lv_pmos ad=0.2856p pd=2.36u as=0.2114p ps=1.54u w=0.84u l=0.13u
X938 a_12428_12936# sg13cmos5l_nand3_1_2.Y VSS.t159 VSS.t149 sg13_lv_nmos ad=0.187p pd=1.78u as=0.14875p ps=1.16u w=0.55u l=0.13u
X939 VSS.t117 a_19450_18226# a_19169_18448# VSS.t410 sg13_lv_nmos ad=79.8f pd=0.8u as=0.1428p ps=1.52u w=0.42u l=0.5u
X940 sg13cmos5l_inv_1_33.Y sg13cmos5l_dfrbpq_1_5.CLK VSS.t1173 VSS.t1055 sg13_lv_nmos ad=0.2516p pd=2.16u as=0.2516p ps=2.16u w=0.74u l=0.13u
X941 VDD.t302 VSS.t1663 VDD.t301 VDD.t16 sg13_lv_pmos ad=0.19p pd=1.38u as=0 ps=0 w=1u l=1u
X942 sg13cmos5l_dfrbpq_1_5.CLK a_21531_13342# VDD.t1600 VDD.t83 sg13_lv_pmos ad=0.2128p pd=1.5u as=0.2128p ps=1.5u w=1.12u l=0.13u
X943 a_7310_12400# sg13cmos5l_mux2_1_0.A1 a_7482_12508# VDD.t83 sg13_lv_pmos ad=0.2225p pd=1.445u as=0.2975p ps=1.595u w=1u l=0.13u
X944 sg13cmos5l_dfrbpq_1_41.CLK a_14218_18226# VDD.t1791 VDD.t231 sg13_lv_pmos ad=0.2128p pd=1.5u as=0.2128p ps=1.5u w=1.12u l=0.13u
X945 VSS.t199 sg13cmos5l_dfrbpq_1_24.Q sg13cmos5l_nand4_1_6.B VSS.t459 sg13_lv_nmos ad=0.23757p pd=2.16u as=0.1406p ps=1.12u w=0.74u l=0.13u
X946 VDD.t1250 a_16186_6888# a_15905_7190# VDD.t2 sg13_lv_pmos ad=0.1523p pd=1.38u as=0.34p ps=2.68u w=1u l=0.5u
X947 a_12394_18988# a_12837_19031# a_12134_19458# VSS.t1159 sg13_lv_nmos ad=79.8f pd=0.8u as=0.1296p ps=1.52u w=0.42u l=0.13u
X948 VSS.t420 a_13679_19381# a_14346_19020# VSS.t2523 sg13_lv_nmos ad=0.1406p pd=1.12u as=0.2516p ps=2.16u w=0.74u l=0.13u
X949 VDD.t4 VSS.t1920 VDD.t3 VDD.t2 sg13_lv_pmos ad=0.34p pd=2.68u as=0 ps=0 w=1u l=1u
X950 VDD.t1434 sg13cmos5l_nand2b_1_4.B sg13cmos5l_nand2b_1_4.Y VDD.t2 sg13_lv_pmos ad=0.2198p pd=1.53u as=0.2128p ps=1.5u w=1.12u l=0.13u
X951 VDD.t2037 a_7498_18226# sg13cmos5l_dfrbpq_1_19.CLK VDD.t231 sg13_lv_pmos ad=0.2128p pd=1.5u as=0.2128p ps=1.5u w=1.12u l=0.13u
X952 a_22096_4870# a_21839_4727# a_22258_4650# VSS.t42 sg13_lv_nmos ad=0.1428p pd=1.52u as=37.8f ps=0.6u w=0.42u l=0.13u
X953 a_19113_17555# a_18756_17512# VDD.t1254 VDD.t310 sg13_lv_pmos ad=63f pd=0.72u as=0.1563p ps=1.22u w=0.42u l=0.13u
X954 a_20794_3864# sg13cmos5l_dlygate4sd3_1_4.A VSS.t22 VSS.t304 sg13_lv_nmos ad=0.1428p pd=1.52u as=79.8f ps=0.8u w=0.42u l=0.13u
X955 VDD.t58 VSS.t1987 VDD.t41 VDD.t5 sg13_lv_pmos ad=0.19p pd=1.38u as=0 ps=0 w=1u l=1u
X956 a_22522_7642# sg13cmos5l_dlygate4sd3_1_16.A VSS.t37 VSS.t667 sg13_lv_nmos ad=0.1428p pd=1.52u as=79.8f ps=0.8u w=0.42u l=0.13u
X957 VDD.t8 a_20997_8447# a_21099_8447# VDD.t8 sg13_lv_pmos ad=1.8716p pd=12.115u as=0.3864p ps=2.93u w=1.12u l=0.13u
X958 sg13cmos5l_a21oi_1_26.Y sg13cmos5l_a21oi_1_18.B1 VSS.t1315 VSS.t1438 sg13_lv_nmos ad=0.1406p pd=1.12u as=0.2516p ps=2.16u w=0.74u l=0.13u
X959 VDD.t1649 sg13cmos5l_buf_1_47.X a_10172_19000# VDD.t231 sg13_lv_pmos ad=0.3808p pd=2.92u as=0.2128p ps=1.5u w=1.12u l=0.15u
X960 VSS.t50 a_10124_11424# sg13cmos5l_a21oi_1_27.B1 VSS.t49 sg13_lv_nmos ad=0.14875p pd=1.16u as=0.2886p ps=2.26u w=0.74u l=0.13u
X961 a_20806_4663# sg13cmos5l_buf_1_7.X VSS.t22 VSS.t21 sg13_lv_nmos ad=37.8f pd=0.6u as=0.1701p ps=1.65u w=0.42u l=0.13u
X962 a_18106_17472# sg13cmos5l_o21ai_1_23.B1 VDD.t1864 VDD.t310 sg13_lv_pmos ad=0.1428p pd=1.52u as=0.1523p ps=1.38u w=0.42u l=0.13u
X963 VSS.t159 a_12814_13239# sg13cmos5l_and2_1_6.A VSS.t149 sg13_lv_nmos ad=0.1426p pd=1.16u as=0.2516p ps=2.16u w=0.74u l=0.13u
X964 a_17220_7362# sg13cmos5l_dfrbpq_1_9.D a_17126_7362# VSS.t2234 sg13_lv_nmos ad=60.89999f pd=0.71u as=0.1428p ps=1.52u w=0.42u l=0.13u
X965 VSS.t122 sg13cmos5l_buf_1_8.A a_20872_3176# VSS.t2543 sg13_lv_nmos ad=0.14875p pd=1.16u as=0.187p ps=1.78u w=0.55u l=0.13u
X966 a_10066_19398# sg13cmos5l_buf_1_47.X VSS.t1155 VSS.t1292 sg13_lv_nmos ad=0.2516p pd=2.16u as=0.1406p ps=1.12u w=0.74u l=0.15u
X967 a_16631_8065# sg13cmos5l_dfrbpq_1_2.D a_17378_7674# VSS.t302 sg13_lv_nmos ad=0.1428p pd=1.52u as=60.89999f ps=0.71u w=0.42u l=0.13u
X968 VSS.t2143 VDD.t2387 VSS.t2145 VSS.t2144 sg13_lv_nmos ad=79.8f pd=0.8u as=0 ps=0 w=0.42u l=1u
X969 VSS.t1849 VDD.t2479 VSS.t1837 VSS.t88 sg13_lv_nmos ad=0.1428p pd=1.52u as=0 ps=0 w=0.42u l=1u
X970 sg13cmos5l_a22oi_1_2.Y sg13cmos5l_nand2b_1_0.B a_12414_7996# VDD.t8 sg13_lv_pmos ad=0.2128p pd=1.5u as=0.2744p ps=1.61u w=1.12u l=0.13u
X971 a_19448_13730# sg13cmos5l_nand4_1_18.C a_19346_13730# VSS.t128 sg13_lv_nmos ad=0.1406p pd=1.12u as=0.1406p ps=1.12u w=0.74u l=0.13u
X972 a_17615_5773# a_16773_5423# a_16356_5416# VDD.t5 sg13_lv_pmos ad=0.2048p pd=1.63u as=0.34p ps=2.68u w=1u l=0.13u
X973 a_17290_8404# a_17733_8447# a_17673_8483# VDD.t8 sg13_lv_pmos ad=79.8f pd=0.8u as=63f ps=0.72u w=0.42u l=0.13u
X974 a_6394_17472# sg13cmos5l_o21ai_1_11.Y VSS.t69 VSS.t1250 sg13_lv_nmos ad=0.1428p pd=1.52u as=79.8f ps=0.8u w=0.42u l=0.13u
X975 a_17153_16344# sg13cmos5l_inv_1_24.Y sg13cmos5l_a21oi_1_19.Y VSS.t2323 sg13_lv_nmos ad=0.1406p pd=1.12u as=0.1406p ps=1.12u w=0.74u l=0.13u
X976 a_20868_8861# a_20580_8440# a_20806_8861# VSS.t2331 sg13_lv_nmos ad=0.1428p pd=1.52u as=37.8f ps=0.6u w=0.42u l=0.13u
X977 a_19642_19738# sg13cmos5l_a21oi_1_25.Y VSS.t1099 VSS.t1488 sg13_lv_nmos ad=0.1428p pd=1.52u as=79.8f ps=0.8u w=0.42u l=0.13u
X978 VSS.t479 a_20207_5773# a_20874_5412# VSS.t10 sg13_lv_nmos ad=0.1406p pd=1.12u as=0.2516p ps=2.16u w=0.74u l=0.13u
X979 a_13102_5850# a_13343_5383# a_12631_5376# VSS.t275 sg13_lv_nmos ad=0.1428p pd=1.52u as=0.12665p ps=1.145u w=0.42u l=0.13u
X980 VDD.t1783 a_18286_16935# sg13cmos5l_inv_1_1.A VDD.t310 sg13_lv_pmos ad=0.2254p pd=1.53u as=0.4256p ps=3u w=1.12u l=0.13u
X981 a_17142_16754# sg13cmos5l_buf_1_42.A sg13cmos5l_a21oi_1_25.A2 VSS.t1233 sg13_lv_nmos ad=0.1406p pd=1.12u as=0.2516p ps=2.16u w=0.74u l=0.13u
X982 VDD.t0 a_8015_11821# a_8272_11702# VDD.t0 sg13_lv_pmos ad=2.1916p pd=14.26u as=79.8f ps=0.8u w=0.42u l=0.13u
X983 VSS.t479 a_20974_6351# sg13cmos5l_buf_1_8.A VSS.t258 sg13_lv_nmos ad=0.1426p pd=1.16u as=0.2516p ps=2.16u w=0.74u l=0.13u
X984 a_11397_18237# sg13cmos5l_dfrbpq_1_41.CLK VSS.t242 VSS.t671 sg13_lv_nmos ad=0.2516p pd=2.16u as=3.77667p ps=24.67u w=0.74u l=0.13u
X985 VSS.t373 a_15280_16238# a_14929_16357# VSS.t1081 sg13_lv_nmos ad=79.8f pd=0.8u as=0.1428p ps=1.52u w=0.42u l=0.13u
X986 a_10510_19287# a_10625_19286# VSS.t1155 VSS.t1157 sg13_lv_nmos ad=0.1428p pd=1.52u as=0.1426p ps=1.16u w=0.42u l=0.5u
X987 a_5303_18649# a_4607_18528# a_5397_18416# VSS.t1110 sg13_lv_nmos ad=0.1296p pd=1.52u as=79.8f ps=0.8u w=0.42u l=0.13u
X988 sg13cmos5l_dfrbpq_1_41.CLK a_14218_18226# VDD.t1787 VDD.t231 sg13_lv_pmos ad=0.2128p pd=1.5u as=0.2128p ps=1.5u w=1.12u l=0.13u
X989 VDD.t1685 sg13cmos5l_nand4_1_1.A sg13cmos5l_a21oi_1_16.A2 VDD.t19 sg13_lv_pmos ad=0.3808p pd=2.92u as=0.2128p ps=1.5u w=1.12u l=0.13u
X990 a_22005_18416# sg13cmos5l_dfrbpq_1_28.RESET_B.t11 VDD.t1255 VDD.t231 sg13_lv_pmos ad=0.147p pd=1.54u as=0.1563p ps=1.22u w=0.42u l=0.13u
X991 VSS.t1698 VDD.t2532 VSS.t1700 VSS.t1699 sg13_lv_nmos ad=79.8f pd=0.8u as=0 ps=0 w=0.42u l=1u
X992 VDD.t758 sg13cmos5l_inv_1_8.A sg13cmos5l_nand2_1_15.Y VDD.t83 sg13_lv_pmos ad=0.3808p pd=2.92u as=0.2128p ps=1.5u w=1.12u l=0.13u
X993 a_5222_17508# a_4952_17549# VSS.t384 VSS.t409 sg13_lv_nmos ad=0.1428p pd=1.52u as=79.8f ps=0.8u w=0.42u l=0.5u
X994 VSS.t375 sg13cmos5l_a21oi_1_12.Y a_7378_16374# VSS.t1338 sg13_lv_nmos ad=0.1406p pd=1.12u as=0.1406p ps=1.12u w=0.74u l=0.15u
X995 VDD.t610 VSS.t1973 VDD.t608 VDD.t5 sg13_lv_pmos ad=0.19p pd=1.38u as=0 ps=0 w=1u l=1u
X996 VDD.t2 a_21839_7285# a_22096_7166# VDD.t2 sg13_lv_pmos ad=2.1916p pd=14.26u as=79.8f ps=0.8u w=0.42u l=0.13u
X997 a_20580_6928# a_20554_6892# VSS.t26 VSS.t1573 sg13_lv_nmos ad=0.2516p pd=2.16u as=0.1626p ps=1.415u w=0.74u l=0.13u
X998 VSS.t1880 VDD.t2463 VSS.t1879 VSS.t1878 sg13_lv_nmos ad=0.1428p pd=1.52u as=0 ps=0 w=0.42u l=1u
X999 VSS.t91 a_18374_18262# a_18486_18326# VSS.t92 sg13_lv_nmos ad=0.1426p pd=1.16u as=0.1428p ps=1.52u w=0.42u l=0.5u
X1000 a_20580_12528# a_20554_12433# VSS.t9 VSS.t177 sg13_lv_nmos ad=0.2516p pd=2.16u as=0.1626p ps=1.415u w=0.74u l=0.13u
X1001 sg13cmos5l_o21ai_1_28.A1 sg13cmos5l_nand3b_1_1.C VSS.t52 VSS.t51 sg13_lv_nmos ad=0.2516p pd=2.16u as=0.2516p ps=2.16u w=0.74u l=0.13u
X1002 sg13cmos5l_nand3_1_2.Y sg13cmos5l_nor3_1_2.B VDD.t997 VDD.t0 sg13_lv_pmos ad=0.2128p pd=1.5u as=0.3808p ps=2.92u w=1.12u l=0.13u
X1003 VSS.t22 a_20398_4167# sg13cmos5l_inv_1_0.A VSS.t2381 sg13_lv_nmos ad=0.1426p pd=1.16u as=0.2516p ps=2.16u w=0.74u l=0.13u
X1004 sg13cmos5l_or4_1_0.D a_7050_9484# VSS.t260 VSS.t2231 sg13_lv_nmos ad=0.2516p pd=2.16u as=0.1406p ps=1.12u w=0.74u l=0.13u
X1005 VSS.t1987 VDD.t2430 VSS.t1987 VSS.t1989 sg13_lv_nmos ad=79.8f pd=0.8u as=0 ps=0 w=0.42u l=1u
X1006 VDD.t408 VSS.t1734 VDD.t407 VDD.t83 sg13_lv_pmos ad=0.19p pd=1.38u as=0 ps=0 w=1u l=1u
X1007 VSS.t441 sg13cmos5l_nor2b_1_0.B_N a_13198_9228# VSS.t440 sg13_lv_nmos ad=0.17255p pd=1.25u as=0.187p ps=1.78u w=0.55u l=0.13u
X1008 VDD.t462 VSS.t291 VDD.t460 VDD.t13 sg13_lv_pmos ad=0.19p pd=1.38u as=0 ps=0 w=1u l=1u
X1009 VDD.t13 VSS.t2070 VDD.t13 VDD.t13 sg13_lv_pmos ad=0.19p pd=1.38u as=0 ps=0 w=1u l=1u
X1010 VSS.t1099 a_20974_19959# sg13cmos5l_buf_1_24.A VSS.t1055 sg13_lv_nmos ad=0.1426p pd=1.16u as=0.2516p ps=2.16u w=0.74u l=0.13u
X1011 a_17717_19020# sg13cmos5l_a21oi_1_21.A1 VDD.t1311 VDD.t231 sg13_lv_pmos ad=0.2128p pd=1.5u as=0.2128p ps=1.5u w=1.12u l=0.13u
X1012 sg13cmos5l_dlygate4sd3_1_24.A a_22506_8436# VDD.t1927 VDD.t8 sg13_lv_pmos ad=0.3808p pd=2.92u as=0.2128p ps=1.5u w=1.12u l=0.13u
X1013 VSS.t1441 sg13cmos5l_a21oi_1_18.B1 sg13cmos5l_dlygate4sd3_1_76.A VSS.t128 sg13_lv_nmos ad=0.2516p pd=2.16u as=0.1406p ps=1.12u w=0.74u l=0.13u
X1014 a_15225_16119# a_14283_16007# a_15023_16357# VDD.t16 sg13_lv_pmos ad=93.45f pd=0.865u as=0.2048p ps=1.63u w=0.42u l=0.13u
X1015 a_3782_9948# a_3512_9989# VSS.t781 VSS.t780 sg13_lv_nmos ad=0.1428p pd=1.52u as=79.8f ps=0.8u w=0.42u l=0.5u
X1016 a_21839_14845# a_20997_14495# a_21745_14845# VSS.t394 sg13_lv_nmos ad=0.12665p pd=1.145u as=0.1428p ps=1.52u w=0.42u l=0.13u
X1017 a_17318_11898# a_18123_11471# a_17578_11428# VDD.t0 sg13_lv_pmos ad=0.1428p pd=1.52u as=79.8f ps=0.8u w=0.42u l=0.13u
X1018 VSS.t190 sg13cmos5l_nor3_1_2.B a_8955_9228# VSS.t552 sg13_lv_nmos ad=0.14505p pd=1.15u as=0.187p ps=1.78u w=0.55u l=0.13u
X1019 VSS.t2088 VDD.t300 VSS.t2090 VSS.t2089 sg13_lv_nmos ad=79.8f pd=0.8u as=0 ps=0 w=0.42u l=1u
X1020 VSS.t15 a_19995_9190# sg13cmos5l_inv_1_2.A VSS.t354 sg13_lv_nmos ad=0.2516p pd=2.16u as=0.1406p ps=1.12u w=0.74u l=0.13u
X1021 VDD.t1231 sg13cmos5l_buf_1_66.X a_7964_17064# VDD.t310 sg13_lv_pmos ad=0.3808p pd=2.92u as=0.2128p ps=1.5u w=1.12u l=0.15u
X1022 a_19044_19445# a_19275_19031# a_18730_18988# VSS.t1102 sg13_lv_nmos ad=0.2373p pd=1.97u as=79.8f ps=0.8u w=0.42u l=0.13u
X1023 a_12458_17044# sg13cmos5l_o21ai_1_5.A1 VDD.t1356 VDD.t310 sg13_lv_pmos ad=0.1176p pd=1.33u as=0.4032p ps=2.96u w=1.12u l=0.13u
X1024 sg13cmos5l_nor3_1_6.Y sg13cmos5l_and4_1_1.A VSS.t196 VSS.t149 sg13_lv_nmos ad=0.1694p pd=1.21u as=0.2618p ps=2.22u w=0.77u l=0.13u
X1025 VSS.t1837 VDD.t2484 VSS.t1836 VSS.t88 sg13_lv_nmos ad=0.1428p pd=1.52u as=0 ps=0 w=0.42u l=1u
X1026 VSS.t342 a_22522_9154# a_22241_9376# VSS.t341 sg13_lv_nmos ad=79.8f pd=0.8u as=0.1428p ps=1.52u w=0.42u l=0.5u
X1027 a_14423_14113# sg13cmos5l_buf_1_45.X.t1 VDD.t1247 VDD.t19 sg13_lv_pmos ad=79.8f pd=0.8u as=0.36237p ps=2.605u w=0.42u l=0.13u
X1028 a_17124_8874# sg13cmos5l_dfrbpq_1_11.D a_17030_8874# VSS.t1007 sg13_lv_nmos ad=60.89999f pd=0.71u as=0.1428p ps=1.52u w=0.42u l=0.13u
X1029 a_7066_18226# sg13cmos5l_o21ai_1_14.Y VDD.t1778 VDD.t231 sg13_lv_pmos ad=0.1428p pd=1.52u as=0.1523p ps=1.38u w=0.42u l=0.13u
X1030 VDD.t1399 VSS.t1905 VDD.t1403 VDD.t2 sg13_lv_pmos ad=0.34p pd=2.68u as=0 ps=0 w=1u l=1u
X1031 VDD.t1436 a_22234_19738# a_21953_19960# VDD.t270 sg13_lv_pmos ad=0.1523p pd=1.38u as=0.34p ps=2.68u w=1u l=0.5u
X1032 a_8037_9959# sg13cmos5l_dfrbpq_1_15.CLK VSS.t816 VSS.t2550 sg13_lv_nmos ad=0.2516p pd=2.16u as=4.90217p ps=31.68u w=0.74u l=0.13u
X1033 a_15694_7674# a_15935_7944# a_15223_7638# VSS.t828 sg13_lv_nmos ad=0.1428p pd=1.52u as=0.12665p ps=1.145u w=0.42u l=0.13u
X1034 sg13cmos5l_o21ai_1_19.Y sg13cmos5l_o21ai_1_19.B1 VDD.t394 VDD.t310 sg13_lv_pmos ad=0.2128p pd=1.5u as=0.3808p ps=2.92u w=1.12u l=0.15u
X1035 sg13cmos5l_inv_1_35.Y sg13cmos5l_dfrbpq_1_41.CLK VSS.t204 VSS.t672 sg13_lv_nmos ad=0.2516p pd=2.16u as=0.2516p ps=2.16u w=0.74u l=0.13u
X1036 VSS.t163 a_21531_13342# sg13cmos5l_dfrbpq_1_5.CLK VSS.t1245 sg13_lv_nmos ad=0.1406p pd=1.12u as=0.1406p ps=1.12u w=0.74u l=0.13u
X1037 sg13cmos5l_dfrbpq_1_11.Q a_19242_8436# VSS.t83 VSS.t586 sg13_lv_nmos ad=0.2516p pd=2.16u as=0.1406p ps=1.12u w=0.74u l=0.13u
X1038 a_5474_16434# sg13cmos5l_dfrbpq_1_24.RESET_B VSS.t176 VSS.t1144 sg13_lv_nmos ad=60.89999f pd=0.71u as=0.1626p ps=1.415u w=0.42u l=0.13u
X1039 VSS.t132 a_19066_15960# a_18785_16262# VSS.t703 sg13_lv_nmos ad=79.8f pd=0.8u as=0.1428p ps=1.52u w=0.42u l=0.5u
X1040 a_12984_15552# sg13cmos5l_buf_1_66.X VDD.t1235 VDD.t16 sg13_lv_pmos ad=0.2128p pd=1.5u as=0.3808p ps=2.92u w=1.12u l=0.15u
X1041 a_11180_15198# sg13cmos5l_dfrbpq_1_18.Q VDD.t1349 VDD.t16 sg13_lv_pmos ad=0.2856p pd=2.36u as=0.2114p ps=1.54u w=0.84u l=0.13u
X1042 a_20997_12189# sg13cmos5l_dfrbpq_1_5.CLK VDD.t83 VDD.t83 sg13_lv_pmos ad=0.4088p pd=2.97u as=2.51485p ps=16.46u w=1.12u l=0.13u
X1043 VDD.t231 a_6448_19262# a_6393_19143# VDD.t231 sg13_lv_pmos ad=1.54512p pd=9.865u as=93.45f ps=0.865u w=0.42u l=0.13u
X1044 VDD.t1169 sg13cmos5l_a21oi_1_27.B1 a_9435_15996# VDD.t16 sg13_lv_pmos ad=0.2144p pd=1.52u as=0.19p ps=1.38u w=1u l=0.13u
X1045 a_12538_10702# sg13cmos5l_inv_1_8.A VSS.t248 VSS.t247 sg13_lv_nmos ad=0.1406p pd=1.12u as=0.2516p ps=2.16u w=0.74u l=0.13u
X1046 VDD.t383 sg13cmos5l_buf_1_65.A sg13cmos5l_o21ai_1_20.A1 VDD.t310 sg13_lv_pmos ad=0.2128p pd=1.5u as=0.3808p ps=2.92u w=1.12u l=0.13u
X1047 VDD.t228 VSS.t1498 VDD.t227 VDD.t19 sg13_lv_pmos ad=0.19p pd=1.38u as=0 ps=0 w=1u l=1u
X1048 a_10214_10386# sg13cmos5l_a21o_1_0.X VDD.t847 VDD.t52 sg13_lv_pmos ad=79.8f pd=0.8u as=0.1428p ps=1.52u w=0.42u l=0.13u
X1049 VSS.t11 a_20464_5654# a_20113_5773# VSS.t10 sg13_lv_nmos ad=79.8f pd=0.8u as=0.1428p ps=1.52u w=0.42u l=0.13u
X1050 a_20868_12223# a_21099_12332# a_20554_12433# VSS.t2208 sg13_lv_nmos ad=0.2373p pd=1.97u as=79.8f ps=0.8u w=0.42u l=0.13u
X1051 VDD.t368 sg13cmos5l_buf_1_7.X a_20294_11898# VDD.t0 sg13_lv_pmos ad=0.36237p pd=2.605u as=79.8f ps=0.8u w=0.42u l=0.13u
X1052 VDD.t52 a_21839_10309# a_22096_10190# VDD.t52 sg13_lv_pmos ad=1.8716p pd=12.115u as=79.8f ps=0.8u w=0.42u l=0.13u
X1053 a_16164_5850# sg13cmos5l_inv_1_8.Y a_16070_5850# VSS.t416 sg13_lv_nmos ad=60.89999f pd=0.71u as=0.1428p ps=1.52u w=0.42u l=0.13u
X1054 a_22005_18416# a_21063_18476# a_21866_18416# VSS.t140 sg13_lv_nmos ad=79.8f pd=0.8u as=0.2373p ps=1.97u w=0.42u l=0.13u
X1055 VSS.t52 sg13cmos5l_nand4_1_6.B sg13cmos5l_nor2_1_12.Y VSS.t1347 sg13_lv_nmos ad=0.2516p pd=2.16u as=0.1406p ps=1.12u w=0.74u l=0.13u
X1056 a_4838_15238# a_4568_15238# VSS.t585 VSS.t1044 sg13_lv_nmos ad=0.1428p pd=1.52u as=79.8f ps=0.8u w=0.42u l=0.5u
X1057 a_17109_9344# a_16167_9404# a_16970_9344# VSS.t2315 sg13_lv_nmos ad=79.8f pd=0.8u as=0.2373p ps=1.97u w=0.42u l=0.13u
X1058 VSS.t2073 VDD.t13 VSS.t2075 VSS.t2074 sg13_lv_nmos ad=79.8f pd=0.8u as=0 ps=0 w=0.42u l=1u
X1059 VSS.t931 a_18352_19990# a_18001_19847# VSS.t930 sg13_lv_nmos ad=79.8f pd=0.8u as=0.1428p ps=1.52u w=0.42u l=0.13u
X1060 a_13738_15964# a_14181_16007# a_14121_16043# VDD.t16 sg13_lv_pmos ad=79.8f pd=0.8u as=63f ps=0.72u w=0.42u l=0.13u
X1061 a_8734_12214# sg13cmos5l_mux2_1_1.A1 a_8637_12214# VSS.t475 sg13_lv_nmos ad=0.1628p pd=1.18u as=0.13135p ps=1.095u w=0.74u l=0.13u
X1062 a_13808_9194# a_13749_9386# sg13cmos5l_inv_1_8.A VSS.t2294 sg13_lv_nmos ad=0.1406p pd=1.12u as=0.3404p ps=2.4u w=0.74u l=0.13u
X1063 VSS.t1795 VDD.t2491 VSS.t1797 VSS.t1796 sg13_lv_nmos ad=79.8f pd=0.8u as=0 ps=0 w=0.42u l=1u
X1064 sg13cmos5l_o21ai_1_25.Y sg13cmos5l_nor2_1_15.Y a_14136_17064# VDD.t310 sg13_lv_pmos ad=0.2128p pd=1.5u as=0.2128p ps=1.5u w=1.12u l=0.15u
X1065 sg13cmos5l_o21ai_1_15.B1 sg13cmos5l_o21ai_1_13.B1 VDD.t2184 VDD.t231 sg13_lv_pmos ad=0.2128p pd=1.5u as=0.3808p ps=2.92u w=1.12u l=0.15u
X1066 a_11397_18237# sg13cmos5l_dfrbpq_1_41.CLK VDD.t231 VDD.t231 sg13_lv_pmos ad=0.4088p pd=2.97u as=1.4953p ps=9.545u w=1.12u l=0.13u
X1067 VDD.t598 VSS.t1973 VDD.t559 VDD.t5 sg13_lv_pmos ad=0.19p pd=1.38u as=0 ps=0 w=1u l=1u
X1068 a_11167_7314# sg13cmos5l_a21oi_1_9.B1 a_11053_7314# VSS.t2497 sg13_lv_nmos ad=0.1216p pd=1.02u as=0.1408p ps=1.08u w=0.64u l=0.13u
X1069 VSS.t1865 VDD.t2466 VSS.t1864 VSS.t1863 sg13_lv_nmos ad=0.1428p pd=1.52u as=0 ps=0 w=0.42u l=1u
X1070 VSS.t2103 VDD.t2395 VSS.t2102 VSS.t2101 sg13_lv_nmos ad=0.1428p pd=1.52u as=0 ps=0 w=0.42u l=1u
X1071 a_21269_9484# sg13cmos5l_inv_1_4.Y VDD.t824 VDD.t52 sg13_lv_pmos ad=0.2128p pd=1.5u as=0.2128p ps=1.5u w=1.12u l=0.13u
X1072 a_10066_19398# sg13cmos5l_o21ai_1_13.B1 sg13cmos5l_o21ai_1_15.B1 VSS.t2435 sg13_lv_nmos ad=0.1406p pd=1.12u as=0.2516p ps=2.16u w=0.74u l=0.15u
X1073 VDD.t1540 a_15322_16714# a_15041_16936# VDD.t310 sg13_lv_pmos ad=0.1523p pd=1.38u as=0.34p ps=2.68u w=1u l=0.5u
X1074 sg13cmos5l_nand3_1_2.A a_14253_13320# VDD.t757 VDD.t83 sg13_lv_pmos ad=0.3808p pd=2.92u as=0.1918p ps=1.5u w=1.12u l=0.13u
X1075 VSS.t163 a_21531_13342# sg13cmos5l_dfrbpq_1_5.CLK VSS.t1241 sg13_lv_nmos ad=0.1406p pd=1.12u as=0.1406p ps=1.12u w=0.74u l=0.13u
X1076 a_20503_15960# a_21063_16083# a_21084_16357# VSS.t646 sg13_lv_nmos ad=0.12665p pd=1.145u as=0.3473p ps=2.71u w=0.74u l=0.13u
X1077 sg13cmos5l_nand2_1_19.Y sg13cmos5l_inv_1_8.A VDD.t756 VDD.t0 sg13_lv_pmos ad=0.2128p pd=1.5u as=0.3808p ps=2.92u w=1.12u l=0.13u
X1078 VSS.t1663 VDD.t2539 VSS.t1663 VSS.t1674 sg13_lv_nmos ad=79.8f pd=0.8u as=0 ps=0 w=0.42u l=1u
X1079 a_14133_5459# sg13cmos5l_buf_1_13.A VDD.t1932 VDD.t5 sg13_lv_pmos ad=0.147p pd=1.54u as=0.1563p ps=1.22u w=0.42u l=0.13u
X1080 a_7726_8703# a_7841_8702# VSS.t260 VSS.t1584 sg13_lv_nmos ad=0.1428p pd=1.52u as=0.1426p ps=1.16u w=0.42u l=0.5u
X1081 a_18490_9154# sg13cmos5l_nand3_1_0.Y VSS.t83 VSS.t301 sg13_lv_nmos ad=0.1428p pd=1.52u as=79.8f ps=0.8u w=0.42u l=0.13u
X1082 a_6490_16714# sg13cmos5l_o21ai_1_10.Y VSS.t407 VSS.t1456 sg13_lv_nmos ad=0.1428p pd=1.52u as=79.8f ps=0.8u w=0.42u l=0.13u
X1083 VDD.t1352 sg13cmos5l_o21ai_1_5.A1 a_11116_17044# VDD.t310 sg13_lv_pmos ad=0.4032p pd=2.96u as=0.1176p ps=1.33u w=1.12u l=0.13u
X1084 a_18587_4948# sg13cmos5l_a21oi_1_0.A2 VDD.t1696 VDD.t5 sg13_lv_pmos ad=0.3808p pd=2.92u as=0.2128p ps=1.5u w=1.12u l=0.13u
X1085 sg13cmos5l_a21oi_1_26.A2 sg13cmos5l_buf_1_42.A VDD.t1590 VDD.t310 sg13_lv_pmos ad=0.2128p pd=1.5u as=0.3808p ps=2.92u w=1.12u l=0.13u
X1086 VSS.t373 a_16172_15960# sg13cmos5l_a21oi_1_18.B1 VSS.t643 sg13_lv_nmos ad=0.14875p pd=1.16u as=0.2886p ps=2.26u w=0.74u l=0.13u
X1087 a_22625_15260# sg13cmos5l_inv_1_25.Y sg13cmos5l_a21oi_1_14.Y VSS.t197 sg13_lv_nmos ad=0.1406p pd=1.12u as=0.1406p ps=1.12u w=0.74u l=0.13u
X1088 VSS.t161 sg13cmos5l_buf_1_13.X a_18468_10698# VSS.t589 sg13_lv_nmos ad=0.1626p pd=1.415u as=60.89999f ps=0.71u w=0.42u l=0.13u
X1089 a_5303_18649# sg13cmos5l_dfrbpq_1_24.RESET_B VDD.t1506 VDD.t231 sg13_lv_pmos ad=79.8f pd=0.8u as=0.36237p ps=2.605u w=0.42u l=0.13u
X1090 VDD.t1942 sg13cmos5l_o21ai_1_3.Y a_16568_9989# VDD.t52 sg13_lv_pmos ad=0.1523p pd=1.38u as=0.1428p ps=1.52u w=0.42u l=0.13u
X1091 a_14668_8436# sg13cmos5l_dlygate4sd3_1_8.X sg13cmos5l_nor2_1_0.Y VDD.t8 sg13_lv_pmos ad=0.1176p pd=1.33u as=0.3808p ps=2.92u w=1.12u l=0.13u
X1092 VDD.t64 VSS.t1987 VDD.t63 VDD.t5 sg13_lv_pmos ad=0.34p pd=2.68u as=0 ps=0 w=1u l=1u
X1093 VDD.t1607 a_6394_17472# a_6113_17774# VDD.t310 sg13_lv_pmos ad=0.1523p pd=1.38u as=0.34p ps=2.68u w=1u l=0.5u
X1094 a_6682_15960# sg13cmos5l_o21ai_1_12.Y VSS.t407 VSS.t1318 sg13_lv_nmos ad=0.1428p pd=1.52u as=79.8f ps=0.8u w=0.42u l=0.13u
X1095 sg13cmos5l_nor2_1_7.Y sg13cmos5l_nand4_1_3.B a_5546_15532# VDD.t16 sg13_lv_pmos ad=0.3808p pd=2.92u as=0.1176p ps=1.33u w=1.12u l=0.13u
X1096 VSS.t174 a_17518_10215# sg13cmos5l_nand3_1_0.C VSS.t2494 sg13_lv_nmos ad=0.1426p pd=1.16u as=0.2516p ps=2.16u w=0.74u l=0.13u
X1097 VDD.t364 sg13cmos5l_buf_1_7.X a_20294_7362# VDD.t2 sg13_lv_pmos ad=0.36237p pd=2.605u as=79.8f ps=0.8u w=0.42u l=0.13u
X1098 a_15404_6888# sg13cmos5l_buf_1_15.A.t1 VSS.t99 VSS.t299 sg13_lv_nmos ad=0.187p pd=1.78u as=0.14875p ps=1.16u w=0.55u l=0.13u
X1099 VSS.t124 a_7334_14484# a_7446_14508# VSS.t123 sg13_lv_nmos ad=0.1426p pd=1.16u as=0.1428p ps=1.52u w=0.42u l=0.5u
X1100 a_14517_13880# sg13cmos5l_buf_1_45.X.t1 VDD.t1306 VDD.t19 sg13_lv_pmos ad=0.147p pd=1.54u as=0.1563p ps=1.22u w=0.42u l=0.13u
X1101 a_14698_6385# a_15141_6141# a_14438_6162# VSS.t205 sg13_lv_nmos ad=79.8f pd=0.8u as=0.1296p ps=1.52u w=0.42u l=0.13u
X1102 a_2156_19734# sg13cmos5l_dlygate4sd3_1_64.X VDD.t1366 VDD.t270 sg13_lv_pmos ad=0.2856p pd=2.36u as=0.2114p ps=1.54u w=0.84u l=0.13u
X1103 VDD.t125 VSS.t1997 VDD.t124 VDD.t5 sg13_lv_pmos ad=0.34p pd=2.68u as=0 ps=0 w=1u l=1u
X1104 sg13cmos5l_a21oi_1_25.Y sg13cmos5l_a21oi_1_18.B1 VSS.t1315 VSS.t1439 sg13_lv_nmos ad=0.1406p pd=1.12u as=0.2516p ps=2.16u w=0.74u l=0.13u
X1105 VSS.t645 a_5036_13686# sg13cmos5l_dfrbpq_1_24.RESET_B VSS.t644 sg13_lv_nmos ad=0.14875p pd=1.16u as=0.2886p ps=2.26u w=0.74u l=0.13u
X1106 a_14446_12508# sg13cmos5l_nand2_1_19.Y sg13cmos5l_nand2b_1_1.A_N VDD.t83 sg13_lv_pmos ad=0.2128p pd=1.5u as=0.3808p ps=2.92u w=1.12u l=0.13u
X1107 VDD.t1596 a_9147_13028# sg13cmos5l_a21oi_1_27.A2 VDD.t83 sg13_lv_pmos ad=0.3808p pd=2.92u as=0.2128p ps=1.5u w=1.12u l=0.13u
X1108 VSS.t120 sg13cmos5l_a21oi_1_4.A2 a_16193_10296# VSS.t1070 sg13_lv_nmos ad=0.2516p pd=2.16u as=0.1406p ps=1.12u w=0.74u l=0.13u
X1109 VDD.t123 VSS.t2005 VDD.t121 VDD.t13 sg13_lv_pmos ad=0.19p pd=1.38u as=0 ps=0 w=1u l=1u
X1110 VSS.t362 a_8122_10666# a_7841_10888# VSS.t2199 sg13_lv_nmos ad=79.8f pd=0.8u as=0.1428p ps=1.52u w=0.42u l=0.5u
X1111 a_20338_10698# sg13cmos5l_buf_1_13.X VSS.t109 VSS.t108 sg13_lv_nmos ad=37.8f pd=0.6u as=79.8f ps=0.8u w=0.42u l=0.13u
X1112 sg13cmos5l_dlygate4sd3_1_28.A a_20586_7972# VSS.t26 VSS.t2343 sg13_lv_nmos ad=0.2516p pd=2.16u as=0.1406p ps=1.12u w=0.74u l=0.13u
X1113 sg13cmos5l_dfrbpq_1_19.CLK a_7498_18226# VSS.t5 VSS.t2269 sg13_lv_nmos ad=0.1406p pd=1.12u as=0.1406p ps=1.12u w=0.74u l=0.13u
X1114 sg13cmos5l_o21ai_1_11.A2 sg13cmos5l_o21ai_1_8.B1 VDD.t1543 VDD.t16 sg13_lv_pmos ad=0.2128p pd=1.5u as=0.3808p ps=2.92u w=1.12u l=0.15u
X1115 VDD.t969 a_19630_15423# sg13cmos5l_inv_1_24.A VDD.t16 sg13_lv_pmos ad=0.2254p pd=1.53u as=0.4256p ps=3u w=1.12u l=0.13u
X1116 a_20937_9995# a_20580_9952# VDD.t1034 VDD.t52 sg13_lv_pmos ad=63f pd=0.72u as=0.1563p ps=1.22u w=0.42u l=0.13u
X1117 sg13cmos5l_inv_1_5.A a_17098_6130# VDD.t986 VDD.t2 sg13_lv_pmos ad=0.2128p pd=1.5u as=0.2128p ps=1.5u w=1.12u l=0.13u
X1118 a_17366_9199# a_16188_9150# a_16970_9344# VSS.t2360 sg13_lv_nmos ad=37.8f pd=0.6u as=0.1428p ps=1.52u w=0.42u l=0.13u
X1119 a_13015_13686# a_13575_13940# a_13596_13686# VSS.t66 sg13_lv_nmos ad=0.12665p pd=1.145u as=0.3473p ps=2.71u w=0.74u l=0.13u
X1120 VSS.t850 VDD.t2399 VSS.t850 VSS.t2064 sg13_lv_nmos ad=79.8f pd=0.8u as=0 ps=0 w=0.42u l=1u
X1121 VSS.t31 sg13cmos5l_inv_1_15.A sg13cmos5l_inv_1_15.Y VSS.t1105 sg13_lv_nmos ad=0.2516p pd=2.16u as=0.2516p ps=2.16u w=0.74u l=0.13u
X1122 sg13cmos5l_a21oi_1_6.Y sg13cmos5l_buf_1_16.A a_19829_8436# VDD.t8 sg13_lv_pmos ad=0.3808p pd=2.92u as=0.2128p ps=1.5u w=1.12u l=0.13u
X1123 VDD.t691 sg13cmos5l_a21oi_1_4.A1 sg13cmos5l_nand3_1_5.Y VDD.t16 sg13_lv_pmos ad=0.2128p pd=1.5u as=0.3808p ps=2.92u w=1.12u l=0.13u
X1124 a_21254_10702# a_20984_10702# VSS.t76 VSS.t556 sg13_lv_nmos ad=0.1428p pd=1.52u as=79.8f ps=0.8u w=0.42u l=0.5u
X1125 VSS.t11 a_18778_6130# a_18497_6352# VSS.t285 sg13_lv_nmos ad=79.8f pd=0.8u as=0.1428p ps=1.52u w=0.42u l=0.5u
X1126 VDD.t325 VSS.t1645 VDD.t324 VDD.t310 sg13_lv_pmos ad=0.34p pd=2.68u as=0 ps=0 w=1u l=1u
X1127 VDD.t1513 sg13cmos5l_dfrbpq_1_24.RESET_B a_4714_14452# VDD.t19 sg13_lv_pmos ad=0.1563p pd=1.22u as=0.147p ps=1.54u w=0.42u l=0.13u
X1128 sg13cmos5l_dlygate4sd3_1_43.A sg13cmos5l_nand2b_1_4.Y a_8671_7996# VDD.t8 sg13_lv_pmos ad=0.2128p pd=1.5u as=0.2716p ps=1.605u w=1.12u l=0.13u
X1129 a_13676_19734# sg13cmos5l_o21ai_1_26.B1 VDD.t1293 VDD.t270 sg13_lv_pmos ad=0.2856p pd=2.36u as=0.2114p ps=1.54u w=0.84u l=0.13u
X1130 VSS.t441 a_12902_8436# a_13014_8460# VSS.t2561 sg13_lv_nmos ad=0.1426p pd=1.16u as=0.1428p ps=1.52u w=0.42u l=0.5u
X1131 a_12239_18335# a_11397_18237# a_12145_18335# VSS.t1259 sg13_lv_nmos ad=0.12665p pd=1.145u as=0.1428p ps=1.52u w=0.42u l=0.13u
X1132 a_20384_16283# a_20503_15960# VDD.t823 VDD.t16 sg13_lv_pmos ad=0.3864p pd=2.93u as=0.2128p ps=1.5u w=1.12u l=0.13u
X1133 a_5412_9199# a_5643_9308# a_5098_9409# VSS.t88 sg13_lv_nmos ad=0.2373p pd=1.97u as=79.8f ps=0.8u w=0.42u l=0.13u
X1134 a_13460_6924# sg13cmos5l_a21oi_1_9.A1 VDD.t1116 VDD.t2 sg13_lv_pmos ad=0.3808p pd=2.92u as=0.2128p ps=1.5u w=1.12u l=0.13u
X1135 a_12140_19734# sg13cmos5l_o21ai_1_18.B1 VDD.t2071 VDD.t270 sg13_lv_pmos ad=0.2856p pd=2.36u as=0.2114p ps=1.54u w=0.84u l=0.13u
X1136 VDD.t1059 a_1294_15423# sg13cmos5l_buf_1_29.A VDD.t16 sg13_lv_pmos ad=0.2254p pd=1.53u as=0.4256p ps=3u w=1.12u l=0.13u
X1137 VDD.t984 a_17098_6130# sg13cmos5l_inv_1_5.A VDD.t2 sg13_lv_pmos ad=0.2128p pd=1.5u as=0.2128p ps=1.5u w=1.12u l=0.13u
X1138 VSS.t569 VDD.t2475 VSS.t569 VSS.t1857 sg13_lv_nmos ad=0.1428p pd=1.52u as=0 ps=0 w=0.42u l=1u
X1139 a_9348_20088# a_9867_19892# a_10607_19847# VSS.t2480 sg13_lv_nmos ad=0.3473p pd=2.71u as=0.12665p ps=1.145u w=0.74u l=0.13u
X1140 VDD.t868 sg13cmos5l_dfrbpq_1_28.RESET_B.t4 a_20554_13945# VDD.t19 sg13_lv_pmos ad=0.1563p pd=1.22u as=0.147p ps=1.54u w=0.42u l=0.13u
X1141 VSS.t1698 VDD.t2526 VSS.t1700 VSS.t1699 sg13_lv_nmos ad=79.8f pd=0.8u as=0 ps=0 w=0.42u l=1u
X1142 VSS.t1785 VDD.t2503 VSS.t1784 VSS.t1783 sg13_lv_nmos ad=0.1428p pd=1.52u as=0 ps=0 w=0.42u l=1u
X1143 sg13cmos5l_a21oi_1_4.A2 a_13096_15996# VDD.t729 VDD.t16 sg13_lv_pmos ad=0.42p pd=2.99u as=0.2114p ps=1.54u w=1.12u l=0.13u
X1144 a_8411_15532# sg13cmos5l_a21o_1_2.A1 sg13cmos5l_a21oi_1_12.Y VDD.t16 sg13_lv_pmos ad=0.2128p pd=1.5u as=0.3808p ps=2.92u w=1.12u l=0.13u
X1145 VDD.t70 VSS.t1987 VDD.t68 VDD.t13 sg13_lv_pmos ad=0.19p pd=1.38u as=0 ps=0 w=1u l=1u
X1146 valid a_12040_15272# VDD.t726 VDD.t16 sg13_lv_pmos ad=0.42p pd=2.99u as=0.2114p ps=1.54u w=1.12u l=0.13u
X1147 VSS.t850 sg13cmos5l_buf_1_3.A sg13cmos5l_inv_1_6.Y VSS.t1600 sg13_lv_nmos ad=0.2516p pd=2.16u as=0.2516p ps=2.16u w=0.74u l=0.13u
X1148 a_15691_12256# sg13cmos5l_nand3_1_2.A a_15597_12256# VSS.t1349 sg13_lv_nmos ad=0.1216p pd=1.02u as=0.2176p ps=1.96u w=0.64u l=0.13u
X1149 VSS.t266 a_20997_9959# a_21099_9959# VSS.t2384 sg13_lv_nmos ad=4.90217p pd=31.68u as=0.2516p ps=2.16u w=0.74u l=0.13u
X1150 VSS.t99 sg13cmos5l_buf_1_13.A a_15530_7674# VSS.t2361 sg13_lv_nmos ad=79.8f pd=0.8u as=37.8f ps=0.6u w=0.42u l=0.13u
X1151 VSS.t182 sg13cmos5l_dfrbpq_1_24.RESET_B a_5412_13410# VSS.t1147 sg13_lv_nmos ad=0.1626p pd=1.415u as=60.89999f ps=0.71u w=0.42u l=0.13u
X1152 VDD.t1167 sg13cmos5l_inv_1_7.A a_19432_3900# VDD.t13 sg13_lv_pmos ad=0.2114p pd=1.54u as=0.2856p ps=2.36u w=0.84u l=0.13u
X1153 a_7524_19024# a_7498_18988# VSS.t1127 VSS.t1298 sg13_lv_nmos ad=0.2516p pd=2.16u as=0.1626p ps=1.415u w=0.74u l=0.13u
X1154 VDD.t1720 sg13cmos5l_o21ai_1_14.A1 a_8444_17064# VDD.t310 sg13_lv_pmos ad=0.3808p pd=2.92u as=0.2128p ps=1.5u w=1.12u l=0.15u
X1155 VSS.t150 a_13210_12936# a_12929_13238# VSS.t149 sg13_lv_nmos ad=79.8f pd=0.8u as=0.1428p ps=1.52u w=0.42u l=0.5u
X1156 sg13cmos5l_dfrbpq_1_13.CLK a_12987_10318# VDD.t1262 VDD.t52 sg13_lv_pmos ad=0.2128p pd=1.5u as=0.2128p ps=1.5u w=1.12u l=0.13u
X1157 a_17914_9912# sg13cmos5l_dlygate4sd3_1_25.A VDD.t1220 VDD.t52 sg13_lv_pmos ad=0.1428p pd=1.52u as=0.1523p ps=1.38u w=0.42u l=0.13u
X1158 VDD.t5 a_21839_4727# a_22096_4870# VDD.t5 sg13_lv_pmos ad=1.96072p pd=12.69u as=79.8f ps=0.8u w=0.42u l=0.13u
X1159 a_5397_18416# sg13cmos5l_dfrbpq_1_24.RESET_B VDD.t1505 VDD.t231 sg13_lv_pmos ad=0.147p pd=1.54u as=0.1563p ps=1.22u w=0.42u l=0.13u
X1160 sg13cmos5l_nor4_1_0.C a_8520_8436# VSS.t190 VSS.t2455 sg13_lv_nmos ad=0.2516p pd=2.16u as=0.14135p ps=1.14u w=0.74u l=0.13u
X1161 VSS.t839 sg13cmos5l_nor2_1_7.Y a_7858_16742# VSS.t1480 sg13_lv_nmos ad=0.1406p pd=1.12u as=0.1406p ps=1.12u w=0.74u l=0.15u
X1162 a_15322_16714# sg13cmos5l_dfrbpq_1_38.Q VDD.t1540 VDD.t310 sg13_lv_pmos ad=0.1428p pd=1.52u as=0.1523p ps=1.38u w=0.42u l=0.13u
X1163 VDD.t1582 sg13cmos5l_nand4_1_18.C sg13cmos5l_a21oi_1_2.A2 VDD.t83 sg13_lv_pmos ad=0.2128p pd=1.5u as=0.2128p ps=1.5u w=1.12u l=0.13u
X1164 sg13cmos5l_a21oi_1_7.A2 sg13cmos5l_nand4_1_1.A a_18782_12218# VSS.t1324 sg13_lv_nmos ad=0.2516p pd=2.16u as=0.1406p ps=1.12u w=0.74u l=0.13u
X1165 VSS.t39 sg13cmos5l_buf_8_2.A.t1 a_17098_6130# VSS.t285 sg13_lv_nmos ad=0.1406p pd=1.12u as=0.1406p ps=1.12u w=0.74u l=0.13u
X1166 VSS.t15 a_22096_8678# a_21745_8797# VSS.t14 sg13_lv_nmos ad=79.8f pd=0.8u as=0.1428p ps=1.52u w=0.42u l=0.13u
X1167 a_14347_13320# sg13cmos5l_nand2_1_19.A a_14253_13320# VSS.t332 sg13_lv_nmos ad=0.1216p pd=1.02u as=0.2176p ps=1.96u w=0.64u l=0.13u
X1168 a_10914_14020# sg13cmos5l_mux2_1_1.A1 a_10812_14020# VDD.t19 sg13_lv_pmos ad=0.2128p pd=1.5u as=0.2128p ps=1.5u w=1.12u l=0.13u
X1169 a_13575_13940# a_13727_13992# VDD.t19 VDD.t19 sg13_lv_pmos ad=0.3864p pd=2.93u as=2.1916p ps=14.26u w=1.12u l=0.13u
X1170 VSS.t520 sg13cmos5l_nand4_1_18.D a_18882_13730# VSS.t128 sg13_lv_nmos ad=0.2516p pd=2.16u as=0.1406p ps=1.12u w=0.74u l=0.13u
X1171 a_1294_9375# a_1409_9376# VDD.t1944 VDD.t52 sg13_lv_pmos ad=0.34p pd=2.68u as=0.2254p ps=1.53u w=1u l=0.5u
X1172 VSS.t937 a_10607_19847# a_11274_20068# VSS.t2425 sg13_lv_nmos ad=0.1406p pd=1.12u as=0.2516p ps=2.16u w=0.74u l=0.13u
X1173 VSS.t199 sg13cmos5l_buf_1_25.A a_12040_15272# VSS.t1115 sg13_lv_nmos ad=0.14875p pd=1.16u as=0.187p ps=1.78u w=0.55u l=0.13u
X1174 VSS.t291 VDD.t2410 VSS.t291 VSS.t2041 sg13_lv_nmos ad=79.8f pd=0.8u as=0 ps=0 w=0.42u l=1u
X1175 VDD.t602 VSS.t1973 VDD.t600 VDD.t5 sg13_lv_pmos ad=0.19p pd=1.38u as=0 ps=0 w=1u l=1u
X1176 VSS.t1058 VDD.t2489 VSS.t1058 VSS.t1824 sg13_lv_nmos ad=0.1428p pd=1.52u as=0 ps=0 w=0.42u l=1u
X1177 VDD.t105 VSS.t2002 VDD.t103 VDD.t13 sg13_lv_pmos ad=0.19p pd=1.38u as=0 ps=0 w=1u l=1u
X1178 VSS.t2108 VDD.t2394 VSS.t2107 VSS.t2106 sg13_lv_nmos ad=0.1428p pd=1.52u as=0 ps=0 w=0.42u l=1u
X1179 a_15914_9186# a_15607_9150# a_15820_9186# VSS.t2447 sg13_lv_nmos ad=37.8f pd=0.6u as=0.1428p ps=1.52u w=0.42u l=0.13u
X1180 a_6448_19262# a_6191_19381# a_6610_19458# VSS.t1300 sg13_lv_nmos ad=0.1428p pd=1.52u as=37.8f ps=0.6u w=0.42u l=0.13u
X1181 a_11372_10662# sg13cmos5l_buf_1_20.A VDD.t663 VDD.t0 sg13_lv_pmos ad=0.2856p pd=2.36u as=0.2114p ps=1.54u w=0.84u l=0.13u
X1182 VDD.t1260 sg13cmos5l_buf_8_2.A a_12987_10318# VDD.t52 sg13_lv_pmos ad=0.2128p pd=1.5u as=0.3808p ps=2.92u w=1.12u l=0.13u
X1183 VSS.t113 sg13cmos5l_buf_8_2.A.t6 a_14218_18226# VSS.t2609 sg13_lv_nmos ad=0.1406p pd=1.12u as=0.1406p ps=1.12u w=0.74u l=0.13u
X1184 VDD.t19 a_5157_14495# a_5259_14495# VDD.t19 sg13_lv_pmos ad=2.1916p pd=14.26u as=0.3864p ps=2.93u w=1.12u l=0.13u
X1185 VDD.t83 a_6021_12983# a_6123_12983# VDD.t83 sg13_lv_pmos ad=2.51485p pd=16.46u as=0.3864p ps=2.93u w=1.12u l=0.13u
X1186 VSS.t1981 VDD.t2432 VSS.t1981 VSS.t1984 sg13_lv_nmos ad=79.8f pd=0.8u as=0 ps=0 w=0.42u l=1u
X1187 a_9070_18447# a_9185_18448# VSS.t56 VSS.t1253 sg13_lv_nmos ad=0.1428p pd=1.52u as=0.1426p ps=1.16u w=0.42u l=0.5u
X1188 a_17051_15996# sg13cmos5l_buf_1_16.A sg13cmos5l_a21oi_1_19.Y VDD.t16 sg13_lv_pmos ad=0.2128p pd=1.5u as=0.3808p ps=2.92u w=1.12u l=0.13u
X1189 VDD.t692 sg13cmos5l_a21oi_1_4.A1 sg13cmos5l_nand2_1_15.B VDD.t19 sg13_lv_pmos ad=0.3808p pd=2.92u as=0.2128p ps=1.5u w=1.12u l=0.13u
X1190 sg13cmos5l_a21oi_1_3.A2 sg13cmos5l_nand4_1_18.D VDD.t970 VDD.t19 sg13_lv_pmos ad=0.2128p pd=1.5u as=0.3808p ps=2.92u w=1.12u l=0.13u
X1191 a_21350_17508# a_21080_17549# VSS.t435 VSS.t225 sg13_lv_nmos ad=0.1428p pd=1.52u as=79.8f ps=0.8u w=0.42u l=0.5u
X1192 VDD.t1726 sg13cmos5l_nand4_1_1.C sg13cmos5l_a21oi_1_13.A2 VDD.t19 sg13_lv_pmos ad=0.2128p pd=1.5u as=0.2128p ps=1.5u w=1.12u l=0.13u
X1193 sg13cmos5l_inv_1_18.A a_13590_11484# VSS.t153 VSS.t219 sg13_lv_nmos ad=0.2516p pd=2.16u as=0.1426p ps=1.16u w=0.74u l=0.13u
X1194 VSS.t190 a_8122_8400# a_7841_8702# VSS.t826 sg13_lv_nmos ad=79.8f pd=0.8u as=0.1428p ps=1.52u w=0.42u l=0.5u
X1195 VDD.t891 sg13cmos5l_buf_1_45.X.t13 a_16550_19770# VDD.t270 sg13_lv_pmos ad=0.36237p pd=2.605u as=79.8f ps=0.8u w=0.42u l=0.13u
X1196 VDD.t231 a_5349_19031# a_5451_19031# VDD.t231 sg13_lv_pmos ad=1.54512p pd=9.865u as=0.3864p ps=2.93u w=1.12u l=0.13u
X1197 VSS.t107 a_11558_19020# a_11670_19044# VSS.t1295 sg13_lv_nmos ad=0.1426p pd=1.16u as=0.1428p ps=1.52u w=0.42u l=0.5u
X1198 sg13cmos5l_nand3b_1_1.Y sg13cmos5l_nor4_1_4.C VDD.t1773 VDD.t16 sg13_lv_pmos ad=0.2128p pd=1.5u as=0.2128p ps=1.5u w=1.12u l=0.13u
X1199 a_14061_8784# sg13cmos5l_inv_1_18.Y VDD.t2146 VDD.t8 sg13_lv_pmos ad=0.1596p pd=1.22u as=0.2856p ps=2.36u w=0.84u l=0.13u
X1200 sg13cmos5l_inv_1_31.A a_19035_16750# VSS.t132 VSS.t448 sg13_lv_nmos ad=0.1406p pd=1.12u as=0.1406p ps=1.12u w=0.74u l=0.13u
X1201 a_7416_12404# sg13cmos5l_mux2_1_0.S VSS.t74 VSS.t2256 sg13_lv_nmos ad=0.187p pd=1.78u as=0.18945p ps=1.27u w=0.55u l=0.13u
X1202 sg13cmos5l_dfrbpq_1_44.Q a_14346_19020# VDD.t2261 VDD.t231 sg13_lv_pmos ad=0.3808p pd=2.92u as=0.2128p ps=1.5u w=1.12u l=0.13u
X1203 a_3886_16746# a_3628_16746# VSS.t228 VSS.t642 sg13_lv_nmos ad=0.1428p pd=1.52u as=79.8f ps=0.8u w=0.42u l=0.13u
X1204 VDD.t143 VSS.t1707 VDD.t142 VDD.t19 sg13_lv_pmos ad=0.34p pd=2.68u as=0 ps=0 w=1u l=1u
X1205 a_10365_7194# sg13cmos5l_dfrbpq_1_47.Q VSS.t759 VSS.t987 sg13_lv_nmos ad=0.187p pd=1.78u as=0.14505p ps=1.15u w=0.55u l=0.13u
X1206 VDD.t2214 a_5626_19738# a_5345_19960# VDD.t270 sg13_lv_pmos ad=0.1523p pd=1.38u as=0.34p ps=2.68u w=1u l=0.5u
X1207 sg13cmos5l_o21ai_1_25.B1 a_15126_19044# VDD.t2263 VDD.t231 sg13_lv_pmos ad=0.4256p pd=3u as=0.2254p ps=1.53u w=1.12u l=0.13u
X1208 VSS.t54 sg13cmos5l_nand4_1_8.B sg13cmos5l_o21ai_1_21.A2 VSS.t1486 sg13_lv_nmos ad=0.2516p pd=2.16u as=0.1406p ps=1.12u w=0.74u l=0.13u
X1209 VDD.t1555 sg13cmos5l_dfrbpq_1_13.RESET_B a_4838_9186# VDD.t52 sg13_lv_pmos ad=0.36237p pd=2.605u as=79.8f ps=0.8u w=0.42u l=0.13u
X1210 VDD.t2233 sg13cmos5l_nor2_1_2.B sg13cmos5l_nor3_1_2.C VDD.t8 sg13_lv_pmos ad=0.3808p pd=2.92u as=0.2128p ps=1.5u w=1.12u l=0.13u
X1211 a_15754_18481# a_16197_18237# a_16137_18649# VDD.t231 sg13_lv_pmos ad=79.8f pd=0.8u as=63f ps=0.72u w=0.42u l=0.13u
X1212 a_15280_17750# a_15023_17869# a_15442_17946# VSS.t1453 sg13_lv_nmos ad=0.1428p pd=1.52u as=37.8f ps=0.6u w=0.42u l=0.13u
X1213 a_13690_16714# sg13cmos5l_o21ai_1_24.Y VDD.t1542 VDD.t310 sg13_lv_pmos ad=0.1428p pd=1.52u as=0.1523p ps=1.38u w=0.42u l=0.13u
X1214 a_20294_7362# a_21099_6935# a_20554_6892# VDD.t2 sg13_lv_pmos ad=0.1428p pd=1.52u as=79.8f ps=0.8u w=0.42u l=0.13u
X1215 a_5998_17775# a_6113_17774# VSS.t69 VSS.t1504 sg13_lv_nmos ad=0.1428p pd=1.52u as=0.1426p ps=1.16u w=0.42u l=0.5u
X1216 sg13cmos5l_nand4_1_8.B sg13cmos5l_nor4_1_1.D a_10530_14484# VDD.t19 sg13_lv_pmos ad=0.4368p pd=3.02u as=0.2128p ps=1.5u w=1.12u l=0.13u
X1217 VDD.t327 VSS.t1645 VDD.t326 VDD.t16 sg13_lv_pmos ad=0.34p pd=2.68u as=0 ps=0 w=1u l=1u
X1218 a_13148_4968# sg13cmos5l_o21ai_1_0.A2 sg13cmos5l_o21ai_1_0.Y VDD.t5 sg13_lv_pmos ad=0.2128p pd=1.5u as=0.2128p ps=1.5u w=1.12u l=0.15u
X1219 a_17804_4614# sg13cmos5l_buf_1_13.A VSS.t850 VSS.t2367 sg13_lv_nmos ad=0.187p pd=1.78u as=0.14875p ps=1.16u w=0.55u l=0.13u
X1220 a_6863_13333# a_6021_12983# a_5604_12976# VDD.t83 sg13_lv_pmos ad=0.2048p pd=1.63u as=0.34p ps=2.68u w=1u l=0.13u
X1221 sg13cmos5l_nand2_1_5.Y sg13cmos5l_and4_1_0.D a_12058_7678# VSS.t1016 sg13_lv_nmos ad=0.2516p pd=2.16u as=0.1406p ps=1.12u w=0.74u l=0.13u
X1222 VSS.t132 a_19035_16750# sg13cmos5l_inv_1_31.A VSS.t445 sg13_lv_nmos ad=0.1406p pd=1.12u as=0.1406p ps=1.12u w=0.74u l=0.13u
X1223 VDD.t1013 a_20494_15423# sg13cmos5l_dfrbpq_1_29.D VDD.t16 sg13_lv_pmos ad=0.2254p pd=1.53u as=0.4256p ps=3u w=1.12u l=0.13u
X1224 VDD.t814 sg13cmos5l_a21oi_1_27.A2 a_9557_11460# VDD.t0 sg13_lv_pmos ad=0.2128p pd=1.5u as=0.3808p ps=2.92u w=1.12u l=0.13u
X1225 VDD.t872 a_1294_19959# sg13cmos5l_buf_1_30.A VDD.t270 sg13_lv_pmos ad=0.2254p pd=1.53u as=0.4256p ps=3u w=1.12u l=0.13u
X1226 VDD.t531 VSS.t1754 VDD.t530 VDD.t83 sg13_lv_pmos ad=0.19p pd=1.38u as=0 ps=0 w=1u l=1u
X1227 VDD.t681 a_9716_15202# a_9674_15532# VDD.t16 sg13_lv_pmos ad=0.2618p pd=1.63u as=0.1176p ps=1.33u w=1.12u l=0.13u
X1228 sg13cmos5l_buf_1_15.A a_5416_9948# VSS.t1058 VSS.t1057 sg13_lv_nmos ad=0.2886p pd=2.26u as=0.14875p ps=1.16u w=0.74u l=0.13u
X1229 VSS.t253 a_20997_6935# a_21099_6935# VSS.t252 sg13_lv_nmos ad=4.7455p pd=30.71u as=0.2516p ps=2.16u w=0.74u l=0.13u
X1230 sg13cmos5l_buf_1_17.X a_1192_8436# VSS.t918 VSS.t88 sg13_lv_nmos ad=0.2886p pd=2.26u as=0.14875p ps=1.16u w=0.74u l=0.13u
X1231 a_17338_18984# sg13cmos5l_dlygate4sd3_1_82.A VSS.t357 VSS.t356 sg13_lv_nmos ad=0.1428p pd=1.52u as=79.8f ps=0.8u w=0.42u l=0.13u
X1232 VDD.t43 VSS.t1981 VDD.t42 VDD.t13 sg13_lv_pmos ad=0.19p pd=1.38u as=0 ps=0 w=1u l=1u
X1233 sg13cmos5l_dfrbpq_1_19.CLK a_7498_18226# VDD.t2037 VDD.t231 sg13_lv_pmos ad=0.2128p pd=1.5u as=0.2128p ps=1.5u w=1.12u l=0.13u
X1234 VSS.t72 sg13cmos5l_dfrbpq_1_28.RESET_B.t6 a_20388_14922# VSS.t871 sg13_lv_nmos ad=0.1626p pd=1.415u as=60.89999f ps=0.71u w=0.42u l=0.13u
X1235 VDD.t696 a_13210_12936# a_12929_13238# VDD.t83 sg13_lv_pmos ad=0.1523p pd=1.38u as=0.34p ps=2.68u w=1u l=0.5u
X1236 VDD.t1086 sg13cmos5l_nand3b_1_0.C sg13cmos5l_nand2_1_19.A VDD.t0 sg13_lv_pmos ad=0.2198p pd=1.53u as=0.2128p ps=1.5u w=1.12u l=0.13u
X1237 VDD.t548 VSS.t1962 VDD.t1460 VDD.t5 sg13_lv_pmos ad=0.34p pd=2.68u as=0 ps=0 w=1u l=1u
X1238 VSS.t380 a_12239_18335# a_12906_18556# VSS.t1153 sg13_lv_nmos ad=0.1406p pd=1.12u as=0.2516p ps=2.16u w=0.74u l=0.13u
X1239 a_19054_18447# a_19169_18448# VSS.t117 VSS.t411 sg13_lv_nmos ad=0.1428p pd=1.52u as=0.1426p ps=1.16u w=0.42u l=0.5u
X1240 VSS.t542 sg13cmos5l_dfrbpq_1_13.RESET_B a_5220_7674# VSS.t1200 sg13_lv_nmos ad=0.1626p pd=1.415u as=60.89999f ps=0.71u w=0.42u l=0.13u
X1241 VDD.t799 a_16078_19287# sg13cmos5l_dfrbpq_1_33.D VDD.t231 sg13_lv_pmos ad=0.2254p pd=1.53u as=0.4256p ps=3u w=1.12u l=0.13u
X1242 a_18098_16362# sg13cmos5l_nand4_1_5.D VSS.t134 VSS.t511 sg13_lv_nmos ad=0.1406p pd=1.12u as=0.2516p ps=2.16u w=0.74u l=0.13u
X1243 VDD.t182 VSS.t1792 VDD.t51 VDD.t0 sg13_lv_pmos ad=0.19p pd=1.38u as=0 ps=0 w=1u l=1u
X1244 VSS.t22 a_22096_4870# a_21745_4727# VSS.t42 sg13_lv_nmos ad=79.8f pd=0.8u as=0.1428p ps=1.52u w=0.42u l=0.13u
X1245 a_22426_18984# sg13cmos5l_dfrbpq_1_35.Q VDD.t1532 VDD.t231 sg13_lv_pmos ad=0.1428p pd=1.52u as=0.1523p ps=1.38u w=0.42u l=0.13u
X1246 a_6670_18447# a_6785_18448# VDD.t1758 VDD.t231 sg13_lv_pmos ad=0.34p pd=2.68u as=0.2254p ps=1.53u w=1u l=0.5u
X1247 sg13cmos5l_dlygate4sd3_1_76.A sg13cmos5l_a21oi_1_18.B1 a_18101_14020# VDD.t19 sg13_lv_pmos ad=0.3808p pd=2.92u as=0.2128p ps=1.5u w=1.12u l=0.13u
X1248 VSS.t153 sg13cmos5l_nand3b_1_0.C a_12758_11826# VSS.t657 sg13_lv_nmos ad=0.18575p pd=1.26u as=0.1406p ps=1.12u w=0.74u l=0.13u
X1249 a_4906_18988# a_5349_19031# a_5289_19067# VDD.t231 sg13_lv_pmos ad=79.8f pd=0.8u as=63f ps=0.72u w=0.42u l=0.13u
X1250 VSS.t373 sg13cmos5l_nand4_1_5.D a_16002_16754# VSS.t510 sg13_lv_nmos ad=0.2516p pd=2.16u as=0.1406p ps=1.12u w=0.74u l=0.13u
X1251 VDD.t738 sg13cmos5l_mux2_1_0.A1 a_8411_12252# VDD.t83 sg13_lv_pmos ad=0.253p pd=1.53u as=0.2856p ps=2.36u w=0.84u l=0.13u
X1252 a_19342_10215# a_19457_10214# VDD.t1964 VDD.t52 sg13_lv_pmos ad=0.34p pd=2.68u as=0.2254p ps=1.53u w=1u l=0.5u
X1253 VDD.t13 VSS.t2072 VDD.t13 VDD.t13 sg13_lv_pmos ad=0.34p pd=2.68u as=0 ps=0 w=1u l=1u
X1254 a_7238_19458# a_8043_19031# a_7498_18988# VDD.t231 sg13_lv_pmos ad=0.1428p pd=1.52u as=79.8f ps=0.8u w=0.42u l=0.13u
X1255 a_17296_18478# sg13cmos5l_buf_1_45.X.t8 VDD.t231 VDD.t231 sg13_lv_pmos ad=79.8f pd=0.8u as=1.4953p ps=9.545u w=0.42u l=0.13u
X1256 a_3415_16710# a_3975_16964# a_3886_17061# VDD.t310 sg13_lv_pmos ad=0.2048p pd=1.63u as=93.45f ps=0.865u w=0.42u l=0.13u
X1257 a_15607_9150# a_16167_9404# a_16078_9501# VDD.t52 sg13_lv_pmos ad=0.2048p pd=1.63u as=93.45f ps=0.865u w=0.42u l=0.13u
X1258 VDD.t885 sg13cmos5l_nand4_1_7.B sg13cmos5l_nand4_1_12.Y VDD.t310 sg13_lv_pmos ad=0.2128p pd=1.5u as=0.2128p ps=1.5u w=1.12u l=0.13u
X1259 VDD.t490 VSS.t1721 VDD.t489 VDD.t83 sg13_lv_pmos ad=0.34p pd=2.68u as=0 ps=0 w=1u l=1u
X1260 a_12940_10996# sg13cmos5l_inv_1_18.A sg13cmos5l_nand2_1_0.B VDD.t0 sg13_lv_pmos ad=0.1176p pd=1.33u as=0.3808p ps=2.92u w=1.12u l=0.13u
X1261 VSS.t2093 VDD.t2397 VSS.t2092 VSS.t2091 sg13_lv_nmos ad=0.1428p pd=1.52u as=0 ps=0 w=0.42u l=1u
X1262 VSS.t132 sg13cmos5l_buf_8_2.A.t5 a_19035_16750# VSS.t1382 sg13_lv_nmos ad=0.1406p pd=1.12u as=0.1406p ps=1.12u w=0.74u l=0.13u
X1263 VSS.t284 sg13cmos5l_a21oi_1_9.A1 a_13434_6887# VSS.t690 sg13_lv_nmos ad=0.374p pd=2.46u as=0.17462p ps=1.185u w=0.55u l=0.13u
X1264 VDD.t1207 a_12814_19959# sg13cmos5l_o21ai_1_17.B1 VDD.t270 sg13_lv_pmos ad=0.2254p pd=1.53u as=0.4256p ps=3u w=1.12u l=0.13u
X1265 a_4821_16043# a_3879_16083# a_4727_16043# VDD.t16 sg13_lv_pmos ad=79.8f pd=0.8u as=0.1428p ps=1.52u w=0.42u l=0.13u
X1266 a_20121_11013# a_19179_10820# a_19919_10775# VDD.t0 sg13_lv_pmos ad=93.45f pd=0.865u as=0.2048p ps=1.63u w=0.42u l=0.13u
X1267 sg13cmos5l_buf_1_15.A.t0 a_5416_9948# VDD.t1437 VDD.t52 sg13_lv_pmos ad=0.42p pd=2.99u as=0.2114p ps=1.54u w=1.12u l=0.13u
X1268 VDD.t1566 a_7068_6126# a_8091_6553# VDD.t2 sg13_lv_pmos ad=0.1563p pd=1.22u as=63f ps=0.72u w=0.42u l=0.13u
X1269 VDD.t458 VSS.t291 VDD.t72 VDD.t13 sg13_lv_pmos ad=0.19p pd=1.38u as=0 ps=0 w=1u l=1u
X1270 VDD.t650 sg13cmos5l_o21ai_1_28.A1 a_11884_15996# VDD.t16 sg13_lv_pmos ad=0.4032p pd=2.96u as=0.1176p ps=1.33u w=1.12u l=0.13u
X1271 VDD.t83 a_7120_13214# a_7065_13095# VDD.t83 sg13_lv_pmos ad=2.51485p pd=16.46u as=93.45f ps=0.865u w=0.42u l=0.13u
X1272 VDD.t1348 sg13cmos5l_buf_1_24.A a_11656_15272# VDD.t16 sg13_lv_pmos ad=0.2114p pd=1.54u as=0.2856p ps=2.36u w=0.84u l=0.13u
X1273 VDD.t516 VSS.t1935 VDD.t840 VDD.t5 sg13_lv_pmos ad=0.34p pd=2.68u as=0 ps=0 w=1u l=1u
X1274 sg13cmos5l_dlygate4sd3_1_54.A a_11274_20068# VDD.t2176 VDD.t270 sg13_lv_pmos ad=0.3808p pd=2.92u as=0.2128p ps=1.5u w=1.12u l=0.13u
X1275 a_16942_19287# a_17057_19286# VSS.t422 VSS.t356 sg13_lv_nmos ad=0.1428p pd=1.52u as=0.1426p ps=1.16u w=0.42u l=0.5u
X1276 a_14926_16935# a_15041_16936# VDD.t902 VDD.t310 sg13_lv_pmos ad=0.34p pd=2.68u as=0.2254p ps=1.53u w=1u l=0.5u
X1277 VDD.t293 VSS.t1702 VDD.t292 VDD.t19 sg13_lv_pmos ad=0.34p pd=2.68u as=0 ps=0 w=1u l=1u
X1278 a_22126_7863# a_22241_7864# VDD.t1094 VDD.t8 sg13_lv_pmos ad=0.34p pd=2.68u as=0.2254p ps=1.53u w=1u l=0.5u
X1279 VDD.t1052 a_8411_12252# a_8911_12508# VDD.t83 sg13_lv_pmos ad=0.2198p pd=1.52u as=0.2975p ps=1.595u w=1u l=0.13u
X1280 VSS.t242 a_11397_18237# a_11499_18380# VSS.t1258 sg13_lv_nmos ad=4.1963p pd=27.415u as=0.2516p ps=2.16u w=0.74u l=0.13u
X1281 a_18286_16935# a_18401_16936# VSS.t134 VSS.t1457 sg13_lv_nmos ad=0.1428p pd=1.52u as=0.1426p ps=1.16u w=0.42u l=0.5u
X1282 VDD.t88 VSS.t2010 VDD.t90 VDD.t5 sg13_lv_pmos ad=0.19p pd=1.38u as=0 ps=0 w=1u l=1u
X1283 a_6368_6337# a_6487_6126# VDD.t763 VDD.t2 sg13_lv_pmos ad=0.3864p pd=2.93u as=0.2128p ps=1.5u w=1.12u l=0.13u
X1284 a_16078_19287# a_16193_19286# VDD.t799 VDD.t231 sg13_lv_pmos ad=0.34p pd=2.68u as=0.2254p ps=1.53u w=1u l=0.5u
X1285 VSS.t232 sg13cmos5l_buf_1_13.X a_17412_11898# VSS.t598 sg13_lv_nmos ad=0.1626p pd=1.415u as=60.89999f ps=0.71u w=0.42u l=0.13u
X1286 VSS.t279 a_10864_5654# a_10513_5773# VSS.t818 sg13_lv_nmos ad=79.8f pd=0.8u as=0.1428p ps=1.52u w=0.42u l=0.13u
X1287 VDD.t1721 sg13cmos5l_nand4_1_1.C sg13cmos5l_a21oi_1_23.A2 VDD.t19 sg13_lv_pmos ad=0.2128p pd=1.5u as=0.2128p ps=1.5u w=1.12u l=0.13u
X1288 a_20434_17946# sg13cmos5l_dfrbpq_1_28.RESET_B.t9 VSS.t117 VSS.t225 sg13_lv_nmos ad=37.8f pd=0.6u as=79.8f ps=0.8u w=0.42u l=0.13u
X1289 sg13cmos5l_nor3_1_7.Y sg13cmos5l_buf_1_14.A VSS.t222 VSS.t221 sg13_lv_nmos ad=0.1694p pd=1.21u as=0.2618p ps=2.22u w=0.77u l=0.13u
X1290 VSS.t441 sg13cmos5l_a22oi_1_0.B2 sg13cmos5l_a22oi_1_0.A2 VSS.t763 sg13_lv_nmos ad=0.2516p pd=2.16u as=0.1406p ps=1.12u w=0.74u l=0.13u
X1291 VSS.t11 a_20294_6166# a_20406_6230# VSS.t258 sg13_lv_nmos ad=0.1426p pd=1.16u as=0.1428p ps=1.52u w=0.42u l=0.5u
X1292 VSS.t159 a_11674_12936# a_11393_13238# VSS.t149 sg13_lv_nmos ad=79.8f pd=0.8u as=0.1428p ps=1.52u w=0.42u l=0.5u
X1293 a_11490_14020# sg13cmos5l_mux2_1_1.A1 a_11388_14020# VDD.t19 sg13_lv_pmos ad=0.2128p pd=1.5u as=0.2128p ps=1.5u w=1.12u l=0.13u
X1294 bp2 a_21256_3900# VDD.t789 VDD.t13 sg13_lv_pmos ad=0.42p pd=2.99u as=0.2114p ps=1.54u w=1.12u l=0.13u
X1295 VDD.t606 VSS.t1973 VDD.t604 VDD.t5 sg13_lv_pmos ad=0.19p pd=1.38u as=0 ps=0 w=1u l=1u
X1296 a_8602_9154# sg13cmos5l_o21ai_1_6.Y VSS.t190 VSS.t1589 sg13_lv_nmos ad=0.1428p pd=1.52u as=79.8f ps=0.8u w=0.42u l=0.13u
X1297 VDD.t109 VSS.t2002 VDD.t107 VDD.t13 sg13_lv_pmos ad=0.19p pd=1.38u as=0 ps=0 w=1u l=1u
X1298 VSS.t2078 VDD.t13 VSS.t2077 VSS.t2076 sg13_lv_nmos ad=0.1428p pd=1.52u as=0 ps=0 w=0.42u l=1u
X1299 VSS.t74 a_8272_11702# a_7921_11821# VSS.t73 sg13_lv_nmos ad=79.8f pd=0.8u as=0.1428p ps=1.52u w=0.42u l=0.13u
X1300 VDD.t52 sg13cmos5l_inv_1_5.A a_16319_9456# VDD.t52 sg13_lv_pmos ad=1.8716p pd=12.115u as=0.4088p ps=2.97u w=1.12u l=0.13u
X1301 a_11206_18271# sg13cmos5l_dfrbpq_1_24.RESET_B VSS.t1138 VSS.t1137 sg13_lv_nmos ad=37.8f pd=0.6u as=0.1701p ps=1.65u w=0.42u l=0.13u
X1302 VDD.t346 VSS.t1658 VDD.t911 VDD.t19 sg13_lv_pmos ad=0.34p pd=2.68u as=0 ps=0 w=1u l=1u
X1303 VDD.t1271 a_12614_6166# a_12726_6230# VDD.t2 sg13_lv_pmos ad=0.2254p pd=1.53u as=0.34p ps=2.68u w=1u l=0.5u
X1304 VDD.t1174 sg13cmos5l_buf_1_0.A a_21256_3176# VDD.t13 sg13_lv_pmos ad=0.2114p pd=1.54u as=0.2856p ps=2.36u w=0.84u l=0.13u
X1305 a_19044_17933# a_18756_17512# a_18982_17933# VSS.t1335 sg13_lv_nmos ad=0.1428p pd=1.52u as=37.8f ps=0.6u w=0.42u l=0.13u
X1306 sg13cmos5l_a21oi_1_16.A2 sg13cmos5l_nand4_1_18.D VDD.t975 VDD.t19 sg13_lv_pmos ad=0.2128p pd=1.5u as=0.3808p ps=2.92u w=1.12u l=0.13u
X1307 a_11759_10309# a_10917_9959# a_10500_9952# VDD.t52 sg13_lv_pmos ad=0.2048p pd=1.63u as=0.34p ps=2.68u w=1u l=0.13u
X1308 a_18374_7674# a_19179_7796# a_18634_7897# VDD.t8 sg13_lv_pmos ad=0.1428p pd=1.52u as=79.8f ps=0.8u w=0.42u l=0.13u
X1309 a_16197_18237# sg13cmos5l_inv_1_31.A VSS.t242 VSS.t2300 sg13_lv_nmos ad=0.2516p pd=2.16u as=3.77667p ps=24.67u w=0.74u l=0.13u
X1310 a_7954_17886# sg13cmos5l_o21ai_1_19.B1 sg13cmos5l_o21ai_1_19.Y VSS.t63 sg13_lv_nmos ad=0.1406p pd=1.12u as=0.2516p ps=2.16u w=0.74u l=0.15u
X1311 a_9924_12223# a_9636_12528# a_9862_12223# VSS.t1485 sg13_lv_nmos ad=0.1428p pd=1.52u as=37.8f ps=0.6u w=0.42u l=0.13u
X1312 a_8272_11702# a_8015_11821# a_8434_11898# VSS.t801 sg13_lv_nmos ad=0.1428p pd=1.52u as=37.8f ps=0.6u w=0.42u l=0.13u
X1313 VSS.t291 VDD.t2427 VSS.t291 VSS.t1994 sg13_lv_nmos ad=79.8f pd=0.8u as=0 ps=0 w=0.42u l=1u
X1314 a_13294_16935# a_13409_16936# VDD.t1577 VDD.t310 sg13_lv_pmos ad=0.34p pd=2.68u as=0.2254p ps=1.53u w=1u l=0.5u
X1315 VDD.t845 sg13cmos5l_buf_1_53.A a_13768_14484# VDD.t19 sg13_lv_pmos ad=0.2114p pd=1.54u as=0.2856p ps=2.36u w=0.84u l=0.13u
X1316 VSS.t159 sg13cmos5l_nand2_1_15.B a_12463_13726# VSS.t66 sg13_lv_nmos ad=0.14505p pd=1.15u as=0.1406p ps=1.12u w=0.74u l=0.13u
X1317 VDD.t1255 a_21084_18222# a_22107_18649# VDD.t231 sg13_lv_pmos ad=0.1563p pd=1.22u as=63f ps=0.72u w=0.42u l=0.13u
X1318 a_8713_10744# sg13cmos5l_dlygate4sd3_1_38.X VSS.t538 VSS.t2563 sg13_lv_nmos ad=0.1216p pd=1.02u as=0.1331p ps=1.12u w=0.64u l=0.13u
X1319 VSS.t1785 VDD.t2493 VSS.t1784 VSS.t1783 sg13_lv_nmos ad=0.1428p pd=1.52u as=0 ps=0 w=0.42u l=1u
X1320 a_19829_3900# sg13cmos5l_inv_1_7.Y VDD.t1103 VDD.t13 sg13_lv_pmos ad=0.2128p pd=1.5u as=0.2128p ps=1.5u w=1.12u l=0.13u
X1321 a_11674_6130# sg13cmos5l_dfrbpq_1_13.Q VSS.t279 VSS.t2568 sg13_lv_nmos ad=0.1428p pd=1.52u as=79.8f ps=0.8u w=0.42u l=0.13u
X1322 a_18489_15549# a_17547_15356# a_18287_15311# VDD.t16 sg13_lv_pmos ad=93.45f pd=0.865u as=0.2048p ps=1.63u w=0.42u l=0.13u
X1323 VDD.t1905 sg13cmos5l_buf_1_63.A a_12232_14484# VDD.t19 sg13_lv_pmos ad=0.2114p pd=1.54u as=0.2856p ps=2.36u w=0.84u l=0.13u
X1324 VDD.t1944 a_1294_9375# sg13cmos5l_buf_1_17.A VDD.t52 sg13_lv_pmos ad=0.2254p pd=1.53u as=0.4256p ps=3u w=1.12u l=0.13u
X1325 VDD.t468 VSS.t291 VDD.t467 VDD.t13 sg13_lv_pmos ad=0.34p pd=2.68u as=0 ps=0 w=1u l=1u
X1326 VSS.t107 a_13210_19738# a_12929_19960# VSS.t804 sg13_lv_nmos ad=79.8f pd=0.8u as=0.1428p ps=1.52u w=0.42u l=0.5u
X1327 VSS.t237 a_22522_6130# a_22241_6352# VSS.t258 sg13_lv_nmos ad=79.8f pd=0.8u as=0.1428p ps=1.52u w=0.42u l=0.5u
X1328 a_19534_16263# a_19649_16262# VDD.t715 VDD.t16 sg13_lv_pmos ad=0.34p pd=2.68u as=0.2254p ps=1.53u w=1u l=0.5u
X1329 VDD.t1389 sg13cmos5l_nand2_1_0.B a_14264_10702# VDD.t0 sg13_lv_pmos ad=0.1523p pd=1.38u as=0.1428p ps=1.52u w=0.42u l=0.13u
X1330 a_22041_7047# a_21099_6935# a_21839_7285# VDD.t2 sg13_lv_pmos ad=93.45f pd=0.865u as=0.2048p ps=1.63u w=0.42u l=0.13u
X1331 VDD.t1115 sg13cmos5l_a21oi_1_9.A1 a_13886_6924# VDD.t2 sg13_lv_pmos ad=0.36p pd=2.72u as=0.1225p ps=1.245u w=1u l=0.13u
X1332 a_14098_19458# sg13cmos5l_buf_1_45.X.t10 VSS.t105 VSS.t426 sg13_lv_nmos ad=37.8f pd=0.6u as=79.8f ps=0.8u w=0.42u l=0.13u
X1333 VSS.t927 a_15760_19990# a_15409_19847# VSS.t166 sg13_lv_nmos ad=79.8f pd=0.8u as=0.1428p ps=1.52u w=0.42u l=0.13u
X1334 sg13cmos5l_a21oi_1_5.A2 sg13cmos5l_nand4_1_18.D VDD.t972 VDD.t83 sg13_lv_pmos ad=0.2128p pd=1.5u as=0.3808p ps=2.92u w=1.12u l=0.13u
X1335 VSS.t260 a_6286_8703# sg13cmos5l_dlygate4sd3_1_42.X VSS.t259 sg13_lv_nmos ad=0.1426p pd=1.16u as=0.2516p ps=2.16u w=0.74u l=0.13u
X1336 VDD.t83 a_20997_12189# a_21099_12332# VDD.t83 sg13_lv_pmos ad=2.51485p pd=16.46u as=0.3864p ps=2.93u w=1.12u l=0.13u
X1337 VSS.t342 a_21839_8797# a_22506_8436# VSS.t14 sg13_lv_nmos ad=0.1406p pd=1.12u as=0.2516p ps=2.16u w=0.74u l=0.13u
X1338 VDD.t242 VSS.t1839 VDD.t241 VDD.t8 sg13_lv_pmos ad=0.34p pd=2.68u as=0 ps=0 w=1u l=1u
X1339 VDD.t334 VSS.t1648 VDD.t333 VDD.t310 sg13_lv_pmos ad=0.34p pd=2.68u as=0 ps=0 w=1u l=1u
X1340 a_18689_4676# sg13cmos5l_inv_1_0.Y sg13cmos5l_a21oi_1_0.Y VSS.t2616 sg13_lv_nmos ad=0.1406p pd=1.12u as=0.1406p ps=1.12u w=0.74u l=0.13u
X1341 a_9322_19993# a_9765_19749# a_9062_19770# VSS.t2276 sg13_lv_nmos ad=79.8f pd=0.8u as=0.1296p ps=1.52u w=0.42u l=0.13u
X1342 VDD.t500 VSS.t1632 VDD.t499 VDD.t310 sg13_lv_pmos ad=0.34p pd=2.68u as=0 ps=0 w=1u l=1u
X1343 VSS.t380 a_12902_17508# a_13014_17532# VSS.t659 sg13_lv_nmos ad=0.1426p pd=1.16u as=0.1428p ps=1.52u w=0.42u l=0.5u
X1344 VDD.t727 sg13cmos5l_buf_1_59.A a_15400_15272# VDD.t16 sg13_lv_pmos ad=0.2114p pd=1.54u as=0.2856p ps=2.36u w=0.84u l=0.13u
X1345 VSS.t825 sg13cmos5l_a21oi_1_11.Y a_13592_6166# VSS.t1387 sg13_lv_nmos ad=79.8f pd=0.8u as=0.1428p ps=1.52u w=0.42u l=0.13u
X1346 VDD.t47 VSS.t1981 VDD.t45 VDD.t13 sg13_lv_pmos ad=0.19p pd=1.38u as=0 ps=0 w=1u l=1u
X1347 VDD.t37 VSS.t1981 VDD.t36 VDD.t5 sg13_lv_pmos ad=0.34p pd=2.68u as=0 ps=0 w=1u l=1u
X1348 VDD.t295 VSS.t1702 VDD.t294 VDD.t83 sg13_lv_pmos ad=0.34p pd=2.68u as=0 ps=0 w=1u l=1u
X1349 VDD.t360 sg13cmos5l_buf_1_7.X a_17386_6892# VDD.t2 sg13_lv_pmos ad=0.1563p pd=1.22u as=0.147p ps=1.54u w=0.42u l=0.13u
X1350 VSS.t759 sg13cmos5l_nand2b_1_3.B a_10447_7294# VSS.t860 sg13_lv_nmos ad=0.14505p pd=1.15u as=0.1406p ps=1.12u w=0.74u l=0.13u
X1351 sg13cmos5l_dlygate4sd3_1_22.A sg13cmos5l_inv_1_4.Y a_21363_9212# VSS.t339 sg13_lv_nmos ad=0.1406p pd=1.12u as=0.1406p ps=1.12u w=0.74u l=0.13u
X1352 a_18095_19847# a_17253_19749# a_16836_20088# VDD.t270 sg13_lv_pmos ad=0.2048p pd=1.63u as=0.34p ps=2.68u w=1u l=0.13u
X1353 sg13cmos5l_nand2_1_11.B a_8844_15424# VDD.t808 VDD.t16 sg13_lv_pmos ad=0.2408p pd=1.55u as=0.3808p ps=2.92u w=1.12u l=0.13u
X1354 sg13cmos5l_nand4_1_1.C a_15496_13760# VSS.t576 VSS.t128 sg13_lv_nmos ad=0.2886p pd=2.26u as=0.14875p ps=1.16u w=0.74u l=0.13u
X1355 sg13cmos5l_a21oi_1_6.A2 sg13cmos5l_nand4_1_1.A a_16190_13730# VSS.t128 sg13_lv_nmos ad=0.2516p pd=2.16u as=0.1406p ps=1.12u w=0.74u l=0.13u
X1356 VDD.t2 a_15983_6239# a_16240_6382# VDD.t2 sg13_lv_pmos ad=2.1916p pd=14.26u as=79.8f ps=0.8u w=0.42u l=0.13u
X1357 VDD.t672 a_20384_18433# sg13cmos5l_dlygate4sd3_1_72.A VDD.t231 sg13_lv_pmos ad=0.2128p pd=1.5u as=0.3808p ps=2.92u w=1.12u l=0.13u
X1358 VSS.t31 sg13cmos5l_nand3_1_0.C a_16770_7290# VSS.t993 sg13_lv_nmos ad=0.2886p pd=2.26u as=0.1406p ps=1.12u w=0.74u l=0.13u
X1359 sg13cmos5l_dfrbpq_1_5.CLK a_21531_13342# VSS.t163 VSS.t1242 sg13_lv_nmos ad=0.1406p pd=1.12u as=0.1406p ps=1.12u w=0.74u l=0.13u
X1360 VDD.t100 VSS.t2002 VDD.t101 VDD.t5 sg13_lv_pmos ad=0.19p pd=1.38u as=0 ps=0 w=1u l=1u
X1361 sg13cmos5l_a21oi_1_15.Y sg13cmos5l_inv_1_20.Y a_17043_12236# VSS.t1512 sg13_lv_nmos ad=0.1406p pd=1.12u as=0.1406p ps=1.12u w=0.74u l=0.13u
X1362 VDD.t1350 a_11674_12936# a_11393_13238# VDD.t83 sg13_lv_pmos ad=0.1523p pd=1.38u as=0.34p ps=2.68u w=1u l=0.5u
X1363 VSS.t2138 VDD.t2388 VSS.t2137 VSS.t2136 sg13_lv_nmos ad=0.1428p pd=1.52u as=0 ps=0 w=0.42u l=1u
X1364 VDD.t5 a_19365_5423# a_19467_5423# VDD.t5 sg13_lv_pmos ad=1.96072p pd=12.69u as=0.3864p ps=2.93u w=1.12u l=0.13u
X1365 VDD.t231 a_11397_18237# a_11499_18380# VDD.t231 sg13_lv_pmos ad=1.54512p pd=9.865u as=0.3864p ps=2.93u w=1.12u l=0.13u
X1366 VDD.t1112 sg13cmos5l_nand2b_1_1.A_N a_10709_6460# VDD.t2 sg13_lv_pmos ad=0.2128p pd=1.5u as=0.3808p ps=2.92u w=1.12u l=0.13u
X1367 a_6256_14726# sg13cmos5l_dfrbpq_1_24.RESET_B VDD.t19 VDD.t19 sg13_lv_pmos ad=79.8f pd=0.8u as=2.1916p ps=14.26u w=0.42u l=0.13u
X1368 VSS.t344 sg13cmos5l_nor2_1_3.Y a_12139_11808# VSS.t496 sg13_lv_nmos ad=0.1331p pd=1.12u as=0.1216p ps=1.02u w=0.64u l=0.13u
X1369 a_10803_6188# sg13cmos5l_nand2b_1_1.A_N VSS.t279 VSS.t2226 sg13_lv_nmos ad=0.1406p pd=1.12u as=0.2516p ps=2.16u w=0.74u l=0.13u
X1370 a_3879_16083# a_4031_15967# VDD.t16 VDD.t16 sg13_lv_pmos ad=0.3864p pd=2.93u as=2.07625p ps=13.51u w=1.12u l=0.13u
X1371 sg13cmos5l_nand4_1_1.B sg13cmos5l_a21oi_1_27.A1 VSS.t196 VSS.t66 sg13_lv_nmos ad=0.2618p pd=2.22u as=0.1463p ps=1.15u w=0.77u l=0.13u
X1372 VDD.t557 VSS.t1966 VDD.t555 VDD.t5 sg13_lv_pmos ad=0.19p pd=1.38u as=0 ps=0 w=1u l=1u
X1373 VDD.t1708 sg13cmos5l_nand4_1_6.B sg13cmos5l_a21oi_1_26.A2 VDD.t310 sg13_lv_pmos ad=0.2128p pd=1.5u as=0.2128p ps=1.5u w=1.12u l=0.13u
X1374 VDD.t1705 a_6863_13333# a_7530_12972# VDD.t83 sg13_lv_pmos ad=0.2128p pd=1.5u as=0.3864p ps=2.93u w=1.12u l=0.13u
X1375 sg13cmos5l_o21ai_1_3.Y sg13cmos5l_o21ai_1_3.A2 a_15000_8416# VDD.t8 sg13_lv_pmos ad=0.2128p pd=1.5u as=0.2128p ps=1.5u w=1.12u l=0.15u
X1376 a_18002_12218# sg13cmos5l_nand4_1_18.D VSS.t232 VSS.t517 sg13_lv_nmos ad=0.1406p pd=1.12u as=0.2516p ps=2.16u w=0.74u l=0.13u
X1377 a_20580_14488# a_20554_14452# VDD.t1066 VDD.t19 sg13_lv_pmos ad=0.34p pd=2.68u as=0.36237p ps=2.605u w=1u l=0.13u
X1378 VSS.t1703 VDD.t2531 VSS.t1702 VSS.t1701 sg13_lv_nmos ad=0.1428p pd=1.52u as=0 ps=0 w=0.42u l=1u
X1379 a_22096_10190# a_21839_10309# a_22258_10386# VSS.t546 sg13_lv_nmos ad=0.1428p pd=1.52u as=37.8f ps=0.6u w=0.42u l=0.13u
X1380 VSS.t101 sg13cmos5l_dfrbpq_1_13.Q sg13cmos5l_nor4_1_0.Y VSS.t2567 sg13_lv_nmos ad=0.2516p pd=2.16u as=0.1406p ps=1.12u w=0.74u l=0.13u
X1381 a_10448_16362# a_10389_16258# sg13cmos5l_nand3b_1_1.Y VSS.t1411 sg13_lv_nmos ad=0.1406p pd=1.12u as=0.3404p ps=2.4u w=0.74u l=0.13u
X1382 VDD.t52 a_20997_9959# a_21099_9959# VDD.t52 sg13_lv_pmos ad=1.8716p pd=12.115u as=0.3864p ps=2.93u w=1.12u l=0.13u
X1383 VSS.t199 sg13cmos5l_buf_1_65.A sg13cmos5l_nand4_1_8.B VSS.t1552 sg13_lv_nmos ad=0.1406p pd=1.12u as=0.1406p ps=1.12u w=0.74u l=0.13u
X1384 a_20997_13701# sg13cmos5l_dfrbpq_1_5.CLK VSS.t1365 VSS.t1563 sg13_lv_nmos ad=0.2516p pd=2.16u as=6.29922p ps=42.355u w=0.74u l=0.13u
X1385 VDD.t2263 a_15014_19020# a_15126_19044# VDD.t231 sg13_lv_pmos ad=0.2254p pd=1.53u as=0.34p ps=2.68u w=1u l=0.5u
X1386 a_19442_14850# sg13cmos5l_nand4_1_5.D VSS.t512 VSS.t432 sg13_lv_nmos ad=0.1406p pd=1.12u as=0.2516p ps=2.16u w=0.74u l=0.13u
X1387 VDD.t1992 sg13cmos5l_buf_1_13.A a_14698_6385# VDD.t2 sg13_lv_pmos ad=0.1563p pd=1.22u as=0.147p ps=1.54u w=0.42u l=0.13u
X1388 a_14181_16007# sg13cmos5l_dfrbpq_1_41.CLK VSS.t674 VSS.t673 sg13_lv_nmos ad=0.2516p pd=2.16u as=4.4216p ps=27.885u w=0.74u l=0.13u
X1389 a_10788_10373# a_10500_9952# a_10726_10373# VSS.t2312 sg13_lv_nmos ad=0.1428p pd=1.52u as=37.8f ps=0.6u w=0.42u l=0.13u
X1390 VDD.t91 VSS.t2014 VDD.t170 VDD.t5 sg13_lv_pmos ad=0.19p pd=1.38u as=0 ps=0 w=1u l=1u
X1391 VSS.t1605 VDD.t2564 VSS.t1605 VSS.t1606 sg13_lv_nmos ad=79.8f pd=0.8u as=0 ps=0 w=0.42u l=1u
X1392 a_20015_19381# a_19173_19031# a_18756_19024# VDD.t231 sg13_lv_pmos ad=0.2048p pd=1.63u as=0.34p ps=2.68u w=1u l=0.13u
X1393 VSS.t239 sg13cmos5l_buf_1_53.A a_13768_14484# VSS.t360 sg13_lv_nmos ad=0.14875p pd=1.16u as=0.187p ps=1.78u w=0.55u l=0.13u
X1394 a_16197_18237# sg13cmos5l_inv_1_31.A VDD.t231 VDD.t231 sg13_lv_pmos ad=0.4088p pd=2.97u as=1.4953p ps=9.545u w=1.12u l=0.13u
X1395 VDD.t72 VSS.t1987 VDD.t71 VDD.t13 sg13_lv_pmos ad=0.34p pd=2.68u as=0 ps=0 w=1u l=1u
X1396 VSS.t132 a_20384_16283# sg13cmos5l_dfrbpq_1_30.Q VSS.t1333 sg13_lv_nmos ad=0.1406p pd=1.12u as=0.2516p ps=2.16u w=0.74u l=0.13u
X1397 a_17445_15213# sg13cmos5l_dfrbpq_1_41.CLK VSS.t493 VSS.t675 sg13_lv_nmos ad=0.2516p pd=2.16u as=6.40482p ps=41.475u w=0.74u l=0.13u
X1398 VDD.t1764 a_6394_13690# a_6113_13912# VDD.t19 sg13_lv_pmos ad=0.1523p pd=1.38u as=0.34p ps=2.68u w=1u l=0.5u
X1399 a_3776_18433# a_3895_18222# VDD.t1484 VDD.t231 sg13_lv_pmos ad=0.3864p pd=2.93u as=0.2128p ps=1.5u w=1.12u l=0.13u
X1400 a_7334_14484# a_7064_14525# VSS.t124 VSS.t188 sg13_lv_nmos ad=0.1428p pd=1.52u as=79.8f ps=0.8u w=0.42u l=0.5u
X1401 VSS.t199 sg13cmos5l_buf_1_63.A a_12232_14484# VSS.t2307 sg13_lv_nmos ad=0.14875p pd=1.16u as=0.187p ps=1.78u w=0.55u l=0.13u
X1402 VDD.t52 a_9136_10190# a_9081_10071# VDD.t52 sg13_lv_pmos ad=1.8716p pd=12.115u as=93.45f ps=0.865u w=0.42u l=0.13u
X1403 VSS.t997 a_2156_19734# code9 VSS.t1062 sg13_lv_nmos ad=0.14875p pd=1.16u as=0.2886p ps=2.26u w=0.74u l=0.13u
X1404 VSS.t2005 VDD.t2422 VSS.t2005 VSS.t2006 sg13_lv_nmos ad=79.8f pd=0.8u as=0 ps=0 w=0.42u l=1u
X1405 a_14542_7191# a_14657_7190# VDD.t1176 VDD.t2 sg13_lv_pmos ad=0.34p pd=2.68u as=0.2254p ps=1.53u w=1u l=0.5u
X1406 sg13cmos5l_nor4_1_0.Y sg13cmos5l_nand2b_1_3.Y VSS.t759 VSS.t758 sg13_lv_nmos ad=0.1406p pd=1.12u as=0.23757p ps=2.16u w=0.74u l=0.13u
X1407 a_16550_19770# a_17355_19892# a_16810_19993# VDD.t270 sg13_lv_pmos ad=0.1428p pd=1.52u as=79.8f ps=0.8u w=0.42u l=0.13u
X1408 VSS.t740 a_10508_10662# sg13cmos5l_o21ai_1_5.A1 VSS.t1593 sg13_lv_nmos ad=0.14875p pd=1.16u as=0.2886p ps=2.26u w=0.74u l=0.13u
X1409 VSS.t2083 VDD.t269 VSS.t2082 VSS.t2081 sg13_lv_nmos ad=0.1428p pd=1.52u as=0 ps=0 w=0.42u l=1u
X1410 VSS.t99 sg13cmos5l_nand2b_1_0.B a_14230_7670# VSS.t975 sg13_lv_nmos ad=0.1406p pd=1.12u as=0.2516p ps=2.16u w=0.74u l=0.15u
X1411 a_18544_15454# a_18287_15311# a_18706_15234# VSS.t392 sg13_lv_nmos ad=0.1428p pd=1.52u as=37.8f ps=0.6u w=0.42u l=0.13u
X1412 a_5412_13410# sg13cmos5l_dfrbpq_1_24.D a_5318_13410# VSS.t1230 sg13_lv_nmos ad=60.89999f pd=0.71u as=0.1428p ps=1.52u w=0.42u l=0.13u
X1413 a_22126_17775# a_22241_17774# VSS.t587 VSS.t225 sg13_lv_nmos ad=0.1428p pd=1.52u as=0.1426p ps=1.16u w=0.42u l=0.5u
X1414 VDD.t887 sg13cmos5l_buf_1_45.X.t5 a_13478_16434# VDD.t16 sg13_lv_pmos ad=0.36237p pd=2.605u as=79.8f ps=0.8u w=0.42u l=0.13u
X1415 a_10685_12972# sg13cmos5l_a21oi_1_27.A1 sg13cmos5l_buf_1_20.A VDD.t83 sg13_lv_pmos ad=0.2128p pd=1.5u as=0.3808p ps=2.92u w=1.12u l=0.13u
X1416 sg13cmos5l_a21oi_1_9.A1 a_12726_6230# VSS.t825 VSS.t884 sg13_lv_nmos ad=0.2516p pd=2.16u as=0.1426p ps=1.16u w=0.74u l=0.13u
X1417 VDD.t270 a_18352_19990# a_18297_20085# VDD.t270 sg13_lv_pmos ad=2.69447p pd=17.64u as=93.45f ps=0.865u w=0.42u l=0.13u
X1418 VDD.t1094 a_22126_7863# sg13cmos5l_buf_1_0.A VDD.t8 sg13_lv_pmos ad=0.2254p pd=1.53u as=0.4256p ps=3u w=1.12u l=0.13u
X1419 a_19430_9190# a_19160_9190# VSS.t83 VSS.t910 sg13_lv_nmos ad=0.1428p pd=1.52u as=79.8f ps=0.8u w=0.42u l=0.5u
X1420 a_21063_16083# a_21215_15967# VSS.t674 VSS.t705 sg13_lv_nmos ad=0.2516p pd=2.16u as=4.4216p ps=27.885u w=0.74u l=0.13u
X1421 VSS.t585 sg13cmos5l_buf_1_66.X a_5782_15230# VSS.t840 sg13_lv_nmos ad=0.1406p pd=1.12u as=0.2516p ps=2.16u w=0.74u l=0.15u
X1422 VDD.t476 VSS.t850 VDD.t475 VDD.t5 sg13_lv_pmos ad=0.34p pd=2.68u as=0 ps=0 w=1u l=1u
X1423 VDD.t604 VSS.t1973 VDD.t603 VDD.t5 sg13_lv_pmos ad=0.34p pd=2.68u as=0 ps=0 w=1u l=1u
X1424 a_6682_8400# sg13cmos5l_dlygate4sd3_1_42.A VSS.t260 VSS.t699 sg13_lv_nmos ad=0.1428p pd=1.52u as=79.8f ps=0.8u w=0.42u l=0.13u
X1425 a_6393_19143# a_5451_19031# a_6191_19381# VDD.t231 sg13_lv_pmos ad=93.45f pd=0.865u as=0.2048p ps=1.63u w=0.42u l=0.13u
X1426 a_16773_5423# sg13cmos5l_inv_1_5.A VSS.t271 VSS.t1040 sg13_lv_nmos ad=0.2516p pd=2.16u as=3.65735p ps=23.23u w=0.74u l=0.13u
X1427 VDD.t1306 a_13596_13686# a_14619_14113# VDD.t19 sg13_lv_pmos ad=0.1563p pd=1.22u as=63f ps=0.72u w=0.42u l=0.13u
X1428 VSS.t13 a_16240_6382# a_15889_6239# VSS.t719 sg13_lv_nmos ad=79.8f pd=0.8u as=0.1428p ps=1.52u w=0.42u l=0.13u
X1429 a_8021_5412# sg13cmos5l_a21oi_1_8.A1 VDD.t2055 VDD.t5 sg13_lv_pmos ad=0.2128p pd=1.5u as=0.2128p ps=1.5u w=1.12u l=0.13u
X1430 a_8338_16742# sg13cmos5l_o21ai_1_21.Y sg13cmos5l_o21ai_1_14.Y VSS.t808 sg13_lv_nmos ad=0.1406p pd=1.12u as=0.2516p ps=2.16u w=0.74u l=0.15u
X1431 VSS.t176 a_4821_16043# a_3900_16357# VSS.t175 sg13_lv_nmos ad=0.1626p pd=1.415u as=0.2516p ps=2.16u w=0.74u l=0.13u
X1432 VSS.t2010 VDD.t2400 VSS.t2014 VSS.t2062 sg13_lv_nmos ad=79.8f pd=0.8u as=0 ps=0 w=0.42u l=1u
X1433 a_13786_7642# sg13cmos5l_dlygate4sd3_1_9.A VDD.t780 VDD.t8 sg13_lv_pmos ad=0.1428p pd=1.52u as=0.1523p ps=1.38u w=0.42u l=0.13u
X1434 VSS.t5 a_7498_18226# sg13cmos5l_dfrbpq_1_19.CLK VSS.t2266 sg13_lv_nmos ad=0.1406p pd=1.12u as=0.1406p ps=1.12u w=0.74u l=0.13u
X1435 VDD.t910 VSS.t1658 VDD.t629 VDD.t19 sg13_lv_pmos ad=0.19p pd=1.38u as=0 ps=0 w=1u l=1u
X1436 sg13cmos5l_buf_1_14.A a_12045_11808# VDD.t827 VDD.t0 sg13_lv_pmos ad=0.3808p pd=2.92u as=0.1918p ps=1.5u w=1.12u l=0.13u
X1437 sg13cmos5l_nor3_1_1.Y sg13cmos5l_o21ai_1_0.A1 VSS.t279 VSS.t2378 sg13_lv_nmos ad=0.1694p pd=1.21u as=0.1463p ps=1.15u w=0.77u l=0.13u
X1438 VSS.t702 a_6928_7894# a_6577_7751# VSS.t2505 sg13_lv_nmos ad=79.8f pd=0.8u as=0.1428p ps=1.52u w=0.42u l=0.13u
X1439 VSS.t915 a_13676_19734# code3 VSS.t914 sg13_lv_nmos ad=0.14875p pd=1.16u as=0.2886p ps=2.26u w=0.74u l=0.13u
X1440 a_4932_19024# a_4906_18988# VSS.t369 VSS.t1305 sg13_lv_nmos ad=0.2516p pd=2.16u as=0.1626p ps=1.415u w=0.74u l=0.13u
X1441 a_21911_18649# sg13cmos5l_dfrbpq_1_28.RESET_B.t11 VDD.t1228 VDD.t231 sg13_lv_pmos ad=79.8f pd=0.8u as=0.36237p ps=2.605u w=0.42u l=0.13u
X1442 VDD.t27 VSS.t2187 VDD.t26 VDD.t13 sg13_lv_pmos ad=0.34p pd=2.68u as=0 ps=0 w=1u l=1u
X1443 a_15225_17631# a_14283_17519# a_15023_17869# VDD.t310 sg13_lv_pmos ad=93.45f pd=0.865u as=0.2048p ps=1.63u w=0.42u l=0.13u
X1444 VSS.t107 a_12140_19734# code5 VSS.t2433 sg13_lv_nmos ad=0.14875p pd=1.16u as=0.2886p ps=2.26u w=0.74u l=0.13u
X1445 a_6256_14726# a_5999_14845# a_6418_14922# VSS.t793 sg13_lv_nmos ad=0.1428p pd=1.52u as=37.8f ps=0.6u w=0.42u l=0.13u
X1446 a_5541_9165# sg13cmos5l_dfrbpq_1_15.CLK VSS.t264 VSS.t2548 sg13_lv_nmos ad=0.2516p pd=2.16u as=5.26052p ps=34.445u w=0.74u l=0.13u
X1447 VDD.t375 sg13cmos5l_buf_1_7.X a_20294_4650# VDD.t5 sg13_lv_pmos ad=0.36237p pd=2.605u as=79.8f ps=0.8u w=0.42u l=0.13u
X1448 VDD.t246 VSS.t1829 VDD.t256 VDD.t8 sg13_lv_pmos ad=0.34p pd=2.68u as=0 ps=0 w=1u l=1u
X1449 a_20409_5535# a_19467_5423# a_20207_5773# VDD.t5 sg13_lv_pmos ad=93.45f pd=0.865u as=0.2048p ps=1.63u w=0.42u l=0.13u
X1450 a_13191_5499# a_13343_5383# VSS.t271 VSS.t276 sg13_lv_nmos ad=0.2516p pd=2.16u as=4.02307p ps=25.55u w=0.74u l=0.13u
X1451 sg13cmos5l_a21oi_1_2.A2 sg13cmos5l_nand4_1_18.B VDD.t1582 VDD.t83 sg13_lv_pmos ad=0.2128p pd=1.5u as=0.2128p ps=1.5u w=1.12u l=0.13u
X1452 VDD.t482 VSS.t850 VDD.t481 VDD.t13 sg13_lv_pmos ad=0.34p pd=2.68u as=0 ps=0 w=1u l=1u
X1453 sg13cmos5l_nand4_1_15.B sg13cmos5l_nor4_1_1.D a_10914_14020# VDD.t19 sg13_lv_pmos ad=0.4368p pd=3.02u as=0.2128p ps=1.5u w=1.12u l=0.13u
X1454 sg13cmos5l_buf_1_42.A a_17608_13760# VSS.t129 VSS.t128 sg13_lv_nmos ad=0.2886p pd=2.26u as=0.14875p ps=1.16u w=0.74u l=0.13u
X1455 VDD.t41 VSS.t1981 VDD.t40 VDD.t5 sg13_lv_pmos ad=0.34p pd=2.68u as=0 ps=0 w=1u l=1u
X1456 VSS.t56 a_9070_18447# sg13cmos5l_dlygate4sd3_1_58.X VSS.t1252 sg13_lv_nmos ad=0.1426p pd=1.16u as=0.2516p ps=2.16u w=0.74u l=0.13u
X1457 a_20294_14922# sg13cmos5l_dfrbpq_1_29.D VDD.t1025 VDD.t19 sg13_lv_pmos ad=79.8f pd=0.8u as=0.1428p ps=1.52u w=0.42u l=0.13u
X1458 a_20554_9916# a_20997_9959# a_20937_9995# VDD.t52 sg13_lv_pmos ad=79.8f pd=0.8u as=63f ps=0.72u w=0.42u l=0.13u
X1459 a_19919_7751# a_19077_7653# a_19825_7751# VSS.t2345 sg13_lv_nmos ad=0.12665p pd=1.145u as=0.1428p ps=1.52u w=0.42u l=0.13u
X1460 a_10214_10386# a_11019_9959# a_10474_9916# VDD.t52 sg13_lv_pmos ad=0.1428p pd=1.52u as=79.8f ps=0.8u w=0.42u l=0.13u
X1461 a_16356_5416# a_16330_5380# VDD.t371 VDD.t5 sg13_lv_pmos ad=0.34p pd=2.68u as=0.36237p ps=2.605u w=1u l=0.13u
X1462 a_13764_17512# a_13738_17476# VSS.t380 VSS.t2236 sg13_lv_nmos ad=0.2516p pd=2.16u as=0.1626p ps=1.415u w=0.74u l=0.13u
X1463 VDD.t700 a_12896_13897# sg13cmos5l_nand2_1_18.A VDD.t19 sg13_lv_pmos ad=0.2128p pd=1.5u as=0.3808p ps=2.92u w=1.12u l=0.13u
X1464 a_13676_12936# sg13cmos5l_buf_1_15.A.t2 VDD.t794 VDD.t83 sg13_lv_pmos ad=0.2856p pd=2.36u as=0.2114p ps=1.54u w=0.84u l=0.13u
X1465 a_9526_16742# sg13cmos5l_o21ai_1_14.A1 VSS.t48 VSS.t1358 sg13_lv_nmos ad=0.1406p pd=1.12u as=0.1406p ps=1.12u w=0.74u l=0.15u
X1466 VSS.t1646 VDD.t2550 VSS.t1645 VSS.t1641 sg13_lv_nmos ad=0.1428p pd=1.52u as=0 ps=0 w=0.42u l=1u
X1467 VSS.t2005 VDD.t2403 VSS.t2005 VSS.t2056 sg13_lv_nmos ad=79.8f pd=0.8u as=0 ps=0 w=0.42u l=1u
X1468 VDD.t900 a_6835_13916# sg13cmos5l_a21o_1_2.X VDD.t19 sg13_lv_pmos ad=0.3808p pd=2.92u as=0.3808p ps=2.92u w=1.12u l=0.13u
X1469 VSS.t153 a_12987_12214# sg13cmos5l_buf_8_2.A VSS.t2626 sg13_lv_nmos ad=0.1406p pd=1.12u as=0.1406p ps=1.12u w=0.74u l=0.13u
X1470 a_17039_18335# a_16197_18237# a_16945_18335# VSS.t92 sg13_lv_nmos ad=0.12665p pd=1.145u as=0.1428p ps=1.52u w=0.42u l=0.13u
X1471 sg13cmos5l_o21ai_1_14.A1 a_8830_17874# VDD.t384 VDD.t310 sg13_lv_pmos ad=0.3808p pd=2.92u as=0.2128p ps=1.5u w=1.12u l=0.13u
X1472 a_15442_17946# sg13cmos5l_buf_1_45.X.t6 VSS.t113 VSS.t925 sg13_lv_nmos ad=37.8f pd=0.6u as=79.8f ps=0.8u w=0.42u l=0.13u
X1473 VDD.t19 sg13cmos5l_dfrbpq_1_13.CLK a_13727_13992# VDD.t19 sg13_lv_pmos ad=2.1916p pd=14.26u as=0.4088p ps=2.97u w=1.12u l=0.13u
X1474 VDD.t1724 sg13cmos5l_nand4_1_1.C sg13cmos5l_nand3_1_8.Y VDD.t83 sg13_lv_pmos ad=0.3808p pd=2.92u as=0.2128p ps=1.5u w=1.12u l=0.13u
X1475 a_6802_9186# sg13cmos5l_dfrbpq_1_13.RESET_B VSS.t260 VSS.t1197 sg13_lv_nmos ad=37.8f pd=0.6u as=79.8f ps=0.8u w=0.42u l=0.13u
X1476 VSS.t206 a_13862_6166# a_13974_6230# VSS.t909 sg13_lv_nmos ad=0.1426p pd=1.16u as=0.1428p ps=1.52u w=0.42u l=0.5u
X1477 VDD.t2022 VSS.t1630 VDD.t323 VDD.t310 sg13_lv_pmos ad=0.19p pd=1.38u as=0 ps=0 w=1u l=1u
X1478 sg13cmos5l_a21oi_1_13.A2 sg13cmos5l_nor3_1_6.Y VDD.t1726 VDD.t19 sg13_lv_pmos ad=0.2128p pd=1.5u as=0.2128p ps=1.5u w=1.12u l=0.13u
X1479 VDD.t1744 sg13cmos5l_buf_8_2.A.t1 a_17098_6130# VDD.t2 sg13_lv_pmos ad=0.2128p pd=1.5u as=0.2128p ps=1.5u w=1.12u l=0.13u
X1480 a_20868_8861# a_21099_8447# a_20554_8404# VSS.t2595 sg13_lv_nmos ad=0.2373p pd=1.97u as=79.8f ps=0.8u w=0.42u l=0.13u
X1481 sg13cmos5l_o21ai_1_18.B1 a_9846_17532# VSS.t58 VSS.t577 sg13_lv_nmos ad=0.2516p pd=2.16u as=0.1426p ps=1.16u w=0.74u l=0.13u
X1482 a_12016_10190# sg13cmos5l_dfrbpq_1_13.RESET_B VDD.t52 VDD.t52 sg13_lv_pmos ad=79.8f pd=0.8u as=1.79022p ps=11.585u w=0.42u l=0.13u
X1483 VSS.t1643 VDD.t2548 VSS.t1642 VSS.t227 sg13_lv_nmos ad=0.1428p pd=1.52u as=0 ps=0 w=0.42u l=1u
X1484 a_17445_15213# sg13cmos5l_dfrbpq_1_41.CLK VDD.t16 VDD.t16 sg13_lv_pmos ad=0.4088p pd=2.97u as=1.97245p ps=12.835u w=1.12u l=0.13u
X1485 VDD.t723 a_9446_13726# a_9558_13790# VDD.t19 sg13_lv_pmos ad=0.2254p pd=1.53u as=0.34p ps=2.68u w=1u l=0.5u
X1486 a_20868_13735# a_21099_13844# a_20554_13945# VSS.t128 sg13_lv_nmos ad=0.2373p pd=1.97u as=79.8f ps=0.8u w=0.42u l=0.13u
X1487 VSS.t2068 VDD.t13 VSS.t2067 VSS.t2066 sg13_lv_nmos ad=0.1428p pd=1.52u as=0 ps=0 w=0.42u l=1u
X1488 a_19044_17933# a_19275_17519# a_18730_17476# VSS.t224 sg13_lv_nmos ad=0.2373p pd=1.97u as=79.8f ps=0.8u w=0.42u l=0.13u
X1489 sg13cmos5l_dlygate4sd3_1_64.X a_5334_17532# VDD.t646 VDD.t310 sg13_lv_pmos ad=0.4256p pd=3u as=0.2254p ps=1.53u w=1.12u l=0.13u
X1490 VDD.t925 sg13cmos5l_dfrbpq_1_24.Q a_7736_13726# VDD.t19 sg13_lv_pmos ad=0.1523p pd=1.38u as=0.1428p ps=1.52u w=0.42u l=0.13u
X1491 VSS.t210 a_22126_3327# sg13cmos5l_buf_1_3.A VSS.t1048 sg13_lv_nmos ad=0.1426p pd=1.16u as=0.2516p ps=2.16u w=0.74u l=0.13u
X1492 VDD.t378 sg13cmos5l_buf_1_7.X a_16330_5380# VDD.t5 sg13_lv_pmos ad=0.1563p pd=1.22u as=0.147p ps=1.54u w=0.42u l=0.13u
X1493 VDD.t1756 sg13cmos5l_dfrbpq_1_28.RESET_B.t14 a_18730_18988# VDD.t231 sg13_lv_pmos ad=0.1563p pd=1.22u as=0.147p ps=1.54u w=0.42u l=0.13u
X1494 a_18470_17946# sg13cmos5l_dfrbpq_1_39.D VDD.t1645 VDD.t310 sg13_lv_pmos ad=79.8f pd=0.8u as=0.1428p ps=1.52u w=0.42u l=0.13u
X1495 a_17820_16754# sg13cmos5l_nand4_1_1.B a_17718_16754# VSS.t1189 sg13_lv_nmos ad=0.1406p pd=1.12u as=0.1406p ps=1.12u w=0.74u l=0.13u
X1496 VDD.t1505 a_4476_18222# a_5499_18649# VDD.t231 sg13_lv_pmos ad=0.1563p pd=1.22u as=63f ps=0.72u w=0.42u l=0.13u
X1497 a_20974_16119# a_20716_16434# VDD.t16 VDD.t16 sg13_lv_pmos ad=93.45f pd=0.865u as=2.07625p ps=13.51u w=0.42u l=0.13u
X1498 VSS.t230 a_1690_15202# a_1409_15424# VSS.t229 sg13_lv_nmos ad=79.8f pd=0.8u as=0.1428p ps=1.52u w=0.42u l=0.5u
X1499 VDD.t1448 sg13cmos5l_a21oi_1_4.A2 a_15358_14850# VDD.t19 sg13_lv_pmos ad=0.2198p pd=1.53u as=0.2856p ps=2.36u w=0.84u l=0.13u
X1500 a_8006_13726# a_7736_13726# VDD.t925 VDD.t19 sg13_lv_pmos ad=0.34p pd=2.68u as=0.1523p ps=1.38u w=1u l=0.5u
X1501 a_18578_12218# sg13cmos5l_nand4_1_18.D VSS.t523 VSS.t522 sg13_lv_nmos ad=0.1406p pd=1.12u as=0.2516p ps=2.16u w=0.74u l=0.13u
X1502 VSS.t1752 VDD.t2506 VSS.t1754 VSS.t1753 sg13_lv_nmos ad=79.8f pd=0.8u as=0 ps=0 w=0.42u l=1u
X1503 a_18678_13730# sg13cmos5l_nand4_1_1.A sg13cmos5l_a21oi_1_15.A2 VSS.t128 sg13_lv_nmos ad=0.1406p pd=1.12u as=0.2516p ps=2.16u w=0.74u l=0.13u
X1504 sg13cmos5l_nand3_1_4.Y sg13cmos5l_nor2_1_2.B VDD.t2234 VDD.t8 sg13_lv_pmos ad=0.2128p pd=1.5u as=0.3808p ps=2.92u w=1.12u l=0.13u
X1505 a_11558_19020# a_11288_19061# VSS.t937 VSS.t1297 sg13_lv_nmos ad=0.1428p pd=1.52u as=79.8f ps=0.8u w=0.42u l=0.5u
X1506 a_13102_5535# a_12844_5850# VDD.t5 VDD.t5 sg13_lv_pmos ad=93.45f pd=0.865u as=1.96072p ps=12.69u w=0.42u l=0.13u
X1507 a_22658_16434# sg13cmos5l_buf_1_15.A.t3 VSS.t677 VSS.t1274 sg13_lv_nmos ad=60.89999f pd=0.71u as=0.1626p ps=1.415u w=0.42u l=0.13u
X1508 a_22041_4965# a_21099_4772# a_21839_4727# VDD.t5 sg13_lv_pmos ad=93.45f pd=0.865u as=0.2048p ps=1.63u w=0.42u l=0.13u
X1509 a_17243_17508# sg13cmos5l_buf_1_16.A sg13cmos5l_a21oi_1_24.Y VDD.t310 sg13_lv_pmos ad=0.2128p pd=1.5u as=0.3808p ps=2.92u w=1.12u l=0.13u
X1510 VSS.t117 a_19054_18447# sg13cmos5l_dfrbpq_1_39.D VSS.t1287 sg13_lv_nmos ad=0.1426p pd=1.16u as=0.2516p ps=2.16u w=0.74u l=0.13u
X1511 VSS.t1660 VDD.t2544 VSS.t1663 VSS.t1662 sg13_lv_nmos ad=79.8f pd=0.8u as=0 ps=0 w=0.42u l=1u
X1512 a_17762_9186# sg13cmos5l_buf_1_13.A VSS.t81 VSS.t2363 sg13_lv_nmos ad=60.89999f pd=0.71u as=0.1626p ps=1.415u w=0.42u l=0.13u
X1513 VSS.t1987 VDD.t2430 VSS.t1987 VSS.t1988 sg13_lv_nmos ad=0.1428p pd=1.52u as=0 ps=0 w=0.42u l=1u
X1514 VDD.t460 VSS.t291 VDD.t459 VDD.t13 sg13_lv_pmos ad=0.34p pd=2.68u as=0 ps=0 w=1u l=1u
X1515 VDD.t1480 sg13cmos5l_buf_1_26.A a_10696_15272# VDD.t16 sg13_lv_pmos ad=0.2114p pd=1.54u as=0.2856p ps=2.36u w=0.84u l=0.13u
X1516 a_4714_14452# a_5157_14495# a_5097_14531# VDD.t19 sg13_lv_pmos ad=79.8f pd=0.8u as=63f ps=0.72u w=0.42u l=0.13u
X1517 VSS.t245 a_14517_13880# a_13596_13686# VSS.t857 sg13_lv_nmos ad=0.1626p pd=1.415u as=0.2516p ps=2.16u w=0.74u l=0.13u
X1518 VSS.t153 a_12987_12214# sg13cmos5l_buf_8_2.A VSS.t2622 sg13_lv_nmos ad=0.1406p pd=1.12u as=0.1406p ps=1.12u w=0.74u l=0.13u
X1519 sg13cmos5l_nand3b_1_1.C a_7350_17532# VDD.t357 VDD.t310 sg13_lv_pmos ad=0.4256p pd=3u as=0.2254p ps=1.53u w=1.12u l=0.13u
X1520 a_11374_17775# a_11489_17774# VSS.t953 VSS.t952 sg13_lv_nmos ad=0.1428p pd=1.52u as=0.1426p ps=1.16u w=0.42u l=0.5u
X1521 a_15582_14850# sg13cmos5l_nand3b_1_3.C VSS.t201 VSS.t1266 sg13_lv_nmos ad=0.1406p pd=1.12u as=0.18575p ps=1.26u w=0.74u l=0.13u
X1522 sg13cmos5l_dfrbpq_1_5.CLK a_21531_13342# VDD.t1597 VDD.t83 sg13_lv_pmos ad=0.2128p pd=1.5u as=0.2128p ps=1.5u w=1.12u l=0.13u
X1523 VSS.t571 VDD.t2476 VSS.t571 VSS.t1856 sg13_lv_nmos ad=79.8f pd=0.8u as=0 ps=0 w=0.42u l=1u
X1524 VSS.t2005 VDD.t2421 VSS.t2005 VSS.t2008 sg13_lv_nmos ad=79.8f pd=0.8u as=0 ps=0 w=0.42u l=1u
X1525 a_18021_11471# sg13cmos5l_dfrbpq_1_13.CLK VDD.t0 VDD.t0 sg13_lv_pmos ad=0.4088p pd=2.97u as=2.1916p ps=14.26u w=1.12u l=0.13u
X1526 VSS.t1618 VDD.t2559 VSS.t1620 VSS.t1619 sg13_lv_nmos ad=79.8f pd=0.8u as=0 ps=0 w=0.42u l=1u
X1527 VSS.t375 a_7354_16714# a_7073_16936# VSS.t374 sg13_lv_nmos ad=79.8f pd=0.8u as=0.1428p ps=1.52u w=0.42u l=0.5u
X1528 VDD.t1767 a_18188_4614# sg13cmos5l_a21oi_1_2.B1 VDD.t5 sg13_lv_pmos ad=0.2114p pd=1.54u as=0.42p ps=2.99u w=1.12u l=0.13u
X1529 a_7941_19031# sg13cmos5l_dfrbpq_1_19.CLK VSS.t169 VSS.t2473 sg13_lv_nmos ad=0.2516p pd=2.16u as=3.5562p ps=22.685u w=0.74u l=0.13u
X1530 VDD.t470 VSS.t291 VDD.t468 VDD.t13 sg13_lv_pmos ad=0.19p pd=1.38u as=0 ps=0 w=1u l=1u
X1531 VSS.t1632 VDD.t2552 VSS.t1632 VSS.t1639 sg13_lv_nmos ad=0.1428p pd=1.52u as=0 ps=0 w=0.42u l=1u
X1532 VDD.t849 sg13cmos5l_buf_1_6.A a_18952_3176# VDD.t13 sg13_lv_pmos ad=0.2114p pd=1.54u as=0.2856p ps=2.36u w=0.84u l=0.13u
X1533 VDD.t1481 sg13cmos5l_inv_1_15.A sg13cmos5l_inv_1_15.Y VDD.t8 sg13_lv_pmos ad=0.3808p pd=2.92u as=0.3808p ps=2.92u w=1.12u l=0.13u
X1534 VDD.t1381 sg13cmos5l_and4_1_0.D sg13cmos5l_nand2_1_5.Y VDD.t8 sg13_lv_pmos ad=0.3808p pd=2.92u as=0.2128p ps=1.5u w=1.12u l=0.13u
X1535 a_4646_19458# a_5451_19031# a_4906_18988# VDD.t231 sg13_lv_pmos ad=0.1428p pd=1.52u as=79.8f ps=0.8u w=0.42u l=0.13u
X1536 VSS.t1902 VDD.t2460 VSS.t1902 VSS.t1901 sg13_lv_nmos ad=0.1428p pd=1.52u as=0 ps=0 w=0.42u l=1u
X1537 a_21466_7642# sg13cmos5l_a21oi_1_2.Y VSS.t26 VSS.t286 sg13_lv_nmos ad=0.1428p pd=1.52u as=79.8f ps=0.8u w=0.42u l=0.13u
X1538 a_10326_14484# sg13cmos5l_nor3_1_4.A VDD.t1081 VDD.t19 sg13_lv_pmos ad=0.2128p pd=1.5u as=0.3808p ps=2.92u w=1.12u l=0.13u
X1539 a_17412_11898# sg13cmos5l_dlygate4sd3_1_13.X a_17318_11898# VSS.t2541 sg13_lv_nmos ad=60.89999f pd=0.71u as=0.1428p ps=1.52u w=0.42u l=0.13u
X1540 a_22234_19738# sg13cmos5l_dfrbpq_1_34.Q VSS.t1056 VSS.t1055 sg13_lv_nmos ad=0.1428p pd=1.52u as=79.8f ps=0.8u w=0.42u l=0.13u
X1541 VDD.t608 VSS.t1973 VDD.t607 VDD.t5 sg13_lv_pmos ad=0.34p pd=2.68u as=0 ps=0 w=1u l=1u
X1542 a_9705_20161# a_9348_20088# VDD.t1536 VDD.t270 sg13_lv_pmos ad=63f pd=0.72u as=0.1563p ps=1.22u w=0.42u l=0.13u
X1543 a_21911_17137# a_21215_17016# a_22005_16904# VSS.t706 sg13_lv_nmos ad=0.1296p pd=1.52u as=79.8f ps=0.8u w=0.42u l=0.13u
X1544 sg13cmos5l_o21ai_1_7.A2 sg13cmos5l_nand4_1_18.B a_8714_20068# VDD.t270 sg13_lv_pmos ad=0.3808p pd=2.92u as=0.1176p ps=1.33u w=1.12u l=0.13u
X1545 a_9624_17064# sg13cmos5l_or4_1_1.X VDD.t1689 VDD.t310 sg13_lv_pmos ad=0.2128p pd=1.5u as=0.3808p ps=2.92u w=1.12u l=0.15u
X1546 sg13cmos5l_inv_1_31.A a_19035_16750# VSS.t132 VSS.t442 sg13_lv_nmos ad=0.1406p pd=1.12u as=0.1406p ps=1.12u w=0.74u l=0.13u
X1547 VDD.t196 VSS.t1797 VDD.t180 VDD.t52 sg13_lv_pmos ad=0.19p pd=1.38u as=0 ps=0 w=1u l=1u
X1548 a_22426_18984# sg13cmos5l_dfrbpq_1_35.Q VSS.t1173 VSS.t1098 sg13_lv_nmos ad=0.1428p pd=1.52u as=79.8f ps=0.8u w=0.42u l=0.13u
X1549 VSS.t1058 VDD.t2496 VSS.t1058 VSS.t1810 sg13_lv_nmos ad=0.1428p pd=1.52u as=0 ps=0 w=0.42u l=1u
X1550 sg13cmos5l_nor2_1_2.Y sg13cmos5l_nor2_1_2.B VSS.t291 VSS.t2487 sg13_lv_nmos ad=0.1406p pd=1.12u as=0.2516p ps=2.16u w=0.74u l=0.13u
X1551 a_4966_14909# sg13cmos5l_dfrbpq_1_24.RESET_B VSS.t585 VSS.t1120 sg13_lv_nmos ad=37.8f pd=0.6u as=0.1701p ps=1.65u w=0.42u l=0.13u
X1552 VSS.t1703 VDD.t2525 VSS.t1702 VSS.t1701 sg13_lv_nmos ad=0.1428p pd=1.52u as=0 ps=0 w=0.42u l=1u
X1553 a_9136_10190# a_8879_10309# a_9298_10386# VSS.t2506 sg13_lv_nmos ad=0.1428p pd=1.52u as=37.8f ps=0.6u w=0.42u l=0.13u
X1554 a_8217_11583# a_7275_11471# a_8015_11821# VDD.t0 sg13_lv_pmos ad=93.45f pd=0.865u as=0.2048p ps=1.63u w=0.42u l=0.13u
X1555 VDD.t1502 sg13cmos5l_dfrbpq_1_24.RESET_B a_7238_19458# VDD.t231 sg13_lv_pmos ad=0.36237p pd=2.605u as=79.8f ps=0.8u w=0.42u l=0.13u
X1556 VSS.t153 clk a_12987_12214# VSS.t714 sg13_lv_nmos ad=0.1406p pd=1.12u as=0.2553p ps=2.17u w=0.74u l=0.13u
X1557 VDD.t1953 sg13cmos5l_buf_1_3.A sg13cmos5l_inv_1_6.Y VDD.t5 sg13_lv_pmos ad=0.3808p pd=2.92u as=0.3808p ps=2.92u w=1.12u l=0.13u
X1558 VDD.t2213 a_6094_19959# sg13cmos5l_o21ai_1_7.B1 VDD.t270 sg13_lv_pmos ad=0.2254p pd=1.53u as=0.4256p ps=3u w=1.12u l=0.13u
X1559 VDD.t1412 a_19246_19959# sg13cmos5l_dfrbpq_1_35.D VDD.t270 sg13_lv_pmos ad=0.2254p pd=1.53u as=0.4256p ps=3u w=1.12u l=0.13u
X1560 a_13478_17946# a_14283_17519# a_13738_17476# VDD.t310 sg13_lv_pmos ad=0.1428p pd=1.52u as=79.8f ps=0.8u w=0.42u l=0.13u
X1561 VDD.t1426 sg13cmos5l_dlygate4sd3_1_50.A a_4568_15238# VDD.t16 sg13_lv_pmos ad=0.1523p pd=1.38u as=0.1428p ps=1.52u w=0.42u l=0.13u
X1562 a_14218_18226# sg13cmos5l_buf_8_2.A.t6 VDD.t2351 VDD.t231 sg13_lv_pmos ad=0.3808p pd=2.92u as=0.2128p ps=1.5u w=1.12u l=0.13u
X1563 VSS.t585 sg13cmos5l_nand4_1_3.B sg13cmos5l_nor2_1_7.Y VSS.t2631 sg13_lv_nmos ad=0.2516p pd=2.16u as=0.1406p ps=1.12u w=0.74u l=0.13u
X1564 bp5 a_20872_3176# VDD.t825 VDD.t13 sg13_lv_pmos ad=0.42p pd=2.99u as=0.2114p ps=1.54u w=1.12u l=0.13u
X1565 VDD.t438 VSS.t2192 VDD.t841 VDD.t13 sg13_lv_pmos ad=0.34p pd=2.68u as=0 ps=0 w=1u l=1u
X1566 a_20384_16921# a_20503_16710# VSS.t132 VSS.t337 sg13_lv_nmos ad=0.2516p pd=2.16u as=0.1406p ps=1.12u w=0.74u l=0.13u
X1567 a_20937_12601# a_20580_12528# VDD.t844 VDD.t83 sg13_lv_pmos ad=63f pd=0.72u as=0.1563p ps=1.22u w=0.42u l=0.13u
X1568 a_12512_5699# a_12631_5376# VDD.t779 VDD.t5 sg13_lv_pmos ad=0.3864p pd=2.93u as=0.2128p ps=1.5u w=1.12u l=0.13u
X1569 VDD.t688 sg13cmos5l_a21oi_1_4.A1 sg13cmos5l_nand4_1_3.D VDD.t19 sg13_lv_pmos ad=0.2128p pd=1.5u as=0.2128p ps=1.5u w=1.12u l=0.13u
X1570 VSS.t1906 VDD.t2449 VSS.t1908 VSS.t1907 sg13_lv_nmos ad=79.8f pd=0.8u as=0 ps=0 w=0.42u l=1u
X1571 sg13cmos5l_dlygate4sd3_1_8.X a_13014_8460# VSS.t441 VSS.t440 sg13_lv_nmos ad=0.2516p pd=2.16u as=0.1426p ps=1.16u w=0.74u l=0.13u
X1572 a_22523_15532# sg13cmos5l_nand3_1_8.Y VDD.t1072 VDD.t16 sg13_lv_pmos ad=0.3808p pd=2.92u as=0.2128p ps=1.5u w=1.12u l=0.13u
X1573 VDD.t999 sg13cmos5l_nor3_1_2.B sg13cmos5l_a21o_1_0.A2 VDD.t0 sg13_lv_pmos ad=0.3808p pd=2.92u as=0.2128p ps=1.5u w=1.12u l=0.15u
X1574 a_6928_7894# a_6671_7751# a_7090_7674# VSS.t700 sg13_lv_nmos ad=0.1428p pd=1.52u as=37.8f ps=0.6u w=0.42u l=0.13u
X1575 VDD.t950 a_21646_15423# sg13cmos5l_buf_1_1.A VDD.t16 sg13_lv_pmos ad=0.2254p pd=1.53u as=0.4256p ps=3u w=1.12u l=0.13u
X1576 sg13cmos5l_a21oi_1_23.A2 sg13cmos5l_nand4_1_3.B VDD.t1721 VDD.t19 sg13_lv_pmos ad=0.2128p pd=1.5u as=0.2128p ps=1.5u w=1.12u l=0.13u
X1577 VSS.t1752 VDD.t2517 VSS.t1754 VSS.t1753 sg13_lv_nmos ad=79.8f pd=0.8u as=0 ps=0 w=0.42u l=1u
X1578 VSS.t180 a_17039_18335# a_17706_18556# VSS.t92 sg13_lv_nmos ad=0.1406p pd=1.12u as=0.2516p ps=2.16u w=0.74u l=0.13u
X1579 VDD.t930 sg13cmos5l_dlygate4sd3_1_50.X sg13cmos5l_o21ai_1_12.Y VDD.t16 sg13_lv_pmos ad=0.3808p pd=2.92u as=0.2128p ps=1.5u w=1.12u l=0.15u
X1580 VSS.t72 a_20890_15202# a_20609_15424# VSS.t717 sg13_lv_nmos ad=79.8f pd=0.8u as=0.1428p ps=1.52u w=0.42u l=0.5u
X1581 VSS.t67 sg13cmos5l_dfrbpq_1_24.Q sg13cmos5l_nand4_1_3.B VSS.t66 sg13_lv_nmos ad=0.23757p pd=2.16u as=0.1406p ps=1.12u w=0.74u l=0.13u
X1582 VSS.t362 a_6442_10666# sg13cmos5l_dfrbpq_1_15.CLK VSS.t2405 sg13_lv_nmos ad=0.1406p pd=1.12u as=0.1406p ps=1.12u w=0.74u l=0.13u
X1583 a_13566_8412# sg13cmos5l_a22oi_1_0.A2 VDD.t942 VDD.t8 sg13_lv_pmos ad=0.2744p pd=1.61u as=0.3808p ps=2.92u w=1.12u l=0.13u
X1584 VSS.t1632 VDD.t2556 VSS.t1632 VSS.t1631 sg13_lv_nmos ad=0.1428p pd=1.52u as=0 ps=0 w=0.42u l=1u
X1585 a_5638_7687# sg13cmos5l_dfrbpq_1_13.RESET_B VSS.t1219 VSS.t1218 sg13_lv_nmos ad=37.8f pd=0.6u as=0.1701p ps=1.65u w=0.42u l=0.13u
X1586 VDD.t423 VSS.t1622 VDD.t422 VDD.t231 sg13_lv_pmos ad=0.34p pd=2.68u as=0 ps=0 w=1u l=1u
X1587 VDD.t643 a_8006_13726# a_8118_13790# VDD.t19 sg13_lv_pmos ad=0.2254p pd=1.53u as=0.34p ps=2.68u w=1u l=0.5u
X1588 VDD.t478 VSS.t850 VDD.t477 VDD.t13 sg13_lv_pmos ad=0.34p pd=2.68u as=0 ps=0 w=1u l=1u
X1589 VDD.t559 VSS.t1966 VDD.t558 VDD.t5 sg13_lv_pmos ad=0.34p pd=2.68u as=0 ps=0 w=1u l=1u
X1590 a_20937_5041# a_20580_4968# VDD.t362 VDD.t5 sg13_lv_pmos ad=63f pd=0.72u as=0.1563p ps=1.22u w=0.42u l=0.13u
X1591 a_9862_12223# sg13cmos5l_dfrbpq_1_13.RESET_B VSS.t50 VSS.t1207 sg13_lv_nmos ad=37.8f pd=0.6u as=0.1701p ps=1.65u w=0.42u l=0.13u
X1592 VDD.t825 sg13cmos5l_buf_1_8.A a_20872_3176# VDD.t13 sg13_lv_pmos ad=0.2114p pd=1.54u as=0.2856p ps=2.36u w=0.84u l=0.13u
X1593 a_8878_7191# a_8993_7190# VSS.t779 VSS.t2503 sg13_lv_nmos ad=0.1428p pd=1.52u as=0.1426p ps=1.16u w=0.42u l=0.5u
X1594 sg13cmos5l_or4_1_1.X a_9096_15996# VDD.t1169 VDD.t16 sg13_lv_pmos ad=0.3808p pd=2.92u as=0.2144p ps=1.52u w=1.12u l=0.13u
X1595 a_19930_4618# sg13cmos5l_dlygate4sd3_1_1.A VDD.t719 VDD.t5 sg13_lv_pmos ad=0.1428p pd=1.52u as=0.1523p ps=1.38u w=0.42u l=0.13u
X1596 VSS.t204 a_13690_16714# a_13409_16936# VSS.t1183 sg13_lv_nmos ad=79.8f pd=0.8u as=0.1428p ps=1.52u w=0.42u l=0.5u
X1597 VDD.t535 VSS.t1058 VDD.t212 VDD.t0 sg13_lv_pmos ad=0.19p pd=1.38u as=0 ps=0 w=1u l=1u
X1598 VSS.t740 VDD.t2494 VSS.t740 VSS.t1814 sg13_lv_nmos ad=0.1428p pd=1.52u as=0 ps=0 w=0.42u l=1u
X1599 VSS.t1981 VDD.t2433 VSS.t1973 VSS.t1980 sg13_lv_nmos ad=0.1428p pd=1.52u as=0 ps=0 w=0.42u l=1u
X1600 a_10864_19990# a_10607_19847# a_11026_19770# VSS.t2424 sg13_lv_nmos ad=0.1428p pd=1.52u as=37.8f ps=0.6u w=0.42u l=0.13u
X1601 a_22030_19287# a_22145_19286# VSS.t1056 VSS.t1098 sg13_lv_nmos ad=0.1428p pd=1.52u as=0.1426p ps=1.16u w=0.42u l=0.5u
X1602 sg13cmos5l_o21ai_1_26.B1 a_13686_18326# VDD.t1146 VDD.t231 sg13_lv_pmos ad=0.4256p pd=3u as=0.2254p ps=1.53u w=1.12u l=0.13u
X1603 VDD.t1282 a_18671_7285# a_19338_6924# VDD.t2 sg13_lv_pmos ad=0.2128p pd=1.5u as=0.3864p ps=2.93u w=1.12u l=0.13u
X1604 VDD.t515 VSS.t1938 VDD.t514 VDD.t2 sg13_lv_pmos ad=0.19p pd=1.38u as=0 ps=0 w=1u l=1u
X1605 VDD.t1249 sg13cmos5l_nand2b_1_3.B sg13cmos5l_nand2b_1_3.Y VDD.t2 sg13_lv_pmos ad=0.2198p pd=1.53u as=0.2128p ps=1.5u w=1.12u l=0.13u
X1606 VDD.t1712 sg13cmos5l_nand4_1_18.A sg13cmos5l_a21oi_1_1.A2 VDD.t19 sg13_lv_pmos ad=0.3808p pd=2.92u as=0.2128p ps=1.5u w=1.12u l=0.13u
X1607 a_3296_16921# a_3415_16710# VSS.t309 VSS.t403 sg13_lv_nmos ad=0.2516p pd=2.16u as=0.1406p ps=1.12u w=0.74u l=0.13u
X1608 VDD.t1595 a_15023_17869# a_15690_17508# VDD.t310 sg13_lv_pmos ad=0.2128p pd=1.5u as=0.3864p ps=2.93u w=1.12u l=0.13u
X1609 a_14532_6162# sg13cmos5l_dlygate4sd3_1_7.X a_14438_6162# VSS.t1041 sg13_lv_nmos ad=60.89999f pd=0.71u as=0.1428p ps=1.52u w=0.42u l=0.13u
X1610 VSS.t101 sg13cmos5l_nand2b_1_1.A_N sg13cmos5l_nor2b_1_2.Y VSS.t2222 sg13_lv_nmos ad=0.2516p pd=2.16u as=0.1406p ps=1.12u w=0.74u l=0.13u
X1611 VDD.t1004 sg13cmos5l_dfrbpq_1_5.Q a_20984_10702# VDD.t0 sg13_lv_pmos ad=0.1523p pd=1.38u as=0.1428p ps=1.52u w=0.42u l=0.13u
X1612 a_13862_6166# a_13592_6166# VDD.t1753 VDD.t2 sg13_lv_pmos ad=0.34p pd=2.68u as=0.1523p ps=1.38u w=1u l=0.5u
X1613 a_11278_6351# a_11393_6352# VDD.t1159 VDD.t2 sg13_lv_pmos ad=0.34p pd=2.68u as=0.2254p ps=1.53u w=1u l=0.5u
X1614 a_20974_17061# a_20716_16746# VDD.t310 VDD.t310 sg13_lv_pmos ad=93.45f pd=0.865u as=2.1916p ps=14.26u w=0.42u l=0.13u
X1615 a_19738_9912# sg13cmos5l_dfrbpq_1_11.Q VDD.t1458 VDD.t52 sg13_lv_pmos ad=0.1428p pd=1.52u as=0.1523p ps=1.38u w=0.42u l=0.13u
X1616 VSS.t380 sg13cmos5l_dfrbpq_1_48.Q a_13304_18262# VSS.t727 sg13_lv_nmos ad=79.8f pd=0.8u as=0.1428p ps=1.52u w=0.42u l=0.13u
X1617 VDD.t2264 sg13cmos5l_o21ai_1_25.B1 sg13cmos5l_o21ai_1_25.Y VDD.t310 sg13_lv_pmos ad=0.3808p pd=2.92u as=0.2128p ps=1.5u w=1.12u l=0.15u
X1618 VDD.t1406 a_6442_10666# sg13cmos5l_dfrbpq_1_15.CLK VDD.t0 sg13_lv_pmos ad=0.2128p pd=1.5u as=0.2128p ps=1.5u w=1.12u l=0.13u
X1619 VDD.t785 sg13cmos5l_nor2_1_2.A a_8620_4948# VDD.t5 sg13_lv_pmos ad=0.4032p pd=2.96u as=0.1176p ps=1.33u w=1.12u l=0.13u
X1620 VDD.t1149 a_10607_5773# a_11274_5412# VDD.t5 sg13_lv_pmos ad=0.2128p pd=1.5u as=0.3864p ps=2.93u w=1.12u l=0.13u
X1621 VSS.t369 sg13cmos5l_o21ai_1_7.B1 a_4744_19808# VSS.t572 sg13_lv_nmos ad=0.14875p pd=1.16u as=0.187p ps=1.78u w=0.55u l=0.13u
X1622 VDD.t389 sg13cmos5l_buf_1_65.A a_8830_17874# VDD.t310 sg13_lv_pmos ad=0.2198p pd=1.53u as=0.2856p ps=2.36u w=0.84u l=0.13u
X1623 VSS.t242 a_16197_18237# a_16299_18380# VSS.t1018 sg13_lv_nmos ad=4.1963p pd=27.415u as=0.2516p ps=2.16u w=0.74u l=0.13u
X1624 sg13cmos5l_inv_1_12.Y sg13cmos5l_inv_1_12.A VDD.t883 VDD.t52 sg13_lv_pmos ad=0.3808p pd=2.92u as=0.3808p ps=2.92u w=1.12u l=0.13u
X1625 a_9062_5850# sg13cmos5l_dfrbpq_1_13.D VDD.t2337 VDD.t5 sg13_lv_pmos ad=79.8f pd=0.8u as=0.1428p ps=1.52u w=0.42u l=0.13u
X1626 VSS.t122 sg13cmos5l_buf_1_4.A a_20488_3176# VSS.t848 sg13_lv_nmos ad=0.14875p pd=1.16u as=0.187p ps=1.78u w=0.55u l=0.13u
X1627 VSS.t291 VDD.t2428 VSS.t291 VSS.t1992 sg13_lv_nmos ad=79.8f pd=0.8u as=0 ps=0 w=0.42u l=1u
X1628 sg13cmos5l_o21ai_1_4.Y sg13cmos5l_o21ai_1_0.Y VDD.t760 VDD.t2 sg13_lv_pmos ad=0.2128p pd=1.5u as=0.3808p ps=2.92u w=1.12u l=0.15u
X1629 VDD.t749 sg13cmos5l_nand4_1_18.C sg13cmos5l_a21oi_1_5.A2 VDD.t83 sg13_lv_pmos ad=0.2128p pd=1.5u as=0.2128p ps=1.5u w=1.12u l=0.13u
X1630 a_19236_5837# a_18948_5416# a_19174_5837# VSS.t861 sg13_lv_nmos ad=0.1428p pd=1.52u as=37.8f ps=0.6u w=0.42u l=0.13u
X1631 sg13cmos5l_inv_1_8.Y sg13cmos5l_inv_1_8.A VSS.t206 VSS.t243 sg13_lv_nmos ad=0.2516p pd=2.16u as=0.2516p ps=2.16u w=0.74u l=0.13u
X1632 a_10118_18262# a_9848_18262# VSS.t58 VSS.t1096 sg13_lv_nmos ad=0.1428p pd=1.52u as=79.8f ps=0.8u w=0.42u l=0.5u
X1633 a_20974_18258# a_20716_18258# VSS.t435 VSS.t118 sg13_lv_nmos ad=0.1428p pd=1.52u as=79.8f ps=0.8u w=0.42u l=0.13u
X1634 a_5660_14040# sg13cmos5l_o21ai_1_9.A2 sg13cmos5l_o21ai_1_9.Y VDD.t19 sg13_lv_pmos ad=0.2128p pd=1.5u as=0.2128p ps=1.5u w=1.12u l=0.15u
X1635 VDD.t252 VSS.t1756 VDD.t525 VDD.t83 sg13_lv_pmos ad=0.34p pd=2.68u as=0 ps=0 w=1u l=1u
X1636 VDD.t1234 sg13cmos5l_buf_1_66.X sg13cmos5l_o21ai_1_9.B1 VDD.t19 sg13_lv_pmos ad=0.3808p pd=2.92u as=0.2128p ps=1.5u w=1.12u l=0.13u
X1637 VDD.t674 a_15610_9912# a_15329_10214# VDD.t52 sg13_lv_pmos ad=0.1523p pd=1.38u as=0.34p ps=2.68u w=1u l=0.5u
X1638 VDD.t464 VSS.t291 VDD.t463 VDD.t13 sg13_lv_pmos ad=0.34p pd=2.68u as=0 ps=0 w=1u l=1u
X1639 a_22522_9154# sg13cmos5l_dlygate4sd3_1_20.A VSS.t342 VSS.t341 sg13_lv_nmos ad=0.1428p pd=1.52u as=79.8f ps=0.8u w=0.42u l=0.13u
X1640 a_18574_14751# a_18689_14750# VSS.t393 VSS.t432 sg13_lv_nmos ad=0.1428p pd=1.52u as=0.1426p ps=1.16u w=0.42u l=0.5u
X1641 VSS.t192 sg13cmos5l_a21oi_1_2.B1 sg13cmos5l_a21oi_1_2.Y VSS.t894 sg13_lv_nmos ad=0.2516p pd=2.16u as=0.1406p ps=1.12u w=0.74u l=0.13u
X1642 a_8006_7678# a_7736_7678# VSS.t812 VSS.t2515 sg13_lv_nmos ad=0.1428p pd=1.52u as=79.8f ps=0.8u w=0.42u l=0.5u
X1643 a_15503_19847# a_14661_19749# a_14244_20088# VDD.t270 sg13_lv_pmos ad=0.2048p pd=1.63u as=0.34p ps=2.68u w=1u l=0.13u
X1644 VDD.t19 a_21839_13799# a_22096_13942# VDD.t19 sg13_lv_pmos ad=2.1916p pd=14.26u as=79.8f ps=0.8u w=0.42u l=0.13u
X1645 VSS.t169 a_14661_19749# a_14763_19892# VSS.t168 sg13_lv_nmos ad=3.91182p pd=24.955u as=0.2516p ps=2.16u w=0.74u l=0.13u
X1646 a_3532_16434# a_3319_15960# VDD.t16 VDD.t16 sg13_lv_pmos ad=79.8f pd=0.8u as=2.07625p ps=13.51u w=0.42u l=0.13u
X1647 a_13764_16000# a_14283_16007# a_15023_16357# VSS.t736 sg13_lv_nmos ad=0.3473p pd=2.71u as=0.12665p ps=1.145u w=0.74u l=0.13u
X1648 VDD.t347 VSS.t1660 VDD.t346 VDD.t19 sg13_lv_pmos ad=0.19p pd=1.38u as=0 ps=0 w=1u l=1u
X1649 a_16356_5416# a_16875_5423# a_17615_5773# VSS.t38 sg13_lv_nmos ad=0.3473p pd=2.71u as=0.12665p ps=1.145u w=0.74u l=0.13u
X1650 a_7378_16374# sg13cmos5l_o21ai_1_8.B1 sg13cmos5l_o21ai_1_11.A2 VSS.t1184 sg13_lv_nmos ad=0.1406p pd=1.12u as=0.2516p ps=2.16u w=0.74u l=0.15u
X1651 a_20580_9952# a_20554_9916# VSS.t596 VSS.t823 sg13_lv_nmos ad=0.2516p pd=2.16u as=0.1626p ps=1.415u w=0.74u l=0.13u
X1652 VSS.t232 sg13cmos5l_a21oi_1_2.B1 sg13cmos5l_a21oi_1_15.Y VSS.t898 sg13_lv_nmos ad=0.2516p pd=2.16u as=0.1406p ps=1.12u w=0.74u l=0.13u
X1653 VSS.t161 sg13cmos5l_inv_1_16.A sg13cmos5l_inv_1_16.Y VSS.t160 sg13_lv_nmos ad=0.2516p pd=2.16u as=0.2516p ps=2.16u w=0.74u l=0.13u
X1654 sg13cmos5l_nand3_1_4.Y sg13cmos5l_dfrbpq_1_15.Q a_9368_7682# VSS.t777 sg13_lv_nmos ad=0.2516p pd=2.16u as=0.1406p ps=1.12u w=0.74u l=0.13u
X1655 VSS.t163 a_21839_13799# a_22506_14020# VSS.t213 sg13_lv_nmos ad=0.1406p pd=1.12u as=0.2516p ps=2.16u w=0.74u l=0.13u
X1656 sg13cmos5l_nor3_1_0.Y sg13cmos5l_a22oi_1_0.B2 VSS.t120 VSS.t765 sg13_lv_nmos ad=0.1694p pd=1.21u as=0.1463p ps=1.15u w=0.77u l=0.13u
X1657 a_18490_9154# sg13cmos5l_nand3_1_0.Y VDD.t653 VDD.t52 sg13_lv_pmos ad=0.1428p pd=1.52u as=0.1523p ps=1.38u w=0.42u l=0.13u
X1658 a_19923_8784# sg13cmos5l_a21oi_1_6.A2 VSS.t83 VSS.t1225 sg13_lv_nmos ad=0.1406p pd=1.12u as=0.2516p ps=2.16u w=0.74u l=0.13u
X1659 a_12496_18478# a_12239_18335# a_12658_18258# VSS.t1152 sg13_lv_nmos ad=0.1428p pd=1.52u as=37.8f ps=0.6u w=0.42u l=0.13u
X1660 a_14746_9912# sg13cmos5l_a22oi_1_0.B2 VSS.t120 VSS.t766 sg13_lv_nmos ad=0.1428p pd=1.52u as=79.8f ps=0.8u w=0.42u l=0.13u
X1661 a_22258_10386# sg13cmos5l_buf_1_13.X VSS.t76 VSS.t546 sg13_lv_nmos ad=37.8f pd=0.6u as=79.8f ps=0.8u w=0.42u l=0.13u
X1662 sg13cmos5l_a21oi_1_19.A2 sg13cmos5l_buf_1_43.X VDD.t748 VDD.t16 sg13_lv_pmos ad=0.2128p pd=1.5u as=0.2128p ps=1.5u w=1.12u l=0.13u
X1663 a_7065_13095# a_6123_12983# a_6863_13333# VDD.t83 sg13_lv_pmos ad=93.45f pd=0.865u as=0.2048p ps=1.63u w=0.42u l=0.13u
X1664 a_9734_17508# a_9464_17549# VDD.t396 VDD.t310 sg13_lv_pmos ad=0.34p pd=2.68u as=0.1523p ps=1.38u w=1u l=0.5u
X1665 a_14902_8814# sg13cmos5l_o21ai_1_3.A2 VSS.t97 VSS.t795 sg13_lv_nmos ad=0.1406p pd=1.12u as=0.1406p ps=1.12u w=0.74u l=0.15u
X1666 a_15023_17869# a_14181_17519# a_14929_17869# VSS.t629 sg13_lv_nmos ad=0.12665p pd=1.145u as=0.1428p ps=1.52u w=0.42u l=0.13u
X1667 VDD.t816 sg13cmos5l_buf_1_54.A a_14920_14484# VDD.t19 sg13_lv_pmos ad=0.2114p pd=1.54u as=0.2856p ps=2.36u w=0.84u l=0.13u
X1668 VSS.t153 a_14446_11727# sg13cmos5l_nand3b_1_0.C VSS.t1029 sg13_lv_nmos ad=0.1426p pd=1.16u as=0.2516p ps=2.16u w=0.74u l=0.13u
X1669 a_10726_10373# sg13cmos5l_dfrbpq_1_13.RESET_B VSS.t740 VSS.t1213 sg13_lv_nmos ad=37.8f pd=0.6u as=0.1701p ps=1.65u w=0.42u l=0.13u
X1670 VSS.t1628 VDD.t2553 VSS.t1630 VSS.t1629 sg13_lv_nmos ad=79.8f pd=0.8u as=0 ps=0 w=0.42u l=1u
X1671 VDD.t0 a_19120_11702# a_19065_11583# VDD.t0 sg13_lv_pmos ad=2.1916p pd=14.26u as=93.45f ps=0.865u w=0.42u l=0.13u
X1672 VSS.t569 sg13cmos5l_nor4_1_0.Y a_12632_8477# VSS.t876 sg13_lv_nmos ad=79.8f pd=0.8u as=0.1428p ps=1.52u w=0.42u l=0.13u
X1673 VDD.t16 sg13cmos5l_dfrbpq_1_19.CLK a_4031_15967# VDD.t16 sg13_lv_pmos ad=2.07625p pd=13.51u as=0.4088p ps=2.97u w=1.12u l=0.13u
X1674 a_19342_10215# a_19457_10214# VSS.t161 VSS.t1082 sg13_lv_nmos ad=0.1428p pd=1.52u as=0.1426p ps=1.16u w=0.42u l=0.5u
X1675 VDD.t1342 sg13cmos5l_buf_1_57.A a_13384_14484# VDD.t19 sg13_lv_pmos ad=0.2114p pd=1.54u as=0.2856p ps=2.36u w=0.84u l=0.13u
X1676 VSS.t74 sg13cmos5l_mux2_1_0.S a_7804_12214# VSS.t2254 sg13_lv_nmos ad=0.18945p pd=1.27u as=0.13135p ps=1.095u w=0.74u l=0.13u
X1677 a_18874_9912# sg13cmos5l_dlygate4sd3_1_18.A VDD.t1006 VDD.t52 sg13_lv_pmos ad=0.1428p pd=1.52u as=0.1523p ps=1.38u w=0.42u l=0.13u
X1678 sg13cmos5l_nand2_1_3.Y sg13cmos5l_nor2_1_2.A a_6394_7294# VSS.t289 sg13_lv_nmos ad=0.2516p pd=2.16u as=0.1406p ps=1.12u w=0.74u l=0.13u
X1679 VDD.t2173 a_7354_19738# a_7073_19960# VDD.t270 sg13_lv_pmos ad=0.1523p pd=1.38u as=0.34p ps=2.68u w=1u l=0.5u
X1680 a_16474_18984# sg13cmos5l_a21oi_1_26.Y VDD.t798 VDD.t231 sg13_lv_pmos ad=0.1428p pd=1.52u as=0.1523p ps=1.38u w=0.42u l=0.13u
X1681 VSS.t1649 VDD.t2549 VSS.t1648 VSS.t1641 sg13_lv_nmos ad=0.1428p pd=1.52u as=0 ps=0 w=0.42u l=1u
X1682 a_9018_15532# sg13cmos5l_a21oi_1_12.A2 sg13cmos5l_nand2_1_11.B VDD.t16 sg13_lv_pmos ad=0.1428p pd=1.375u as=0.2408p ps=1.55u w=1.12u l=0.13u
X1683 VSS.t83 a_18490_9154# a_18209_9376# VSS.t82 sg13_lv_nmos ad=79.8f pd=0.8u as=0.1428p ps=1.52u w=0.42u l=0.5u
X1684 a_6470_11898# sg13cmos5l_dfrbpq_1_45.D VDD.t1091 VDD.t0 sg13_lv_pmos ad=79.8f pd=0.8u as=0.1428p ps=1.52u w=0.42u l=0.13u
X1685 sg13cmos5l_a21o_1_0.A2 sg13cmos5l_nor3_1_2.B a_10774_10694# VSS.t548 sg13_lv_nmos ad=0.2516p pd=2.16u as=0.1406p ps=1.12u w=0.74u l=0.15u
X1686 VDD.t114 VSS.t2005 VDD.t113 VDD.t5 sg13_lv_pmos ad=0.34p pd=2.68u as=0 ps=0 w=1u l=1u
X1687 a_8985_19143# a_8043_19031# a_8783_19381# VDD.t231 sg13_lv_pmos ad=93.45f pd=0.865u as=0.2048p ps=1.63u w=0.42u l=0.13u
X1688 a_13958_19770# a_14763_19892# a_14218_19993# VDD.t270 sg13_lv_pmos ad=0.1428p pd=1.52u as=79.8f ps=0.8u w=0.42u l=0.13u
X1689 VDD.t18 VSS.t653 VDD.t17 VDD.t16 sg13_lv_pmos ad=0.34p pd=2.68u as=0 ps=0 w=1u l=1u
X1690 VSS.t1365 a_20997_13701# a_21099_13844# VSS.t1364 sg13_lv_nmos ad=6.29922p pd=42.355u as=0.2516p ps=2.16u w=0.74u l=0.13u
X1691 a_7120_13214# a_6863_13333# a_7282_13410# VSS.t149 sg13_lv_nmos ad=0.1428p pd=1.52u as=37.8f ps=0.6u w=0.42u l=0.13u
X1692 VSS.t67 a_6863_13333# a_7530_12972# VSS.t149 sg13_lv_nmos ad=0.1406p pd=1.12u as=0.2516p ps=2.16u w=0.74u l=0.13u
X1693 VDD.t600 VSS.t1973 VDD.t599 VDD.t5 sg13_lv_pmos ad=0.34p pd=2.68u as=0 ps=0 w=1u l=1u
X1694 VDD.t1043 sg13cmos5l_buf_1_13.X a_17290_8404# VDD.t8 sg13_lv_pmos ad=0.1563p pd=1.22u as=0.147p ps=1.54u w=0.42u l=0.13u
X1695 VSS.t674 a_14181_16007# a_14283_16007# VSS.t1500 sg13_lv_nmos ad=4.4216p pd=27.885u as=0.2516p ps=2.16u w=0.74u l=0.13u
X1696 VDD.t103 VSS.t2002 VDD.t102 VDD.t13 sg13_lv_pmos ad=0.34p pd=2.68u as=0 ps=0 w=1u l=1u
X1697 a_16185_6477# a_15243_6284# a_15983_6239# VDD.t2 sg13_lv_pmos ad=93.45f pd=0.865u as=0.2048p ps=1.63u w=0.42u l=0.13u
X1698 VDD.t2 a_20997_6935# a_21099_6935# VDD.t2 sg13_lv_pmos ad=2.1916p pd=14.26u as=0.3864p ps=2.93u w=1.12u l=0.13u
X1699 VDD.t2311 sg13cmos5l_dfrbpq_1_13.Q a_11678_7972# VDD.t8 sg13_lv_pmos ad=0.3808p pd=2.92u as=0.2128p ps=1.5u w=1.12u l=0.13u
X1700 sg13cmos5l_dfrbpq_1_39.Q a_20682_17508# VDD.t1377 VDD.t310 sg13_lv_pmos ad=0.3808p pd=2.92u as=0.2128p ps=1.5u w=1.12u l=0.13u
X1701 VDD.t784 sg13cmos5l_nor3_1_2.A a_7750_9508# VDD.t52 sg13_lv_pmos ad=0.19p pd=1.38u as=0.2125p ps=1.425u w=1u l=0.13u
X1702 a_10809_5535# a_9867_5423# a_10607_5773# VDD.t5 sg13_lv_pmos ad=93.45f pd=0.865u as=0.2048p ps=1.63u w=0.42u l=0.13u
X1703 VDD.t231 a_16197_18237# a_16299_18380# VDD.t231 sg13_lv_pmos ad=1.54512p pd=9.865u as=0.3864p ps=2.93u w=1.12u l=0.13u
X1704 VDD.t270 a_15760_19990# a_15705_20085# VDD.t270 sg13_lv_pmos ad=2.69447p pd=17.64u as=93.45f ps=0.865u w=0.42u l=0.13u
X1705 a_19066_15960# sg13cmos5l_dlygate4sd3_1_72.A VDD.t1127 VDD.t16 sg13_lv_pmos ad=0.1428p pd=1.52u as=0.1523p ps=1.38u w=0.42u l=0.13u
X1706 sg13cmos5l_o21ai_1_24.Y sg13cmos5l_buf_1_59.A a_12694_16742# VSS.t625 sg13_lv_nmos ad=0.2516p pd=2.16u as=0.1406p ps=1.12u w=0.74u l=0.15u
X1707 VDD.t1102 a_22005_16904# a_21084_16710# VDD.t310 sg13_lv_pmos ad=0.36237p pd=2.605u as=0.34p ps=2.68u w=1u l=0.13u
X1708 a_10787_12972# sg13cmos5l_dfrbpq_1_24.Q a_10685_12972# VDD.t83 sg13_lv_pmos ad=0.2464p pd=1.56u as=0.2128p ps=1.5u w=1.12u l=0.13u
X1709 a_20794_12936# sg13cmos5l_dlygate4sd3_1_76.A VDD.t1028 VDD.t83 sg13_lv_pmos ad=0.1428p pd=1.52u as=0.1523p ps=1.38u w=0.42u l=0.13u
X1710 a_10811_4948# sg13cmos5l_a21oi_1_9.B1 sg13cmos5l_a21oi_1_9.Y VDD.t5 sg13_lv_pmos ad=0.2128p pd=1.5u as=0.3808p ps=2.92u w=1.12u l=0.13u
X1711 a_16836_20088# a_17355_19892# a_18095_19847# VSS.t2430 sg13_lv_nmos ad=0.3473p pd=2.71u as=0.12665p ps=1.145u w=0.74u l=0.13u
X1712 VDD.t68 VSS.t1987 VDD.t67 VDD.t13 sg13_lv_pmos ad=0.34p pd=2.68u as=0 ps=0 w=1u l=1u
X1713 a_6873_7989# a_5931_7796# a_6671_7751# VDD.t8 sg13_lv_pmos ad=93.45f pd=0.865u as=0.2048p ps=1.63u w=0.42u l=0.13u
X1714 VDD.t421 VSS.t1739 VDD.t287 VDD.t0 sg13_lv_pmos ad=0.19p pd=1.38u as=0 ps=0 w=1u l=1u
X1715 VDD.t2286 sg13cmos5l_buf_1_8.A sg13cmos5l_inv_1_14.Y VDD.t13 sg13_lv_pmos ad=0.3808p pd=2.92u as=0.3808p ps=2.92u w=1.12u l=0.13u
X1716 a_4740_14488# a_4714_14452# VSS.t585 VSS.t1560 sg13_lv_nmos ad=0.2516p pd=2.16u as=0.1626p ps=1.415u w=0.74u l=0.13u
X1717 a_7334_14484# a_7064_14525# VDD.t717 VDD.t19 sg13_lv_pmos ad=0.34p pd=2.68u as=0.1523p ps=1.38u w=1u l=0.5u
X1718 a_20554_14452# a_20997_14495# a_20294_14922# VSS.t1540 sg13_lv_nmos ad=79.8f pd=0.8u as=0.1296p ps=1.52u w=0.42u l=0.13u
X1719 VDD.t649 a_21934_10887# sg13cmos5l_dfrbpq_1_7.D VDD.t0 sg13_lv_pmos ad=0.2254p pd=1.53u as=0.4256p ps=3u w=1.12u l=0.13u
X1720 a_6470_11898# a_7275_11471# a_6730_11428# VDD.t0 sg13_lv_pmos ad=0.1428p pd=1.52u as=79.8f ps=0.8u w=0.42u l=0.13u
X1721 VSS.t479 a_21358_5679# sg13cmos5l_dfrbpq_1_0.D VSS.t10 sg13_lv_nmos ad=0.1426p pd=1.16u as=0.2516p ps=2.16u w=0.74u l=0.13u
X1722 a_15597_12256# sg13cmos5l_nand3_1_2.A VDD.t1711 VDD.t83 sg13_lv_pmos ad=0.1596p pd=1.22u as=0.2856p ps=2.36u w=0.84u l=0.13u
X1723 a_15104_7849# a_15223_7638# VDD.t661 VDD.t8 sg13_lv_pmos ad=0.3864p pd=2.93u as=0.2128p ps=1.5u w=1.12u l=0.13u
X1724 a_11474_7972# sg13cmos5l_nand2b_1_3.Y sg13cmos5l_nor4_1_0.Y VDD.t8 sg13_lv_pmos ad=0.2128p pd=1.5u as=0.4368p ps=3.02u w=1.12u l=0.13u
X1725 a_7362_8802# sg13cmos5l_nand4_1_0.C a_7260_8802# VSS.t1003 sg13_lv_nmos ad=0.1406p pd=1.12u as=0.1406p ps=1.12u w=0.74u l=0.13u
X1726 a_14136_17064# sg13cmos5l_buf_1_47.X VDD.t1650 VDD.t310 sg13_lv_pmos ad=0.2128p pd=1.5u as=0.3808p ps=2.92u w=1.12u l=0.15u
X1727 a_5626_19738# sg13cmos5l_dfrbpq_1_20.Q VSS.t369 VSS.t2471 sg13_lv_nmos ad=0.1428p pd=1.52u as=79.8f ps=0.8u w=0.42u l=0.13u
X1728 VSS.t46 sg13cmos5l_a21oi_1_12.A2 a_8879_15238# VSS.t322 sg13_lv_nmos ad=0.1898p pd=1.36u as=0.1406p ps=1.12u w=0.74u l=0.13u
X1729 a_20580_4968# a_20554_4873# VDD.t375 VDD.t5 sg13_lv_pmos ad=0.34p pd=2.68u as=0.36237p ps=2.605u w=1u l=0.13u
X1730 VSS.t2005 VDD.t2402 VSS.t2005 VSS.t2057 sg13_lv_nmos ad=0.1428p pd=1.52u as=0 ps=0 w=0.42u l=1u
X1731 sg13cmos5l_nor2_1_15.Y sg13cmos5l_o21ai_1_5.A1 VSS.t52 VSS.t982 sg13_lv_nmos ad=0.1406p pd=1.12u as=0.2516p ps=2.16u w=0.74u l=0.13u
X1732 sg13cmos5l_buf_1_2.A a_20406_6230# VDD.t1011 VDD.t2 sg13_lv_pmos ad=0.4256p pd=3u as=0.2254p ps=1.53u w=1.12u l=0.13u
X1733 VSS.t1623 VDD.t2558 VSS.t1625 VSS.t1624 sg13_lv_nmos ad=79.8f pd=0.8u as=0 ps=0 w=0.42u l=1u
X1734 VSS.t674 sg13cmos5l_dfrbpq_1_5.CLK a_21215_15967# VSS.t1564 sg13_lv_nmos ad=4.4216p pd=27.885u as=0.2516p ps=2.16u w=0.74u l=0.13u
X1735 a_8337_13362# sg13cmos5l_mux2_1_1.A1 VDD.t933 VDD.t83 sg13_lv_pmos ad=0.1848p pd=1.28u as=0.1596p ps=1.22u w=0.84u l=0.13u
X1736 a_16838_9948# a_16568_9989# VDD.t1942 VDD.t52 sg13_lv_pmos ad=0.34p pd=2.68u as=0.1523p ps=1.38u w=1u l=0.5u
X1737 a_15480_8752# sg13cmos5l_a22oi_1_2.Y a_15622_8412# VDD.t8 sg13_lv_pmos ad=0.2856p pd=2.36u as=0.1596p ps=1.22u w=0.84u l=0.13u
X1738 sg13cmos5l_a21oi_1_13.Y sg13cmos5l_inv_1_17.Y a_19923_13748# VSS.t128 sg13_lv_nmos ad=0.1406p pd=1.12u as=0.1406p ps=1.12u w=0.74u l=0.13u
X1739 sg13cmos5l_a21oi_1_5.A2 sg13cmos5l_nand4_1_18.A a_18398_13338# VSS.t128 sg13_lv_nmos ad=0.2516p pd=2.16u as=0.1406p ps=1.12u w=0.74u l=0.13u
X1740 a_20997_11471# sg13cmos5l_dfrbpq_1_5.CLK VDD.t0 VDD.t0 sg13_lv_pmos ad=0.4088p pd=2.97u as=2.07625p ps=13.51u w=1.12u l=0.13u
X1741 a_15197_10996# sg13cmos5l_inv_1_18.A sg13cmos5l_nor3_1_0.Y VDD.t0 sg13_lv_pmos ad=0.2128p pd=1.5u as=0.3808p ps=2.92u w=1.12u l=0.13u
X1742 VSS.t1926 VDD.t2445 VSS.t1925 VSS.t1924 sg13_lv_nmos ad=0.1428p pd=1.52u as=0 ps=0 w=0.42u l=1u
X1743 a_6766_7191# a_6881_7190# VDD.t2026 VDD.t2 sg13_lv_pmos ad=0.34p pd=2.68u as=0.2254p ps=1.53u w=1u l=0.5u
X1744 VDD.t312 VSS.t1617 VDD.t311 VDD.t310 sg13_lv_pmos ad=0.34p pd=2.68u as=0 ps=0 w=1u l=1u
X1745 VDD.t1510 a_4917_16904# a_3996_16710# VDD.t310 sg13_lv_pmos ad=0.36237p pd=2.605u as=0.34p ps=2.68u w=1u l=0.13u
X1746 a_10053_12189# sg13cmos5l_dfrbpq_1_13.CLK VDD.t83 VDD.t83 sg13_lv_pmos ad=0.4088p pd=2.97u as=2.51485p ps=16.46u w=1.12u l=0.13u
X1747 VSS.t67 sg13cmos5l_mux2_1_0.S a_9147_13028# VSS.t149 sg13_lv_nmos ad=0.14505p pd=1.15u as=0.187p ps=1.78u w=0.55u l=0.13u
X1748 a_20388_11898# sg13cmos5l_dlygate4sd3_1_71.X a_20294_11898# VSS.t178 sg13_lv_nmos ad=60.89999f pd=0.71u as=0.1428p ps=1.52u w=0.42u l=0.13u
X1749 VDD.t42 VSS.t1973 VDD.t621 VDD.t13 sg13_lv_pmos ad=0.34p pd=2.68u as=0 ps=0 w=1u l=1u
X1750 VDD.t1125 a_6671_7751# a_7338_7972# VDD.t8 sg13_lv_pmos ad=0.2128p pd=1.5u as=0.3864p ps=2.93u w=1.12u l=0.13u
X1751 VDD.t231 a_20272_19262# a_20217_19143# VDD.t231 sg13_lv_pmos ad=1.54512p pd=9.865u as=93.45f ps=0.865u w=0.42u l=0.13u
X1752 VSS.t201 sg13cmos5l_buf_1_54.A a_14920_14484# VSS.t1508 sg13_lv_nmos ad=0.14875p pd=1.16u as=0.187p ps=1.78u w=0.55u l=0.13u
X1753 VSS.t291 VDD.t2428 VSS.t291 VSS.t1991 sg13_lv_nmos ad=0.1428p pd=1.52u as=0 ps=0 w=0.42u l=1u
X1754 a_16283_17508# sg13cmos5l_a21oi_1_18.B1 sg13cmos5l_a21oi_1_26.Y VDD.t310 sg13_lv_pmos ad=0.2128p pd=1.5u as=0.3808p ps=2.92u w=1.12u l=0.13u
X1755 a_7742_12508# sg13cmos5l_a21oi_1_4.A1 a_7310_12400# VDD.t83 sg13_lv_pmos ad=0.3325p pd=1.665u as=0.2225p ps=1.445u w=1u l=0.13u
X1756 VDD.t1159 a_11278_6351# sg13cmos5l_a21oi_1_9.B1 VDD.t2 sg13_lv_pmos ad=0.2254p pd=1.53u as=0.4256p ps=3u w=1.12u l=0.13u
X1757 VSS.t969 sg13cmos5l_buf_1_57.A a_13384_14484# VSS.t968 sg13_lv_nmos ad=0.14875p pd=1.16u as=0.187p ps=1.78u w=0.55u l=0.13u
X1758 a_21839_14845# a_20997_14495# a_20580_14488# VDD.t19 sg13_lv_pmos ad=0.2048p pd=1.63u as=0.34p ps=2.68u w=1u l=0.13u
X1759 sg13cmos5l_dlygate4sd3_1_3.A a_22506_6924# VDD.t1290 VDD.t2 sg13_lv_pmos ad=0.3808p pd=2.92u as=0.2128p ps=1.5u w=1.12u l=0.13u
X1760 a_19077_10677# sg13cmos5l_dfrbpq_1_5.CLK VSS.t266 VSS.t590 sg13_lv_nmos ad=0.2516p pd=2.16u as=4.90217p ps=31.68u w=0.74u l=0.13u
X1761 VDD.t1564 a_7989_6320# a_7068_6126# VDD.t2 sg13_lv_pmos ad=0.36237p pd=2.605u as=0.34p ps=2.68u w=1u l=0.13u
X1762 VDD.t1549 sg13cmos5l_a21oi_1_16.A2 a_17429_12508# VDD.t83 sg13_lv_pmos ad=0.2128p pd=1.5u as=0.3808p ps=2.92u w=1.12u l=0.13u
X1763 VSS.t2 a_10053_12189# a_10155_12332# VSS.t156 sg13_lv_nmos ad=4.7455p pd=30.71u as=0.2516p ps=2.16u w=0.74u l=0.13u
X1764 a_13298_10706# sg13cmos5l_nor3_1_2.B VSS.t86 VSS.t550 sg13_lv_nmos ad=0.1406p pd=1.12u as=0.2886p ps=2.26u w=0.74u l=0.13u
X1765 VSS.t22 a_22126_4167# sg13cmos5l_inv_1_7.A VSS.t193 sg13_lv_nmos ad=0.1426p pd=1.16u as=0.2516p ps=2.16u w=0.74u l=0.13u
X1766 a_10474_9916# a_10917_9959# a_10214_10386# VSS.t605 sg13_lv_nmos ad=79.8f pd=0.8u as=0.1296p ps=1.52u w=0.42u l=0.13u
X1767 VSS.t1208 VDD.t2478 VSS.t1852 VSS.t1851 sg13_lv_nmos ad=79.8f pd=0.8u as=0 ps=0 w=0.42u l=1u
X1768 VSS.t113 a_14218_18226# sg13cmos5l_dfrbpq_1_41.CLK VSS.t1428 sg13_lv_nmos ad=0.1406p pd=1.12u as=0.1406p ps=1.12u w=0.74u l=0.13u
X1769 VDD.t731 sg13cmos5l_buf_1_1.A sg13cmos5l_inv_1_13.Y VDD.t52 sg13_lv_pmos ad=0.3808p pd=2.92u as=0.3808p ps=2.92u w=1.12u l=0.13u
X1770 VDD.t551 VSS.t1966 VDD.t550 VDD.t5 sg13_lv_pmos ad=0.34p pd=2.68u as=0 ps=0 w=1u l=1u
X1771 VDD.t1488 a_21370_19738# a_21089_19960# VDD.t270 sg13_lv_pmos ad=0.1523p pd=1.38u as=0.34p ps=2.68u w=1u l=0.5u
X1772 a_21084_18222# a_21215_18528# a_20503_18222# VDD.t231 sg13_lv_pmos ad=0.34p pd=2.68u as=0.2048p ps=1.63u w=1u l=0.13u
X1773 VDD.t701 sg13cmos5l_inv_1_16.A sg13cmos5l_inv_1_16.Y VDD.t0 sg13_lv_pmos ad=0.3808p pd=2.92u as=0.3808p ps=2.92u w=1.12u l=0.13u
X1774 VDD.t126 VSS.t291 VDD.t471 VDD.t13 sg13_lv_pmos ad=0.34p pd=2.68u as=0 ps=0 w=1u l=1u
X1775 VSS.t222 a_16558_11727# sg13cmos5l_nand3_1_0.B VSS.t614 sg13_lv_nmos ad=0.1426p pd=1.16u as=0.2516p ps=2.16u w=0.74u l=0.13u
X1776 VDD.t5 a_10607_5773# a_10864_5654# VDD.t5 sg13_lv_pmos ad=1.96072p pd=12.69u as=79.8f ps=0.8u w=0.42u l=0.13u
X1777 VSS.t284 a_13390_7863# sg13cmos5l_and4_1_0.D VSS.t1087 sg13_lv_nmos ad=0.1426p pd=1.16u as=0.2516p ps=2.16u w=0.74u l=0.13u
X1778 a_9610_12433# a_10053_12189# a_9993_12601# VDD.t83 sg13_lv_pmos ad=79.8f pd=0.8u as=63f ps=0.72u w=0.42u l=0.13u
X1779 VDD.t321 VSS.t1627 VDD.t320 VDD.t231 sg13_lv_pmos ad=0.34p pd=2.68u as=0 ps=0 w=1u l=1u
X1780 VDD.t1062 sg13cmos5l_dfrbpq_1_28.RESET_B.t10 a_18470_17946# VDD.t310 sg13_lv_pmos ad=0.36237p pd=2.605u as=79.8f ps=0.8u w=0.42u l=0.13u
X1781 VSS.t1688 VDD.t2534 VSS.t1687 VSS.t1686 sg13_lv_nmos ad=0.1428p pd=1.52u as=0 ps=0 w=0.42u l=1u
X1782 a_20997_4629# sg13cmos5l_inv_1_2.A VDD.t5 VDD.t5 sg13_lv_pmos ad=0.4088p pd=2.97u as=1.8716p ps=12.115u w=1.12u l=0.13u
X1783 a_18778_6130# sg13cmos5l_dlygate4sd3_1_29.A VSS.t11 VSS.t2197 sg13_lv_nmos ad=0.1428p pd=1.52u as=79.8f ps=0.8u w=0.42u l=0.13u
X1784 a_10878_7180# sg13cmos5l_a21oi_1_9.A2 VDD.t2095 VDD.t2 sg13_lv_pmos ad=0.1596p pd=1.22u as=0.1596p ps=1.22u w=0.84u l=0.13u
X1785 VDD.t135 VSS.t1999 VDD.t125 VDD.t5 sg13_lv_pmos ad=0.19p pd=1.38u as=0 ps=0 w=1u l=1u
X1786 a_20176_7894# a_19919_7751# a_20338_7674# VSS.t2296 sg13_lv_nmos ad=0.1428p pd=1.52u as=37.8f ps=0.6u w=0.42u l=0.13u
X1787 a_13676_12936# sg13cmos5l_buf_1_15.A.t2 VSS.t150 VSS.t149 sg13_lv_nmos ad=0.187p pd=1.78u as=0.14875p ps=1.16u w=0.55u l=0.13u
X1788 VSS.t1885 VDD.t2462 VSS.t542 VSS.t1898 sg13_lv_nmos ad=79.8f pd=0.8u as=0 ps=0 w=0.42u l=1u
X1789 a_5998_13911# a_6113_13912# VSS.t182 VSS.t1229 sg13_lv_nmos ad=0.1428p pd=1.52u as=0.1426p ps=1.16u w=0.42u l=0.5u
X1790 a_9081_10071# a_8139_9959# a_8879_10309# VDD.t52 sg13_lv_pmos ad=93.45f pd=0.865u as=0.2048p ps=1.63u w=0.42u l=0.13u
X1791 a_9562_9190# sg13cmos5l_nand2b_1_5.Y VSS.t190 VSS.t2606 sg13_lv_nmos ad=0.1406p pd=1.12u as=0.2516p ps=2.16u w=0.74u l=0.13u
X1792 VSS.t1053 a_8006_7678# a_8118_7742# VSS.t2350 sg13_lv_nmos ad=0.1426p pd=1.16u as=0.1428p ps=1.52u w=0.42u l=0.5u
X1793 VSS.t232 sg13cmos5l_a21oi_1_2.B1 sg13cmos5l_dlygate4sd3_1_18.A VSS.t897 sg13_lv_nmos ad=0.2516p pd=2.16u as=0.1406p ps=1.12u w=0.74u l=0.13u
X1794 a_18660_11016# a_18634_10921# VSS.t161 VSS.t589 sg13_lv_nmos ad=0.2516p pd=2.16u as=0.1626p ps=1.415u w=0.74u l=0.13u
X1795 a_22005_16904# a_21063_16964# a_21866_16904# VSS.t647 sg13_lv_nmos ad=79.8f pd=0.8u as=0.2373p ps=1.97u w=0.42u l=0.13u
X1796 VDD.t927 sg13cmos5l_o21ai_1_21.B1 a_4360_19808# VDD.t270 sg13_lv_pmos ad=0.2114p pd=1.54u as=0.2856p ps=2.36u w=0.84u l=0.13u
X1797 VSS.t242 sg13cmos5l_dfrbpq_1_19.CLK a_4607_18528# VSS.t2472 sg13_lv_nmos ad=4.1963p pd=27.415u as=0.2516p ps=2.16u w=0.74u l=0.13u
X1798 sg13cmos5l_nand4_1_7.B a_10833_14874# VSS.t199 VSS.t310 sg13_lv_nmos ad=0.3552p pd=2.44u as=0.1447p ps=1.15u w=0.74u l=0.13u
X1799 VSS.t362 VDD.t2488 VSS.t362 VSS.t1826 sg13_lv_nmos ad=0.1428p pd=1.52u as=0 ps=0 w=0.42u l=1u
X1800 a_8122_8400# sg13cmos5l_or4_1_0.D VSS.t190 VSS.t1580 sg13_lv_nmos ad=0.1428p pd=1.52u as=79.8f ps=0.8u w=0.42u l=0.13u
X1801 VSS.t1083 a_19738_9912# a_19457_10214# VSS.t1082 sg13_lv_nmos ad=79.8f pd=0.8u as=0.1428p ps=1.52u w=0.42u l=0.5u
X1802 a_5349_19031# sg13cmos5l_dfrbpq_1_19.CLK VSS.t169 VSS.t2474 sg13_lv_nmos ad=0.2516p pd=2.16u as=3.5562p ps=22.685u w=0.74u l=0.13u
X1803 VDD.t107 VSS.t2002 VDD.t106 VDD.t13 sg13_lv_pmos ad=0.34p pd=2.68u as=0 ps=0 w=1u l=1u
X1804 VSS.t293 sg13cmos5l_nor2_1_2.Y sg13cmos5l_a21oi_1_8.Y VSS.t2500 sg13_lv_nmos ad=0.2516p pd=2.16u as=0.1406p ps=1.12u w=0.74u l=0.13u
X1805 VDD.t919 a_19035_16750# sg13cmos5l_inv_1_31.A VDD.t310 sg13_lv_pmos ad=0.3864p pd=2.93u as=0.2128p ps=1.5u w=1.12u l=0.13u
X1806 a_20806_12223# sg13cmos5l_dfrbpq_1_28.RESET_B.t2 VSS.t9 VSS.t32 sg13_lv_nmos ad=37.8f pd=0.6u as=0.1701p ps=1.65u w=0.42u l=0.13u
X1807 a_19120_11702# a_18863_11821# a_19282_11898# VSS.t404 sg13_lv_nmos ad=0.1428p pd=1.52u as=37.8f ps=0.6u w=0.42u l=0.13u
X1808 a_7620_9952# a_7594_9916# VSS.t362 VSS.t361 sg13_lv_nmos ad=0.2516p pd=2.16u as=0.1626p ps=1.415u w=0.74u l=0.13u
X1809 VSS.t1911 VDD.t2448 VSS.t1910 VSS.t1909 sg13_lv_nmos ad=0.1428p pd=1.52u as=0 ps=0 w=0.42u l=1u
X1810 a_6928_7894# sg13cmos5l_dfrbpq_1_13.RESET_B VDD.t8 VDD.t8 sg13_lv_pmos ad=79.8f pd=0.8u as=1.8716p ps=12.115u w=0.42u l=0.13u
X1811 sg13cmos5l_dfrbpq_1_19.CLK a_7498_18226# VDD.t2033 VDD.t231 sg13_lv_pmos ad=0.2128p pd=1.5u as=0.2128p ps=1.5u w=1.12u l=0.13u
X1812 sg13cmos5l_buf_1_16.A a_19048_12248# VSS.t7 VSS.t2618 sg13_lv_nmos ad=0.2886p pd=2.26u as=0.14875p ps=1.16u w=0.74u l=0.13u
X1813 a_17621_7972# sg13cmos5l_inv_1_3.Y VDD.t678 VDD.t8 sg13_lv_pmos ad=0.2128p pd=1.5u as=0.2128p ps=1.5u w=1.12u l=0.13u
X1814 VSS.t52 sg13cmos5l_buf_1_47.X a_12694_16742# VSS.t1293 sg13_lv_nmos ad=0.1406p pd=1.12u as=0.2516p ps=2.16u w=0.74u l=0.15u
X1815 a_21839_13799# a_20997_13701# a_21745_13799# VSS.t1366 sg13_lv_nmos ad=0.12665p pd=1.145u as=0.1428p ps=1.52u w=0.42u l=0.13u
X1816 VSS.t253 a_19077_7653# a_19179_7796# VSS.t2344 sg13_lv_nmos ad=4.7455p pd=30.71u as=0.2516p ps=2.16u w=0.74u l=0.13u
X1817 a_22042_15202# sg13cmos5l_dfrbpq_1_27.Q VSS.t72 VSS.t197 sg13_lv_nmos ad=0.1428p pd=1.52u as=79.8f ps=0.8u w=0.42u l=0.13u
X1818 a_21070_7863# a_21185_7864# VDD.t937 VDD.t8 sg13_lv_pmos ad=0.34p pd=2.68u as=0.2254p ps=1.53u w=1u l=0.5u
X1819 sg13cmos5l_dlygate4sd3_1_51.X a_4182_19044# VDD.t1490 VDD.t231 sg13_lv_pmos ad=0.4256p pd=3u as=0.2254p ps=1.53u w=1.12u l=0.13u
X1820 a_8444_17064# sg13cmos5l_nand3_1_5.Y sg13cmos5l_o21ai_1_14.Y VDD.t310 sg13_lv_pmos ad=0.2128p pd=1.5u as=0.2128p ps=1.5u w=1.12u l=0.15u
X1821 a_14423_14113# a_13727_13992# a_14517_13880# VSS.t1506 sg13_lv_nmos ad=0.1296p pd=1.52u as=79.8f ps=0.8u w=0.42u l=0.13u
X1822 a_12430_9375# a_12545_9376# VDD.t1014 VDD.t52 sg13_lv_pmos ad=0.34p pd=2.68u as=0.2254p ps=1.53u w=1u l=0.5u
X1823 VDD.t1009 sg13cmos5l_inv_1_0.A a_19048_3900# VDD.t13 sg13_lv_pmos ad=0.2114p pd=1.54u as=0.2856p ps=2.36u w=0.84u l=0.13u
X1824 sg13cmos5l_mux2_1_1.X a_8734_12214# VDD.t1052 VDD.t83 sg13_lv_pmos ad=0.6048p pd=3.32u as=0.2198p ps=1.52u w=1.12u l=0.13u
X1825 VDD.t0 a_18021_11471# a_18123_11471# VDD.t0 sg13_lv_pmos ad=2.1916p pd=14.26u as=0.3864p ps=2.93u w=1.12u l=0.13u
X1826 a_7858_16742# sg13cmos5l_dlygate4sd3_1_64.X sg13cmos5l_dlygate4sd3_1_62.A VSS.t998 sg13_lv_nmos ad=0.1406p pd=1.12u as=0.2516p ps=2.16u w=0.74u l=0.15u
X1827 VSS.t46 VDD.t2537 VSS.t46 VSS.t1678 sg13_lv_nmos ad=0.1428p pd=1.52u as=0 ps=0 w=0.42u l=1u
X1828 VDD.t1545 sg13cmos5l_nand4_1_1.C sg13cmos5l_a21oi_1_7.A2 VDD.t83 sg13_lv_pmos ad=0.2128p pd=1.5u as=0.2128p ps=1.5u w=1.12u l=0.13u
X1829 sg13cmos5l_dlygate4sd3_1_13.X a_17622_10766# VDD.t920 VDD.t0 sg13_lv_pmos ad=0.4256p pd=3u as=0.2254p ps=1.53u w=1.12u l=0.13u
X1830 a_9350_12210# sg13cmos5l_mux2_1_1.X VDD.t1913 VDD.t83 sg13_lv_pmos ad=79.8f pd=0.8u as=0.1428p ps=1.52u w=0.42u l=0.13u
X1831 VSS.t850 sg13cmos5l_buf_1_8.A sg13cmos5l_inv_1_14.Y VSS.t2542 sg13_lv_nmos ad=0.2516p pd=2.16u as=0.2516p ps=2.16u w=0.74u l=0.13u
X1832 VSS.t15 a_19995_9190# sg13cmos5l_inv_1_2.A VSS.t352 sg13_lv_nmos ad=0.1406p pd=1.12u as=0.1406p ps=1.12u w=0.74u l=0.13u
X1833 VDD.t1431 a_15503_19847# a_16170_20068# VDD.t270 sg13_lv_pmos ad=0.2128p pd=1.5u as=0.3864p ps=2.93u w=1.12u l=0.13u
X1834 a_6958_16935# a_7073_16936# VSS.t407 VSS.t1306 sg13_lv_nmos ad=0.1428p pd=1.52u as=0.1426p ps=1.16u w=0.42u l=0.5u
X1835 sg13cmos5l_inv_1_31.A a_19035_16750# VDD.t915 VDD.t310 sg13_lv_pmos ad=0.2128p pd=1.5u as=0.2128p ps=1.5u w=1.12u l=0.13u
X1836 a_15488_9361# a_15607_9150# VSS.t97 VSS.t2446 sg13_lv_nmos ad=0.2516p pd=2.16u as=0.1406p ps=1.12u w=0.74u l=0.13u
X1837 a_14181_17519# sg13cmos5l_dfrbpq_1_41.CLK VSS.t242 VSS.t669 sg13_lv_nmos ad=0.2516p pd=2.16u as=3.77667p ps=24.67u w=0.74u l=0.13u
X1838 VSS.t17 a_22096_12430# a_21745_12287# VSS.t16 sg13_lv_nmos ad=79.8f pd=0.8u as=0.1428p ps=1.52u w=0.42u l=0.13u
X1839 a_14842_11424# sg13cmos5l_nor2b_1_0.B_N VSS.t222 VSS.t956 sg13_lv_nmos ad=0.1428p pd=1.52u as=79.8f ps=0.8u w=0.42u l=0.13u
X1840 VDD.t1498 sg13cmos5l_dfrbpq_1_24.RESET_B a_4646_19458# VDD.t231 sg13_lv_pmos ad=0.36237p pd=2.605u as=79.8f ps=0.8u w=0.42u l=0.13u
X1841 VSS.t182 sg13cmos5l_mux2_1_0.A1 a_7214_13768# VSS.t66 sg13_lv_nmos ad=0.2176p pd=1.96u as=81.6f ps=0.895u w=0.64u l=0.13u
X1842 VSS.t2010 VDD.t2401 VSS.t2010 VSS.t2059 sg13_lv_nmos ad=0.1428p pd=1.52u as=0 ps=0 w=0.42u l=1u
X1843 a_11180_15198# sg13cmos5l_dfrbpq_1_18.Q VSS.t199 VSS.t977 sg13_lv_nmos ad=0.187p pd=1.78u as=0.14875p ps=1.16u w=0.55u l=0.13u
X1844 a_17342_13730# sg13cmos5l_nand4_1_7.B a_17240_13730# VSS.t128 sg13_lv_nmos ad=0.1406p pd=1.12u as=0.1406p ps=1.12u w=0.74u l=0.13u
X1845 a_17126_7362# a_17931_6935# a_17386_6892# VDD.t2 sg13_lv_pmos ad=0.1428p pd=1.52u as=79.8f ps=0.8u w=0.42u l=0.13u
X1846 VDD.t1140 a_4838_15238# a_4950_15302# VDD.t16 sg13_lv_pmos ad=0.2254p pd=1.53u as=0.34p ps=2.68u w=1u l=0.5u
X1847 a_16478_15242# sg13cmos5l_nand4_1_8.B a_16376_15242# VSS.t1487 sg13_lv_nmos ad=0.1406p pd=1.12u as=0.1406p ps=1.12u w=0.74u l=0.13u
X1848 a_20890_15202# sg13cmos5l_a21oi_1_13.Y VDD.t647 VDD.t16 sg13_lv_pmos ad=0.1428p pd=1.52u as=0.1523p ps=1.38u w=0.42u l=0.13u
X1849 a_21839_7285# a_20997_6935# a_21745_7285# VSS.t36 sg13_lv_nmos ad=0.12665p pd=1.145u as=0.1428p ps=1.52u w=0.42u l=0.13u
X1850 a_17124_19783# a_16836_20088# a_17062_19783# VSS.t166 sg13_lv_nmos ad=0.1428p pd=1.52u as=37.8f ps=0.6u w=0.42u l=0.13u
X1851 a_12134_19458# sg13cmos5l_dlygate4sd3_1_55.X VDD.t1523 VDD.t231 sg13_lv_pmos ad=79.8f pd=0.8u as=0.1428p ps=1.52u w=0.42u l=0.13u
X1852 VDD.t2353 sg13cmos5l_buf_8_2.A.t4 a_21531_13342# VDD.t83 sg13_lv_pmos ad=0.2128p pd=1.5u as=0.3808p ps=2.92u w=1.12u l=0.13u
X1853 a_16742_15234# sg13cmos5l_dlygate4sd3_1_81.X VDD.t1672 VDD.t16 sg13_lv_pmos ad=79.8f pd=0.8u as=0.1428p ps=1.52u w=0.42u l=0.13u
X1854 sg13cmos5l_a21oi_1_0.A2 sg13cmos5l_nand4_1_18.A a_18974_13338# VSS.t128 sg13_lv_nmos ad=0.2516p pd=2.16u as=0.1406p ps=1.12u w=0.74u l=0.13u
X1855 sg13cmos5l_buf_8_2.A a_12987_12214# VDD.t2361 VDD.t83 sg13_lv_pmos ad=0.2128p pd=1.5u as=0.2128p ps=1.5u w=1.12u l=0.13u
X1856 VDD.t192 VSS.t1799 VDD.t191 VDD.t0 sg13_lv_pmos ad=0.34p pd=2.68u as=0 ps=0 w=1u l=1u
X1857 a_11014_9508# sg13cmos5l_o21ai_1_0.A2 a_10771_9380# VDD.t52 sg13_lv_pmos ad=0.2125p pd=1.425u as=0.35p ps=2.7u w=1u l=0.13u
X1858 VSS.t153 sg13cmos5l_nand2_1_18.A a_13208_11501# VSS.t152 sg13_lv_nmos ad=79.8f pd=0.8u as=0.1428p ps=1.52u w=0.42u l=0.13u
X1859 VSS.t124 sg13cmos5l_a21oi_1_27.B1 sg13cmos5l_a21o_1_2.B1 VSS.t2285 sg13_lv_nmos ad=0.2618p pd=2.22u as=0.1694p ps=1.21u w=0.77u l=0.13u
X1860 sg13cmos5l_nand4_1_3.D a_15358_14850# VDD.t688 VDD.t19 sg13_lv_pmos ad=0.3808p pd=2.92u as=0.2128p ps=1.5u w=1.12u l=0.13u
X1861 VDD.t1977 sg13cmos5l_nand2b_1_1.A_N sg13cmos5l_a21o_1_1.A2 VDD.t52 sg13_lv_pmos ad=0.3808p pd=2.92u as=0.2128p ps=1.5u w=1.12u l=0.13u
X1862 VDD.t1015 a_10330_9154# a_10049_9376# VDD.t52 sg13_lv_pmos ad=0.1523p pd=1.38u as=0.34p ps=2.68u w=1u l=0.5u
X1863 sg13cmos5l_inv_1_2.A a_19995_9190# VSS.t15 VSS.t349 sg13_lv_nmos ad=0.1406p pd=1.12u as=0.1406p ps=1.12u w=0.74u l=0.13u
X1864 a_18863_11821# a_18021_11471# a_17604_11464# VDD.t0 sg13_lv_pmos ad=0.2048p pd=1.63u as=0.34p ps=2.68u w=1u l=0.13u
X1865 a_18948_10711# a_19179_10820# a_18634_10921# VSS.t589 sg13_lv_nmos ad=0.2373p pd=1.97u as=79.8f ps=0.8u w=0.42u l=0.13u
X1866 VDD.t184 VSS.t1792 VDD.t54 VDD.t52 sg13_lv_pmos ad=0.19p pd=1.38u as=0 ps=0 w=1u l=1u
X1867 a_18188_4614# sg13cmos5l_buf_1_16.A VDD.t1767 VDD.t5 sg13_lv_pmos ad=0.2856p pd=2.36u as=0.2114p ps=1.54u w=0.84u l=0.13u
X1868 sg13cmos5l_dlygate4sd3_1_97.X a_13014_17532# VSS.t380 VSS.t1476 sg13_lv_nmos ad=0.2516p pd=2.16u as=0.1426p ps=1.16u w=0.74u l=0.13u
X1869 VSS.t369 sg13cmos5l_dfrbpq_1_24.RESET_B a_4740_19458# VSS.t1133 sg13_lv_nmos ad=0.1626p pd=1.415u as=60.89999f ps=0.71u w=0.42u l=0.13u
X1870 VSS.t228 sg13cmos5l_dfrbpq_1_24.RESET_B a_3626_16434# VSS.t227 sg13_lv_nmos ad=79.8f pd=0.8u as=37.8f ps=0.6u w=0.42u l=0.13u
X1871 a_14517_13880# a_13575_13940# a_14423_14113# VDD.t19 sg13_lv_pmos ad=79.8f pd=0.8u as=0.1428p ps=1.52u w=0.42u l=0.13u
X1872 a_11026_19770# sg13cmos5l_buf_1_15.A.t5 VSS.t937 VSS.t1272 sg13_lv_nmos ad=37.8f pd=0.6u as=79.8f ps=0.8u w=0.42u l=0.13u
X1873 VDD.t1229 sg13cmos5l_nand2_1_15.B sg13cmos5l_mux2_1_0.A1 VDD.t19 sg13_lv_pmos ad=0.2198p pd=1.53u as=0.2128p ps=1.5u w=1.12u l=0.13u
X1874 VSS.t291 VDD.t2427 VSS.t291 VSS.t1993 sg13_lv_nmos ad=0.1428p pd=1.52u as=0 ps=0 w=0.42u l=1u
X1875 VDD.t730 sg13cmos5l_buf_1_13.A a_14438_6162# VDD.t2 sg13_lv_pmos ad=0.36237p pd=2.605u as=79.8f ps=0.8u w=0.42u l=0.13u
X1876 a_22096_7166# a_21839_7285# a_22258_7362# VSS.t36 sg13_lv_nmos ad=0.1428p pd=1.52u as=37.8f ps=0.6u w=0.42u l=0.13u
X1877 a_8602_9154# sg13cmos5l_o21ai_1_6.Y VDD.t718 VDD.t52 sg13_lv_pmos ad=0.1428p pd=1.52u as=0.1523p ps=1.38u w=0.42u l=0.13u
X1878 VSS.t1870 VDD.t2465 VSS.t1872 VSS.t1871 sg13_lv_nmos ad=79.8f pd=0.8u as=0 ps=0 w=0.42u l=1u
X1879 VDD.t100 VSS.t2002 VDD.t99 VDD.t5 sg13_lv_pmos ad=0.34p pd=2.68u as=0 ps=0 w=1u l=1u
X1880 a_18730_18988# a_19173_19031# a_19113_19067# VDD.t231 sg13_lv_pmos ad=79.8f pd=0.8u as=63f ps=0.72u w=0.42u l=0.13u
X1881 VDD.t0 a_22096_11702# a_22041_11583# VDD.t0 sg13_lv_pmos ad=2.1916p pd=14.26u as=93.45f ps=0.865u w=0.42u l=0.13u
X1882 sg13cmos5l_nand2_1_9.Y sg13cmos5l_a21o_1_2.B1 VDD.t711 VDD.t16 sg13_lv_pmos ad=0.2128p pd=1.5u as=0.3808p ps=2.92u w=1.12u l=0.13u
X1883 VSS.t15 sg13cmos5l_buf_8_2.A.t2 a_19995_9190# VSS.t1385 sg13_lv_nmos ad=0.1406p pd=1.12u as=0.1406p ps=1.12u w=0.74u l=0.13u
X1884 VSS.t230 VDD.t2541 VSS.t1669 VSS.t1668 sg13_lv_nmos ad=0.1428p pd=1.52u as=0 ps=0 w=0.42u l=1u
X1885 sg13cmos5l_nand2b_1_5.Y sg13cmos5l_nor3_1_2.C VDD.t863 VDD.t52 sg13_lv_pmos ad=0.2128p pd=1.5u as=0.2198p ps=1.53u w=1.12u l=0.13u
X1886 VSS.t2010 VDD.t2419 VSS.t2010 VSS.t2012 sg13_lv_nmos ad=0.1428p pd=1.52u as=0 ps=0 w=0.42u l=1u
X1887 a_13210_19738# sg13cmos5l_o21ai_1_25.Y VDD.t665 VDD.t270 sg13_lv_pmos ad=0.1428p pd=1.52u as=0.1523p ps=1.38u w=0.42u l=0.13u
X1888 VDD.t888 sg13cmos5l_buf_1_45.X.t5 a_13738_15964# VDD.t16 sg13_lv_pmos ad=0.1563p pd=1.22u as=0.147p ps=1.54u w=0.42u l=0.13u
X1889 VSS.t153 a_13478_11460# a_13590_11484# VSS.t315 sg13_lv_nmos ad=0.1426p pd=1.16u as=0.1428p ps=1.52u w=0.42u l=0.5u
X1890 sg13cmos5l_buf_8_2.A.t0 a_12987_12214# VDD.t2363 VDD.t83 sg13_lv_pmos ad=0.2128p pd=1.5u as=0.2128p ps=1.5u w=1.12u l=0.13u
X1891 VDD.t724 sg13cmos5l_dfrbpq_1_13.RESET_B a_5098_9409# VDD.t52 sg13_lv_pmos ad=0.1563p pd=1.22u as=0.147p ps=1.54u w=0.42u l=0.13u
X1892 sg13cmos5l_inv_1_2.A a_19995_9190# VDD.t835 VDD.t52 sg13_lv_pmos ad=0.2128p pd=1.5u as=0.2128p ps=1.5u w=1.12u l=0.13u
X1893 VDD.t129 VSS.t1997 VDD.t128 VDD.t13 sg13_lv_pmos ad=0.34p pd=2.68u as=0 ps=0 w=1u l=1u
X1894 VDD.t1345 sg13cmos5l_nand2b_1_0.B a_14668_8436# VDD.t8 sg13_lv_pmos ad=0.4032p pd=2.96u as=0.1176p ps=1.33u w=1.12u l=0.13u
X1895 VDD.t231 sg13cmos5l_dfrbpq_1_19.CLK a_4607_18528# VDD.t231 sg13_lv_pmos ad=1.4953p pd=9.545u as=0.4088p ps=2.97u w=1.12u l=0.13u
X1896 sg13cmos5l_dfrbpq_1_38.Q a_15690_17508# VDD.t1595 VDD.t310 sg13_lv_pmos ad=0.3808p pd=2.92u as=0.2128p ps=1.5u w=1.12u l=0.13u
X1897 VDD.t965 sg13cmos5l_nand4_1_5.D sg13cmos5l_a21oi_1_25.A2 VDD.t310 sg13_lv_pmos ad=0.3808p pd=2.92u as=0.2128p ps=1.5u w=1.12u l=0.13u
X1898 a_10895_12287# a_10053_12189# a_10801_12287# VSS.t157 sg13_lv_nmos ad=0.12665p pd=1.145u as=0.1428p ps=1.52u w=0.42u l=0.13u
X1899 a_11674_6130# sg13cmos5l_dfrbpq_1_13.Q VDD.t2134 VDD.t2 sg13_lv_pmos ad=0.1428p pd=1.52u as=0.1523p ps=1.38u w=0.42u l=0.13u
X1900 a_6490_16714# sg13cmos5l_o21ai_1_10.Y VDD.t956 VDD.t310 sg13_lv_pmos ad=0.1428p pd=1.52u as=0.1523p ps=1.38u w=0.42u l=0.13u
X1901 sg13cmos5l_nor2_1_16.Y sg13cmos5l_o21ai_1_5.A1 VSS.t52 VSS.t982 sg13_lv_nmos ad=0.1406p pd=1.12u as=0.2516p ps=2.16u w=0.74u l=0.13u
X1902 sg13cmos5l_nand3_1_0.Y sg13cmos5l_nand3_1_0.B VDD.t2200 VDD.t2 sg13_lv_pmos ad=0.2128p pd=1.5u as=0.2128p ps=1.5u w=1.12u l=0.13u
X1903 VSS.t2302 a_17253_19749# a_17355_19892# VSS.t2431 sg13_lv_nmos ad=3.91182p pd=24.955u as=0.2516p ps=2.16u w=0.74u l=0.13u
X1904 VDD.t844 sg13cmos5l_dfrbpq_1_28.RESET_B.t2 a_20554_12433# VDD.t83 sg13_lv_pmos ad=0.1563p pd=1.22u as=0.147p ps=1.54u w=0.42u l=0.13u
X1905 VSS.t1737 VDD.t2509 VSS.t1739 VSS.t1738 sg13_lv_nmos ad=79.8f pd=0.8u as=0 ps=0 w=0.42u l=1u
X1906 a_5220_19445# a_4932_19024# a_5158_19445# VSS.t1304 sg13_lv_nmos ad=0.1428p pd=1.52u as=37.8f ps=0.6u w=0.42u l=0.13u
X1907 a_5998_17775# a_6113_17774# VDD.t645 VDD.t310 sg13_lv_pmos ad=0.34p pd=2.68u as=0.2254p ps=1.53u w=1u l=0.5u
X1908 a_16763_17508# sg13cmos5l_a21oi_1_18.B1 sg13cmos5l_a21oi_1_25.Y VDD.t310 sg13_lv_pmos ad=0.2128p pd=1.5u as=0.3808p ps=2.92u w=1.12u l=0.13u
X1909 VSS.t134 sg13cmos5l_nand4_1_5.D a_16578_16754# VSS.t505 sg13_lv_nmos ad=0.2516p pd=2.16u as=0.1406p ps=1.12u w=0.74u l=0.13u
X1910 a_5999_14845# a_5157_14495# a_5905_14845# VSS.t494 sg13_lv_nmos ad=0.12665p pd=1.145u as=0.1428p ps=1.52u w=0.42u l=0.13u
X1911 a_10461_11730# sg13cmos5l_mux2_1_1.A1 VSS.t477 VSS.t476 sg13_lv_nmos ad=0.187p pd=1.78u as=0.14505p ps=1.15u w=0.55u l=0.13u
X1912 VSS.t1219 VDD.t2461 VSS.t1219 VSS.t1900 sg13_lv_nmos ad=79.8f pd=0.8u as=0 ps=0 w=0.42u l=1u
X1913 VDD.t8 a_19077_7653# a_19179_7796# VDD.t8 sg13_lv_pmos ad=1.8716p pd=12.115u as=0.3864p ps=2.93u w=1.12u l=0.13u
X1914 sg13cmos5l_a22oi_1_0.B2 a_12426_9948# VSS.t248 VSS.t800 sg13_lv_nmos ad=0.2516p pd=2.16u as=0.1406p ps=1.12u w=0.74u l=0.13u
X1915 VSS.t97 a_14446_9375# sg13cmos5l_dlygate4sd3_1_15.X VSS.t2385 sg13_lv_nmos ad=0.1426p pd=1.16u as=0.2516p ps=2.16u w=0.74u l=0.13u
X1916 a_18922_5380# a_19365_5423# a_18662_5850# VSS.t1587 sg13_lv_nmos ad=79.8f pd=0.8u as=0.1296p ps=1.52u w=0.42u l=0.13u
X1917 a_13778_10706# sg13cmos5l_nor3_1_2.B VSS.t86 VSS.t551 sg13_lv_nmos ad=0.1406p pd=1.12u as=0.2886p ps=2.26u w=0.74u l=0.13u
X1918 VDD.t833 a_19995_9190# sg13cmos5l_inv_1_2.A VDD.t52 sg13_lv_pmos ad=0.2128p pd=1.5u as=0.2128p ps=1.5u w=1.12u l=0.13u
X1919 VSS.t1433 a_18106_17472# a_17825_17774# VSS.t179 sg13_lv_nmos ad=79.8f pd=0.8u as=0.1428p ps=1.52u w=0.42u l=0.5u
X1920 VSS.t1665 VDD.t2543 VSS.t1663 VSS.t1664 sg13_lv_nmos ad=0.1428p pd=1.52u as=0 ps=0 w=0.42u l=1u
X1921 VDD.t2018 a_14534_10702# a_14646_10766# VDD.t0 sg13_lv_pmos ad=0.2254p pd=1.53u as=0.34p ps=2.68u w=1u l=0.5u
X1922 sg13cmos5l_dfrbpq_1_47.D a_13974_6230# VDD.t857 VDD.t2 sg13_lv_pmos ad=0.4256p pd=3u as=0.2254p ps=1.53u w=1.12u l=0.13u
X1923 VDD.t1753 sg13cmos5l_a21oi_1_11.Y a_13592_6166# VDD.t2 sg13_lv_pmos ad=0.1523p pd=1.38u as=0.1428p ps=1.52u w=0.42u l=0.13u
X1924 a_16578_13338# sg13cmos5l_nand4_1_1.A a_16476_13338# VSS.t128 sg13_lv_nmos ad=0.1406p pd=1.12u as=0.1406p ps=1.12u w=0.74u l=0.13u
X1925 sg13cmos5l_dfrbpq_1_5.Q a_20586_10996# VSS.t596 VSS.t886 sg13_lv_nmos ad=0.2516p pd=2.16u as=0.1406p ps=1.12u w=0.74u l=0.13u
X1926 VSS.t571 VDD.t2477 VSS.t190 VSS.t1853 sg13_lv_nmos ad=0.1428p pd=1.52u as=0 ps=0 w=0.42u l=1u
X1927 VDD.t786 sg13cmos5l_nor2_1_2.A sg13cmos5l_nand2_1_3.Y VDD.t2 sg13_lv_pmos ad=0.3808p pd=2.92u as=0.2128p ps=1.5u w=1.12u l=0.13u
X1928 a_10522_7678# sg13cmos5l_nand2_1_6.A sg13cmos5l_a21oi_1_10.A2 VSS.t2491 sg13_lv_nmos ad=0.1406p pd=1.12u as=0.2516p ps=2.16u w=0.74u l=0.13u
X1929 a_20806_11885# sg13cmos5l_buf_1_7.X VSS.t9 VSS.t32 sg13_lv_nmos ad=37.8f pd=0.6u as=0.1701p ps=1.65u w=0.42u l=0.13u
X1930 a_18873_7047# a_17931_6935# a_18671_7285# VDD.t2 sg13_lv_pmos ad=93.45f pd=0.865u as=0.2048p ps=1.63u w=0.42u l=0.13u
X1931 a_12658_18258# sg13cmos5l_dfrbpq_1_24.RESET_B VSS.t380 VSS.t1139 sg13_lv_nmos ad=37.8f pd=0.6u as=79.8f ps=0.8u w=0.42u l=0.13u
X1932 sg13cmos5l_a21oi_1_1.A2 sg13cmos5l_nand4_1_18.D VDD.t976 VDD.t19 sg13_lv_pmos ad=0.2128p pd=1.5u as=0.3808p ps=2.92u w=1.12u l=0.13u
X1933 a_20554_4873# a_20997_4629# a_20937_5041# VDD.t5 sg13_lv_pmos ad=79.8f pd=0.8u as=63f ps=0.72u w=0.42u l=0.13u
X1934 a_16836_20088# a_16810_19993# VDD.t891 VDD.t270 sg13_lv_pmos ad=0.34p pd=2.68u as=0.36237p ps=2.605u w=1u l=0.13u
X1935 VDD.t815 a_15480_8752# sg13cmos5l_dfrbpq_1_2.D VDD.t8 sg13_lv_pmos ad=0.2226p pd=1.535u as=0.3976p ps=2.95u w=1.12u l=0.13u
X1936 a_5397_18416# a_4455_18476# a_5303_18649# VDD.t231 sg13_lv_pmos ad=79.8f pd=0.8u as=0.1428p ps=1.52u w=0.42u l=0.13u
X1937 sg13cmos5l_buf_1_26.A a_18486_18326# VDD.t657 VDD.t231 sg13_lv_pmos ad=0.4256p pd=3u as=0.2254p ps=1.53u w=1.12u l=0.13u
X1938 VSS.t1618 VDD.t2555 VSS.t1617 VSS.t1616 sg13_lv_nmos ad=0.1428p pd=1.52u as=0 ps=0 w=0.42u l=1u
X1939 a_12987_12214# clk VDD.t1136 VDD.t83 sg13_lv_pmos ad=0.2128p pd=1.5u as=0.2128p ps=1.5u w=1.12u l=0.13u
X1940 VDD.t1778 a_7066_18226# a_6785_18448# VDD.t231 sg13_lv_pmos ad=0.1523p pd=1.38u as=0.34p ps=2.68u w=1u l=0.5u
X1941 VDD.t705 sg13cmos5l_and2_1_3.X a_16840_12972# VDD.t83 sg13_lv_pmos ad=0.2114p pd=1.54u as=0.2856p ps=2.36u w=0.84u l=0.13u
X1942 VSS.t2168 VDD.t2382 VSS.t2170 VSS.t2169 sg13_lv_nmos ad=79.8f pd=0.8u as=0 ps=0 w=0.42u l=1u
X1943 a_21531_13342# sg13cmos5l_buf_8_2.A.t4 VSS.t163 VSS.t2612 sg13_lv_nmos ad=0.1406p pd=1.12u as=0.1406p ps=1.12u w=0.74u l=0.13u
X1944 VDD.t147 VSS.t2110 VDD.t146 VDD.t13 sg13_lv_pmos ad=0.19p pd=1.38u as=0 ps=0 w=1u l=1u
X1945 a_20580_8440# a_21099_8447# a_21839_8797# VSS.t14 sg13_lv_nmos ad=0.3473p pd=2.71u as=0.12665p ps=1.145u w=0.74u l=0.13u
X1946 VDD.t318 VSS.t1644 VDD.t314 VDD.t310 sg13_lv_pmos ad=0.19p pd=1.38u as=0 ps=0 w=1u l=1u
X1947 VDD.t207 VSS.t538 VDD.t575 VDD.t0 sg13_lv_pmos ad=0.34p pd=2.68u as=0 ps=0 w=1u l=1u
X1948 a_22522_6130# sg13cmos5l_dlygate4sd3_1_24.A VSS.t237 VSS.t258 sg13_lv_nmos ad=0.1428p pd=1.52u as=79.8f ps=0.8u w=0.42u l=0.13u
X1949 a_6958_6162# a_6700_6162# VSS.t1204 VSS.t2209 sg13_lv_nmos ad=0.1428p pd=1.52u as=79.8f ps=0.8u w=0.42u l=0.13u
X1950 sg13cmos5l_nor3_1_2.B sg13cmos5l_inv_1_18.Y a_13566_8828# VSS.t2390 sg13_lv_nmos ad=0.2664p pd=1.46u as=96.2f ps=1u w=0.74u l=0.13u
X1951 VDD.t1220 a_17914_9912# a_17633_10214# VDD.t52 sg13_lv_pmos ad=0.1523p pd=1.38u as=0.34p ps=2.68u w=1u l=0.5u
X1952 VSS.t1433 sg13cmos5l_dfrbpq_1_33.Q a_18104_18262# VSS.t92 sg13_lv_nmos ad=79.8f pd=0.8u as=0.1428p ps=1.52u w=0.42u l=0.13u
X1953 a_18970_14448# sg13cmos5l_dlygate4sd3_1_77.A VDD.t2082 VDD.t19 sg13_lv_pmos ad=0.1428p pd=1.52u as=0.1523p ps=1.38u w=0.42u l=0.13u
X1954 a_16070_5850# a_16875_5423# a_16330_5380# VDD.t5 sg13_lv_pmos ad=0.1428p pd=1.52u as=79.8f ps=0.8u w=0.42u l=0.13u
X1955 sg13cmos5l_dlygate4sd3_1_77.A a_18954_15532# VSS.t500 VSS.t392 sg13_lv_nmos ad=0.2516p pd=2.16u as=0.1406p ps=1.12u w=0.74u l=0.13u
X1956 VSS.t1688 VDD.t2528 VSS.t1687 VSS.t1686 sg13_lv_nmos ad=0.1428p pd=1.52u as=0 ps=0 w=0.42u l=1u
X1957 VSS.t2010 VDD.t2400 VSS.t2010 VSS.t2061 sg13_lv_nmos ad=0.1428p pd=1.52u as=0 ps=0 w=0.42u l=1u
X1958 a_4476_18222# a_4607_18528# a_3895_18222# VDD.t231 sg13_lv_pmos ad=0.34p pd=2.68u as=0.2048p ps=1.63u w=1u l=0.13u
X1959 VDD.t978 sg13cmos5l_dfrbpq_1_19.D a_4727_16043# VDD.t16 sg13_lv_pmos ad=0.1428p pd=1.52u as=79.8f ps=0.8u w=0.42u l=0.13u
X1960 VSS.t7 a_19718_12214# a_19830_12278# VSS.t1422 sg13_lv_nmos ad=0.1426p pd=1.16u as=0.1428p ps=1.52u w=0.42u l=0.5u
X1961 a_15214_10215# a_15329_10214# VSS.t120 VSS.t738 sg13_lv_nmos ad=0.1428p pd=1.52u as=0.1426p ps=1.16u w=0.42u l=0.5u
X1962 VSS.t402 sg13cmos5l_o21ai_1_5.A1 sg13cmos5l_nor2_1_10.Y VSS.t986 sg13_lv_nmos ad=0.2516p pd=2.16u as=0.1406p ps=1.12u w=0.74u l=0.13u
X1963 VDD.t953 a_5998_13911# sg13cmos5l_dfrbpq_1_24.D VDD.t19 sg13_lv_pmos ad=0.2254p pd=1.53u as=0.4256p ps=3u w=1.12u l=0.13u
X1964 VDD.t391 sg13cmos5l_dfrbpq_1_13.RESET_B a_6470_11898# VDD.t0 sg13_lv_pmos ad=0.36237p pd=2.605u as=79.8f ps=0.8u w=0.42u l=0.13u
X1965 VDD.t2060 a_19919_7751# a_20586_7972# VDD.t8 sg13_lv_pmos ad=0.2128p pd=1.5u as=0.3864p ps=2.93u w=1.12u l=0.13u
X1966 VDD.t19 a_21839_14845# a_22096_14726# VDD.t19 sg13_lv_pmos ad=2.1916p pd=14.26u as=79.8f ps=0.8u w=0.42u l=0.13u
X1967 sg13cmos5l_dfrbpq_1_13.RESET_B a_5032_9948# VDD.t2024 VDD.t52 sg13_lv_pmos ad=0.42p pd=2.99u as=0.2114p ps=1.54u w=1.12u l=0.13u
X1968 VSS.t48 sg13cmos5l_o21ai_1_8.B1 a_8698_16366# VSS.t1185 sg13_lv_nmos ad=0.2516p pd=2.16u as=0.1406p ps=1.12u w=0.74u l=0.13u
X1969 a_19829_14020# sg13cmos5l_inv_1_17.Y VDD.t1694 VDD.t19 sg13_lv_pmos ad=0.2128p pd=1.5u as=0.2128p ps=1.5u w=1.12u l=0.13u
X1970 VDD.t1073 sg13cmos5l_nand3_1_8.Y a_17621_12972# VDD.t83 sg13_lv_pmos ad=0.2128p pd=1.5u as=0.3808p ps=2.92u w=1.12u l=0.13u
X1971 VDD.t1014 a_12430_9375# sg13cmos5l_o21ai_1_0.A2 VDD.t52 sg13_lv_pmos ad=0.2254p pd=1.53u as=0.4256p ps=3u w=1.12u l=0.13u
X1972 VDD.t937 a_21070_7863# sg13cmos5l_dfrbpq_1_8.D VDD.t8 sg13_lv_pmos ad=0.2254p pd=1.53u as=0.4256p ps=3u w=1.12u l=0.13u
X1973 VDD.t2057 sg13cmos5l_o21ai_1_17.B1 sg13cmos5l_o21ai_1_17.Y VDD.t310 sg13_lv_pmos ad=0.3808p pd=2.92u as=0.2128p ps=1.5u w=1.12u l=0.15u
X1974 a_5782_15230# sg13cmos5l_nor2_1_6.Y VSS.t585 VSS.t1005 sg13_lv_nmos ad=0.1406p pd=1.12u as=0.1406p ps=1.12u w=0.74u l=0.15u
X1975 sg13cmos5l_dfrbpq_1_29.Q a_22506_14484# VDD.t1135 VDD.t19 sg13_lv_pmos ad=0.3808p pd=2.92u as=0.2128p ps=1.5u w=1.12u l=0.13u
X1976 a_10359_14020# sg13cmos5l_nor4_1_1.D a_10245_14020# VDD.t19 sg13_lv_pmos ad=0.2128p pd=1.5u as=0.2464p ps=1.56u w=1.12u l=0.13u
X1977 VSS.t1737 VDD.t2520 VSS.t1739 VSS.t1738 sg13_lv_nmos ad=79.8f pd=0.8u as=0 ps=0 w=0.42u l=1u
X1978 a_22005_16904# sg13cmos5l_dfrbpq_1_28.RESET_B.t7 VDD.t1325 VDD.t310 sg13_lv_pmos ad=0.147p pd=1.54u as=0.1563p ps=1.22u w=0.42u l=0.13u
X1979 VSS.t124 sg13cmos5l_nand2_1_11.B a_8026_14854# VSS.t1319 sg13_lv_nmos ad=0.2516p pd=2.16u as=0.1406p ps=1.12u w=0.74u l=0.13u
X1980 sg13cmos5l_buf_1_65.A a_7912_12972# VDD.t1172 VDD.t83 sg13_lv_pmos ad=0.42p pd=2.99u as=0.2114p ps=1.54u w=1.12u l=0.13u
X1981 VDD.t1388 VSS.t2095 VDD.t626 VDD.t13 sg13_lv_pmos ad=0.19p pd=1.38u as=0 ps=0 w=1u l=1u
X1982 VDD.t2251 a_8878_7191# sg13cmos5l_nor2_1_2.A VDD.t2 sg13_lv_pmos ad=0.2254p pd=1.53u as=0.4256p ps=3u w=1.12u l=0.13u
X1983 VSS.t271 a_9765_5423# a_9867_5423# VSS.t770 sg13_lv_nmos ad=4.02307p pd=25.55u as=0.2516p ps=2.16u w=0.74u l=0.13u
X1984 a_16474_18984# sg13cmos5l_a21oi_1_26.Y VSS.t306 VSS.t305 sg13_lv_nmos ad=0.1428p pd=1.52u as=79.8f ps=0.8u w=0.42u l=0.13u
X1985 a_11292_4658# sg13cmos5l_a21oi_1_9.A1 sg13cmos5l_nand3_1_3.Y VSS.t693 sg13_lv_nmos ad=0.1406p pd=1.12u as=0.2516p ps=2.16u w=0.74u l=0.13u
X1986 sg13cmos5l_dlygate4sd3_1_1.A a_18282_5412# VSS.t316 VSS.t38 sg13_lv_nmos ad=0.2516p pd=2.16u as=0.1406p ps=1.12u w=0.74u l=0.13u
X1987 VSS.t1693 VDD.t2533 VSS.t1692 VSS.t1691 sg13_lv_nmos ad=0.1428p pd=1.52u as=0 ps=0 w=0.42u l=1u
X1988 VSS.t2113 VDD.t2393 VSS.t2115 VSS.t2114 sg13_lv_nmos ad=79.8f pd=0.8u as=0 ps=0 w=0.42u l=1u
X1989 VSS.t1875 VDD.t2464 VSS.t1877 VSS.t1876 sg13_lv_nmos ad=79.8f pd=0.8u as=0 ps=0 w=0.42u l=1u
X1990 a_15223_7638# a_15783_7892# a_15804_7638# VSS.t1060 sg13_lv_nmos ad=0.12665p pd=1.145u as=0.3473p ps=2.71u w=0.74u l=0.13u
X1991 VSS.t169 a_12837_19031# a_12939_19031# VSS.t1160 sg13_lv_nmos ad=3.91182p pd=24.955u as=0.2516p ps=2.16u w=0.74u l=0.13u
X1992 VDD.t194 VSS.t1797 VDD.t178 VDD.t0 sg13_lv_pmos ad=0.19p pd=1.38u as=0 ps=0 w=1u l=1u
X1993 VDD.t718 a_8602_9154# a_8321_9376# VDD.t52 sg13_lv_pmos ad=0.1523p pd=1.38u as=0.34p ps=2.68u w=1u l=0.5u
X1994 VDD.t1425 a_10771_9380# sg13cmos5l_a21o_1_0.X VDD.t52 sg13_lv_pmos ad=0.3808p pd=2.92u as=0.3808p ps=2.92u w=1.12u l=0.13u
X1995 VDD.t111 VSS.t2005 VDD.t110 VDD.t5 sg13_lv_pmos ad=0.34p pd=2.68u as=0 ps=0 w=1u l=1u
X1996 a_14244_20088# a_14763_19892# a_15503_19847# VSS.t166 sg13_lv_nmos ad=0.3473p pd=2.71u as=0.12665p ps=1.145u w=0.74u l=0.13u
X1997 a_17296_18478# a_17039_18335# a_17458_18258# VSS.t92 sg13_lv_nmos ad=0.1428p pd=1.52u as=37.8f ps=0.6u w=0.42u l=0.13u
X1998 a_7173_11471# sg13cmos5l_dfrbpq_1_15.CLK VSS.t2 VSS.t2547 sg13_lv_nmos ad=0.2516p pd=2.16u as=4.7455p ps=30.71u w=0.74u l=0.13u
X1999 a_19919_10775# a_19077_10677# a_19825_10775# VSS.t591 sg13_lv_nmos ad=0.12665p pd=1.145u as=0.1428p ps=1.52u w=0.42u l=0.13u
X2000 VDD.t721 sg13cmos5l_buf_1_10.A a_21640_3900# VDD.t13 sg13_lv_pmos ad=0.2114p pd=1.54u as=0.2856p ps=2.36u w=0.84u l=0.13u
X2001 VSS.t39 a_17098_6130# sg13cmos5l_inv_1_5.A VSS.t285 sg13_lv_nmos ad=0.1406p pd=1.12u as=0.1406p ps=1.12u w=0.74u l=0.13u
X2002 a_17290_8404# a_17733_8447# a_17030_8874# VSS.t1575 sg13_lv_nmos ad=79.8f pd=0.8u as=0.1296p ps=1.52u w=0.42u l=0.13u
X2003 a_6487_6126# a_7047_6380# a_6958_6477# VDD.t2 sg13_lv_pmos ad=0.2048p pd=1.63u as=93.45f ps=0.865u w=0.42u l=0.13u
X2004 VDD.t1903 sg13cmos5l_buf_1_65.A sg13cmos5l_o21ai_1_10.A2 VDD.t16 sg13_lv_pmos ad=0.2128p pd=1.5u as=0.3808p ps=2.92u w=1.12u l=0.13u
X2005 sg13cmos5l_a21oi_1_0.A2 sg13cmos5l_nand4_1_3.D VDD.t904 VDD.t83 sg13_lv_pmos ad=0.2128p pd=1.5u as=0.3808p ps=2.92u w=1.12u l=0.13u
X2006 a_12131_5412# sg13cmos5l_o21ai_1_0.A1 a_12029_5412# VDD.t5 sg13_lv_pmos ad=0.2464p pd=1.56u as=0.2128p ps=1.5u w=1.12u l=0.13u
X2007 VDD.t1803 a_18574_14751# sg13cmos5l_inv_1_16.A VDD.t19 sg13_lv_pmos ad=0.2254p pd=1.53u as=0.4256p ps=3u w=1.12u l=0.13u
X2008 sg13cmos5l_nand3_1_3.Y sg13cmos5l_a21oi_1_9.A2 VDD.t1118 VDD.t5 sg13_lv_pmos ad=0.2128p pd=1.5u as=0.2128p ps=1.5u w=1.12u l=0.13u
X2009 a_9156_19770# sg13cmos5l_dlygate4sd3_1_58.X a_9062_19770# VSS.t2281 sg13_lv_nmos ad=60.89999f pd=0.71u as=0.1428p ps=1.52u w=0.42u l=0.13u
X2010 VDD.t277 VSS.t1605 VDD.t276 VDD.t231 sg13_lv_pmos ad=0.34p pd=2.68u as=0 ps=0 w=1u l=1u
X2011 a_6094_16935# a_6209_16936# VDD.t1704 VDD.t310 sg13_lv_pmos ad=0.34p pd=2.68u as=0.2254p ps=1.53u w=1u l=0.5u
X2012 a_20580_4968# a_21099_4772# a_21839_4727# VSS.t42 sg13_lv_nmos ad=0.3473p pd=2.71u as=0.12665p ps=1.145u w=0.74u l=0.13u
X2013 a_7524_19024# a_7498_18988# VDD.t1502 VDD.t231 sg13_lv_pmos ad=0.34p pd=2.68u as=0.36237p ps=2.605u w=1u l=0.13u
X2014 VDD.t133 VSS.t1997 VDD.t132 VDD.t13 sg13_lv_pmos ad=0.34p pd=2.68u as=0 ps=0 w=1u l=1u
X2015 VDD.t8 a_19919_7751# a_20176_7894# VDD.t8 sg13_lv_pmos ad=1.8716p pd=12.115u as=79.8f ps=0.8u w=0.42u l=0.13u
X2016 a_15223_7638# a_15783_7892# a_15694_7989# VDD.t8 sg13_lv_pmos ad=0.2048p pd=1.63u as=93.45f ps=0.865u w=0.42u l=0.13u
X2017 a_4917_16904# sg13cmos5l_dfrbpq_1_24.RESET_B VDD.t1509 VDD.t310 sg13_lv_pmos ad=0.147p pd=1.54u as=0.1563p ps=1.22u w=0.42u l=0.13u
X2018 VDD.t1490 a_4070_19020# a_4182_19044# VDD.t231 sg13_lv_pmos ad=0.2254p pd=1.53u as=0.34p ps=2.68u w=1u l=0.5u
X2019 VSS.t222 sg13cmos5l_nor3_1_0.Y a_15226_12214# VSS.t722 sg13_lv_nmos ad=0.2516p pd=2.16u as=0.1406p ps=1.12u w=0.74u l=0.13u
X2020 VDD.t1180 a_14938_6888# a_14657_7190# VDD.t2 sg13_lv_pmos ad=0.1523p pd=1.38u as=0.34p ps=2.68u w=1u l=0.5u
X2021 sg13cmos5l_a21oi_1_3.A2 sg13cmos5l_nand4_1_1.A a_16766_13730# VSS.t128 sg13_lv_nmos ad=0.2516p pd=2.16u as=0.1406p ps=1.12u w=0.74u l=0.13u
X2022 a_20794_12936# sg13cmos5l_dlygate4sd3_1_76.A VSS.t583 VSS.t162 sg13_lv_nmos ad=0.1428p pd=1.52u as=79.8f ps=0.8u w=0.42u l=0.13u
X2023 sg13cmos5l_inv_1_5.A a_17098_6130# VSS.t13 VSS.t285 sg13_lv_nmos ad=0.1406p pd=1.12u as=0.1406p ps=1.12u w=0.74u l=0.13u
X2024 a_5078_16421# a_3900_16357# a_4682_16276# VSS.t963 sg13_lv_nmos ad=37.8f pd=0.6u as=0.1428p ps=1.52u w=0.42u l=0.13u
X2025 VDD.t358 a_18863_11821# a_19530_11460# VDD.t0 sg13_lv_pmos ad=0.2128p pd=1.5u as=0.3864p ps=2.93u w=1.12u l=0.13u
X2026 VDD.t1333 sg13cmos5l_nor2b_1_0.B_N a_13198_9228# VDD.t52 sg13_lv_pmos ad=0.2618p pd=1.63u as=0.2856p ps=2.36u w=0.84u l=0.13u
X2027 VDD.t315 VSS.t1644 VDD.t319 VDD.t16 sg13_lv_pmos ad=0.19p pd=1.38u as=0 ps=0 w=1u l=1u
X2028 VSS.t2153 VDD.t2385 VSS.t2155 VSS.t2154 sg13_lv_nmos ad=79.8f pd=0.8u as=0 ps=0 w=0.42u l=1u
X2029 sg13cmos5l_o21ai_1_22.Y sg13cmos5l_o21ai_1_22.B1 a_9526_16742# VSS.t297 sg13_lv_nmos ad=0.2516p pd=2.16u as=0.1406p ps=1.12u w=0.74u l=0.15u
X2030 VSS.t260 a_6682_8400# a_6401_8702# VSS.t788 sg13_lv_nmos ad=79.8f pd=0.8u as=0.1428p ps=1.52u w=0.42u l=0.5u
X2031 sg13cmos5l_nand3b_1_3.C a_1192_19020# VSS.t400 VSS.t1269 sg13_lv_nmos ad=0.2886p pd=2.26u as=0.14875p ps=1.16u w=0.74u l=0.13u
X2032 VDD.t1092 sg13cmos5l_nand2_1_12.Y a_12632_17549# VDD.t310 sg13_lv_pmos ad=0.1523p pd=1.38u as=0.1428p ps=1.52u w=0.42u l=0.13u
X2033 a_8812_17044# sg13cmos5l_nand3b_1_1.Y sg13cmos5l_o21ai_1_8.B1 VDD.t310 sg13_lv_pmos ad=0.1176p pd=1.33u as=0.3808p ps=2.92u w=1.12u l=0.13u
X2034 a_16091_9948# sg13cmos5l_a21oi_1_4.A2 VDD.t689 VDD.t52 sg13_lv_pmos ad=0.3808p pd=2.92u as=0.2128p ps=1.5u w=1.12u l=0.13u
X2035 a_16078_19287# a_16193_19286# VSS.t307 VSS.t305 sg13_lv_nmos ad=0.1428p pd=1.52u as=0.1426p ps=1.16u w=0.42u l=0.5u
X2036 VSS.t56 sg13cmos5l_buf_8_2.A.t7 a_7498_18226# VSS.t1375 sg13_lv_nmos ad=0.1406p pd=1.12u as=0.1406p ps=1.12u w=0.74u l=0.13u
X2037 a_18002_14850# sg13cmos5l_nand4_1_16.D VSS.t786 VSS.t785 sg13_lv_nmos ad=0.1406p pd=1.12u as=0.2516p ps=2.16u w=0.74u l=0.13u
X2038 VDD.t329 VSS.t1741 VDD.t328 VDD.t83 sg13_lv_pmos ad=0.34p pd=2.68u as=0 ps=0 w=1u l=1u
X2039 a_5481_9577# a_5124_9504# VDD.t724 VDD.t52 sg13_lv_pmos ad=63f pd=0.72u as=0.1563p ps=1.22u w=0.42u l=0.13u
X2040 VSS.t99 a_16186_6888# a_15905_7190# VSS.t1042 sg13_lv_nmos ad=79.8f pd=0.8u as=0.1428p ps=1.52u w=0.42u l=0.5u
X2041 VDD.t863 sg13cmos5l_nor3_1_2.B a_8955_9228# VDD.t52 sg13_lv_pmos ad=0.2198p pd=1.53u as=0.2856p ps=2.36u w=0.84u l=0.13u
X2042 VSS.t293 sg13cmos5l_dfrbpq_1_13.RESET_B a_9156_5850# VSS.t1222 sg13_lv_nmos ad=0.1626p pd=1.415u as=60.89999f ps=0.71u w=0.42u l=0.13u
X2043 a_18928_7166# sg13cmos5l_buf_1_7.X VDD.t2 VDD.t2 sg13_lv_pmos ad=79.8f pd=0.8u as=2.07625p ps=13.51u w=0.42u l=0.13u
X2044 VSS.t190 sg13cmos5l_dfrbpq_1_15.Q a_8520_8436# VSS.t776 sg13_lv_nmos ad=0.14135p pd=1.14u as=0.1045p ps=0.93u w=0.55u l=0.13u
X2045 VDD.t1087 a_12902_17508# a_13014_17532# VDD.t310 sg13_lv_pmos ad=0.2254p pd=1.53u as=0.34p ps=2.68u w=1u l=0.5u
X2046 VSS.t164 sg13cmos5l_a21oi_1_18.B1 sg13cmos5l_dfrbpq_1_28.D VSS.t128 sg13_lv_nmos ad=0.2516p pd=2.16u as=0.1406p ps=1.12u w=0.74u l=0.13u
X2047 a_14039_5459# sg13cmos5l_dfrbpq_1_47.D a_14786_5850# VSS.t243 sg13_lv_nmos ad=0.1428p pd=1.52u as=60.89999f ps=0.71u w=0.42u l=0.13u
X2048 VDD.t0 a_20997_11471# a_21099_11471# VDD.t0 sg13_lv_pmos ad=2.1916p pd=14.26u as=0.3864p ps=2.93u w=1.12u l=0.13u
X2049 VSS.t1707 VDD.t2530 VSS.t1707 VSS.t1706 sg13_lv_nmos ad=0.1428p pd=1.52u as=0 ps=0 w=0.42u l=1u
X2050 a_14039_5459# sg13cmos5l_buf_1_13.A VDD.t2108 VDD.t5 sg13_lv_pmos ad=79.8f pd=0.8u as=0.36237p ps=2.605u w=0.42u l=0.13u
X2051 a_3415_16710# a_3975_16964# a_3996_16710# VSS.t453 sg13_lv_nmos ad=0.12665p pd=1.145u as=0.3473p ps=2.71u w=0.74u l=0.13u
X2052 VDD.t1019 a_18682_16714# a_18401_16936# VDD.t310 sg13_lv_pmos ad=0.1523p pd=1.38u as=0.34p ps=2.68u w=1u l=0.5u
X2053 VDD.t1202 a_11759_10309# a_12426_9948# VDD.t52 sg13_lv_pmos ad=0.2128p pd=1.5u as=0.3864p ps=2.93u w=1.12u l=0.13u
X2054 a_20580_14040# a_21099_13844# a_21839_13799# VSS.t1515 sg13_lv_nmos ad=0.3473p pd=2.71u as=0.12665p ps=1.145u w=0.74u l=0.13u
X2055 a_6383_9263# a_5541_9165# a_5124_9504# VDD.t52 sg13_lv_pmos ad=0.2048p pd=1.63u as=0.34p ps=2.68u w=1u l=0.13u
X2056 bn5 a_14536_14484# VDD.t1752 VDD.t19 sg13_lv_pmos ad=0.42p pd=2.99u as=0.2114p ps=1.54u w=1.12u l=0.13u
X2057 VSS.t2173 VDD.t2381 VSS.t2175 VSS.t2174 sg13_lv_nmos ad=79.8f pd=0.8u as=0 ps=0 w=0.42u l=1u
X2058 VSS.t37 a_21839_7285# a_22506_6924# VSS.t36 sg13_lv_nmos ad=0.1406p pd=1.12u as=0.2516p ps=2.16u w=0.74u l=0.13u
X2059 a_16631_8065# a_15935_7944# a_16725_7832# VSS.t830 sg13_lv_nmos ad=0.1296p pd=1.52u as=79.8f ps=0.8u w=0.42u l=0.13u
X2060 sg13cmos5l_dfrbpq_1_29.Q a_22506_14484# VSS.t636 VSS.t394 sg13_lv_nmos ad=0.2516p pd=2.16u as=0.1406p ps=1.12u w=0.74u l=0.13u
X2061 VDD.t13 VSS.t2080 VDD.t268 VDD.t13 sg13_lv_pmos ad=0.19p pd=1.38u as=0 ps=0 w=1u l=1u
X2062 bn4 a_11656_15272# VDD.t1348 VDD.t16 sg13_lv_pmos ad=0.42p pd=2.99u as=0.2114p ps=1.54u w=1.12u l=0.13u
X2063 sg13cmos5l_dlygate4sd3_1_71.X a_19830_12278# VDD.t1427 VDD.t83 sg13_lv_pmos ad=0.4256p pd=3u as=0.2254p ps=1.53u w=1.12u l=0.13u
X2064 a_19065_11583# a_18123_11471# a_18863_11821# VDD.t0 sg13_lv_pmos ad=93.45f pd=0.865u as=0.2048p ps=1.63u w=0.42u l=0.13u
X2065 VSS.t86 a_12987_10318# sg13cmos5l_dfrbpq_1_13.CLK VSS.t1093 sg13_lv_nmos ad=0.1406p pd=1.12u as=0.1406p ps=1.12u w=0.74u l=0.13u
X2066 a_13749_9386# sg13cmos5l_inv_1_18.A VDD.t1049 VDD.t52 sg13_lv_pmos ad=0.2856p pd=2.36u as=0.2198p ps=1.53u w=0.84u l=0.13u
X2067 sg13cmos5l_dfrbpq_1_41.CLK a_14218_18226# VSS.t113 VSS.t1429 sg13_lv_nmos ad=0.1406p pd=1.12u as=0.1406p ps=1.12u w=0.74u l=0.13u
X2068 sg13cmos5l_dfrbpq_1_3.D a_16950_9972# VDD.t1008 VDD.t52 sg13_lv_pmos ad=0.4256p pd=3u as=0.2254p ps=1.53u w=1.12u l=0.13u
X2069 a_20294_12210# sg13cmos5l_dfrbpq_1_28.D VDD.t1687 VDD.t83 sg13_lv_pmos ad=79.8f pd=0.8u as=0.1428p ps=1.52u w=0.42u l=0.13u
X2070 VSS.t266 a_19077_10677# a_19179_10820# VSS.t590 sg13_lv_nmos ad=4.90217p pd=31.68u as=0.2516p ps=2.16u w=0.74u l=0.13u
X2071 VDD.t180 VSS.t1794 VDD.t179 VDD.t52 sg13_lv_pmos ad=0.34p pd=2.68u as=0 ps=0 w=1u l=1u
X2072 sg13cmos5l_inv_1_5.A a_17098_6130# VSS.t13 VSS.t527 sg13_lv_nmos ad=0.1406p pd=1.12u as=0.2516p ps=2.16u w=0.74u l=0.13u
X2073 VDD.t433 VSS.t571 VDD.t432 VDD.t8 sg13_lv_pmos ad=0.34p pd=2.68u as=0 ps=0 w=1u l=1u
X2074 VDD.t1372 sg13cmos5l_nand4_1_0.C sg13cmos5l_o21ai_1_6.B1 VDD.t8 sg13_lv_pmos ad=0.3808p pd=2.92u as=0.3808p ps=2.92u w=1.12u l=0.13u
X2075 VSS.t5 a_7498_18226# sg13cmos5l_dfrbpq_1_19.CLK VSS.t2270 sg13_lv_nmos ad=0.1406p pd=1.12u as=0.1406p ps=1.12u w=0.74u l=0.13u
X2076 a_22096_13942# a_21839_13799# a_22258_13722# VSS.t212 sg13_lv_nmos ad=0.1428p pd=1.52u as=37.8f ps=0.6u w=0.42u l=0.13u
X2077 VSS.t196 sg13cmos5l_dfrbpq_1_24.Q sg13cmos5l_nor3_1_6.Y VSS.t149 sg13_lv_nmos ad=0.1463p pd=1.15u as=0.1694p ps=1.21u w=0.77u l=0.13u
X2078 a_21839_11821# a_20997_11471# a_20580_11464# VDD.t0 sg13_lv_pmos ad=0.2048p pd=1.63u as=0.34p ps=2.68u w=1u l=0.13u
X2079 a_18671_7285# a_17829_6935# a_17412_6928# VDD.t2 sg13_lv_pmos ad=0.2048p pd=1.63u as=0.34p ps=2.68u w=1u l=0.13u
X2080 a_20554_13945# a_20997_13701# a_20937_14113# VDD.t19 sg13_lv_pmos ad=79.8f pd=0.8u as=63f ps=0.72u w=0.42u l=0.13u
X2081 a_21370_19738# sg13cmos5l_dfrbpq_1_39.Q VDD.t1488 VDD.t270 sg13_lv_pmos ad=0.1428p pd=1.52u as=0.1523p ps=1.38u w=0.42u l=0.13u
X2082 VSS.t48 sg13cmos5l_nand4_1_15.B sg13cmos5l_o21ai_1_18.A2 VSS.t233 sg13_lv_nmos ad=0.2516p pd=2.16u as=0.1406p ps=1.12u w=0.74u l=0.13u
X2083 VDD.t19 sg13cmos5l_buf_1_45.X.t2 a_13228_13722# VDD.t19 sg13_lv_pmos ad=2.1916p pd=14.26u as=79.8f ps=0.8u w=0.42u l=0.13u
X2084 a_18382_6351# a_18497_6352# VDD.t807 VDD.t2 sg13_lv_pmos ad=0.34p pd=2.68u as=0.2254p ps=1.53u w=1u l=0.5u
X2085 VDD.t1012 sg13cmos5l_a21oi_1_10.A2 a_9077_6460# VDD.t2 sg13_lv_pmos ad=0.2128p pd=1.5u as=0.3808p ps=2.92u w=1.12u l=0.13u
X2086 a_9171_6188# sg13cmos5l_a21oi_1_10.A2 VSS.t293 VSS.t792 sg13_lv_nmos ad=0.1406p pd=1.12u as=0.2516p ps=2.16u w=0.74u l=0.13u
X2087 VDD.t289 VSS.t1700 VDD.t296 VDD.t19 sg13_lv_pmos ad=0.19p pd=1.38u as=0 ps=0 w=1u l=1u
X2088 VSS.t182 a_6394_13690# a_6113_13912# VSS.t2248 sg13_lv_nmos ad=79.8f pd=0.8u as=0.1428p ps=1.52u w=0.42u l=0.5u
X2089 a_4108_18258# a_3895_18222# VDD.t231 VDD.t231 sg13_lv_pmos ad=79.8f pd=0.8u as=1.54512p ps=9.865u w=0.42u l=0.13u
X2090 VSS.t199 sg13cmos5l_buf_1_24.A a_11656_15272# VSS.t1568 sg13_lv_nmos ad=0.14875p pd=1.16u as=0.187p ps=1.78u w=0.55u l=0.13u
X2091 bp8 a_19720_3176# VDD.t926 VDD.t13 sg13_lv_pmos ad=0.42p pd=2.99u as=0.2114p ps=1.54u w=1.12u l=0.13u
X2092 a_10878_7180# sg13cmos5l_and4_1_0.D VDD.t1382 VDD.t2 sg13_lv_pmos ad=0.1848p pd=1.28u as=0.2044p ps=1.53u w=0.84u l=0.13u
X2093 sg13cmos5l_dfrbpq_1_9.D a_16566_8460# VDD.t1374 VDD.t8 sg13_lv_pmos ad=0.4256p pd=3u as=0.2254p ps=1.53u w=1.12u l=0.13u
X2094 sg13cmos5l_dlygate4sd3_1_56.X a_10230_18326# VDD.t713 VDD.t231 sg13_lv_pmos ad=0.4256p pd=3u as=0.2254p ps=1.53u w=1.12u l=0.13u
X2095 VSS.t26 a_20176_7894# a_19825_7751# VSS.t686 sg13_lv_nmos ad=79.8f pd=0.8u as=0.1428p ps=1.52u w=0.42u l=0.13u
X2096 a_17811_19368# sg13cmos5l_nand4_1_12.Y VSS.t357 VSS.t1442 sg13_lv_nmos ad=0.1406p pd=1.12u as=0.2516p ps=2.16u w=0.74u l=0.13u
X2097 a_8637_5682# sg13cmos5l_nand2b_1_1.A_N VSS.t293 VSS.t2227 sg13_lv_nmos ad=0.187p pd=1.78u as=0.14505p ps=1.15u w=0.55u l=0.13u
X2098 a_10694_18258# sg13cmos5l_dlygate4sd3_1_56.X VDD.t1620 VDD.t231 sg13_lv_pmos ad=79.8f pd=0.8u as=0.1428p ps=1.52u w=0.42u l=0.13u
X2099 a_10389_16258# sg13cmos5l_buf_1_65.A VDD.t390 VDD.t16 sg13_lv_pmos ad=0.2856p pd=2.36u as=0.2198p ps=1.53u w=0.84u l=0.13u
X2100 VSS.t136 sg13cmos5l_dfrbpq_1_28.RESET_B a_16836_15234# VSS.t135 sg13_lv_nmos ad=0.1626p pd=1.415u as=60.89999f ps=0.71u w=0.42u l=0.13u
X2101 VDD.t2 sg13cmos5l_dfrbpq_1_15.CLK a_7199_6432# VDD.t2 sg13_lv_pmos ad=2.1916p pd=14.26u as=0.4088p ps=2.97u w=1.12u l=0.13u
X2102 VDD.t1243 a_1690_19738# a_1409_19960# VDD.t270 sg13_lv_pmos ad=0.1523p pd=1.38u as=0.34p ps=2.68u w=1u l=0.5u
X2103 VSS.t248 a_12016_10190# a_11665_10309# VSS.t2601 sg13_lv_nmos ad=79.8f pd=0.8u as=0.1428p ps=1.52u w=0.42u l=0.13u
X2104 a_15705_20085# a_14763_19892# a_15503_19847# VDD.t270 sg13_lv_pmos ad=93.45f pd=0.865u as=0.2048p ps=1.63u w=0.42u l=0.13u
X2105 VSS.t7 a_18863_11821# a_19530_11460# VSS.t405 sg13_lv_nmos ad=0.1406p pd=1.12u as=0.2516p ps=2.16u w=0.74u l=0.13u
X2106 a_17628_16362# sg13cmos5l_nand4_1_15.B a_17526_16362# VSS.t234 sg13_lv_nmos ad=0.1406p pd=1.12u as=0.1406p ps=1.12u w=0.74u l=0.13u
X2107 VSS.t86 a_12987_10318# sg13cmos5l_dfrbpq_1_13.CLK VSS.t1089 sg13_lv_nmos ad=0.1406p pd=1.12u as=0.1406p ps=1.12u w=0.74u l=0.13u
X2108 VSS.t120 a_15610_9912# a_15329_10214# VSS.t557 sg13_lv_nmos ad=79.8f pd=0.8u as=0.1428p ps=1.52u w=0.42u l=0.5u
X2109 sg13cmos5l_a21oi_1_3.Y sg13cmos5l_inv_1_3.Y a_17715_7700# VSS.t126 sg13_lv_nmos ad=0.1406p pd=1.12u as=0.1406p ps=1.12u w=0.74u l=0.13u
X2110 a_16454_8436# a_16184_8477# VSS.t81 VSS.t80 sg13_lv_nmos ad=0.1428p pd=1.52u as=79.8f ps=0.8u w=0.42u l=0.5u
X2111 sg13cmos5l_dfrbpq_1_41.CLK a_14218_18226# VSS.t113 VSS.t1425 sg13_lv_nmos ad=0.1406p pd=1.12u as=0.1406p ps=1.12u w=0.74u l=0.13u
X2112 VDD.t725 a_22042_15202# a_21761_15424# VDD.t16 sg13_lv_pmos ad=0.1523p pd=1.38u as=0.34p ps=2.68u w=1u l=0.5u
X2113 a_3790_16434# a_4031_15967# a_3319_15960# VSS.t227 sg13_lv_nmos ad=0.1428p pd=1.52u as=0.12665p ps=1.145u w=0.42u l=0.13u
X2114 VSS.t2118 VDD.t2392 VSS.t2120 VSS.t2119 sg13_lv_nmos ad=79.8f pd=0.8u as=0 ps=0 w=0.42u l=1u
X2115 VSS.t1880 VDD.t2463 VSS.t1882 VSS.t1881 sg13_lv_nmos ad=79.8f pd=0.8u as=0 ps=0 w=0.42u l=1u
X2116 a_17038_14751# a_17153_14750# VDD.t1244 VDD.t19 sg13_lv_pmos ad=0.34p pd=2.68u as=0.2254p ps=1.53u w=1u l=0.5u
X2117 VSS.t402 sg13cmos5l_nand3_1_6.C a_11202_16362# VSS.t401 sg13_lv_nmos ad=0.2886p pd=2.26u as=0.1406p ps=1.12u w=0.74u l=0.13u
X2118 VDD.t804 a_10316_12936# sg13cmos5l_mux2_1_1.A1 VDD.t83 sg13_lv_pmos ad=0.2114p pd=1.54u as=0.42p ps=2.99u w=1.12u l=0.13u
X2119 a_18974_13338# sg13cmos5l_nand4_1_3.B a_18872_13338# VSS.t128 sg13_lv_nmos ad=0.1406p pd=1.12u as=0.1406p ps=1.12u w=0.74u l=0.13u
X2120 a_8848_12214# sg13cmos5l_mux2_1_1.A0 a_8734_12214# VSS.t1448 sg13_lv_nmos ad=0.3367p pd=1.65u as=0.1628p ps=1.18u w=0.74u l=0.13u
X2121 VDD.t952 sg13cmos5l_nor2_1_3.Y sg13cmos5l_buf_1_21.A VDD.t0 sg13_lv_pmos ad=0.3808p pd=2.92u as=0.2128p ps=1.5u w=1.12u l=0.13u
X2122 VDD.t1108 sg13cmos5l_buf_1_2.A sg13cmos5l_inv_1_3.Y VDD.t13 sg13_lv_pmos ad=0.3808p pd=2.92u as=0.3808p ps=2.92u w=1.12u l=0.13u
X2123 VDD.t161 VSS.t1215 VDD.t446 VDD.t8 sg13_lv_pmos ad=0.19p pd=1.38u as=0 ps=0 w=1u l=1u
X2124 a_22126_17775# a_22241_17774# VDD.t1030 VDD.t310 sg13_lv_pmos ad=0.34p pd=2.68u as=0.2254p ps=1.53u w=1u l=0.5u
X2125 a_12812_15960# sg13cmos5l_nand3_1_2.Y VDD.t1839 VDD.t16 sg13_lv_pmos ad=0.2856p pd=2.36u as=0.2114p ps=1.54u w=0.84u l=0.13u
X2126 sg13cmos5l_a21oi_1_17.Y sg13cmos5l_a21oi_1_4.A1 a_16179_12236# VSS.t147 sg13_lv_nmos ad=0.1406p pd=1.12u as=0.1406p ps=1.12u w=0.74u l=0.13u
X2127 a_15141_6141# sg13cmos5l_inv_1_5.A VSS.t271 VSS.t1039 sg13_lv_nmos ad=0.2516p pd=2.16u as=3.65735p ps=23.23u w=0.74u l=0.13u
X2128 VSS.t46 sg13cmos5l_dfrbpq_1_24.Q sg13cmos5l_nor4_1_1.D VSS.t460 sg13_lv_nmos ad=0.2516p pd=2.16u as=0.2516p ps=2.16u w=0.74u l=0.13u
X2129 a_12597_11722# sg13cmos5l_nand2_1_0.A VSS.t153 VSS.t708 sg13_lv_nmos ad=0.187p pd=1.78u as=0.18575p ps=1.26u w=0.55u l=0.13u
X2130 VDD.t514 VSS.t1935 VDD.t839 VDD.t2 sg13_lv_pmos ad=0.34p pd=2.68u as=0 ps=0 w=1u l=1u
X2131 a_20937_8483# a_20580_8440# VDD.t365 VDD.t8 sg13_lv_pmos ad=63f pd=0.72u as=0.1563p ps=1.22u w=0.42u l=0.13u
X2132 a_9636_12528# a_10155_12332# a_10895_12287# VSS.t639 sg13_lv_nmos ad=0.3473p pd=2.71u as=0.12665p ps=1.145u w=0.74u l=0.13u
X2133 a_8576_10901# sg13cmos5l_dlygate4sd3_1_38.X VDD.t990 VDD.t0 sg13_lv_pmos ad=0.1596p pd=1.22u as=0.1918p ps=1.5u w=0.84u l=0.13u
X2134 a_15798_16754# sg13cmos5l_buf_1_42.A sg13cmos5l_nand4_1_12.Y VSS.t1231 sg13_lv_nmos ad=0.1406p pd=1.12u as=0.2516p ps=2.16u w=0.74u l=0.13u
X2135 VDD.t1557 sg13cmos5l_dfrbpq_1_13.RESET_B a_9350_12210# VDD.t83 sg13_lv_pmos ad=0.36237p pd=2.605u as=79.8f ps=0.8u w=0.42u l=0.13u
X2136 sg13cmos5l_dfrbpq_1_34.Q a_16170_20068# VDD.t1431 VDD.t270 sg13_lv_pmos ad=0.3808p pd=2.92u as=0.2128p ps=1.5u w=1.12u l=0.13u
X2137 a_17062_19783# sg13cmos5l_buf_1_45.X.t13 VSS.t422 VSS.t166 sg13_lv_nmos ad=37.8f pd=0.6u as=0.1701p ps=1.65u w=0.42u l=0.13u
X2138 VDD.t917 a_19035_16750# sg13cmos5l_inv_1_31.A VDD.t310 sg13_lv_pmos ad=0.2128p pd=1.5u as=0.2128p ps=1.5u w=1.12u l=0.13u
X2139 VDD.t155 VSS.t2140 VDD.t154 VDD.t13 sg13_lv_pmos ad=0.19p pd=1.38u as=0 ps=0 w=1u l=1u
X2140 a_17872_5654# sg13cmos5l_buf_1_7.X VDD.t5 VDD.t5 sg13_lv_pmos ad=79.8f pd=0.8u as=1.8716p ps=12.115u w=0.42u l=0.13u
X2141 a_9765_19749# sg13cmos5l_dfrbpq_1_19.CLK VSS.t169 VSS.t2477 sg13_lv_nmos ad=0.2516p pd=2.16u as=3.5562p ps=22.685u w=0.74u l=0.13u
X2142 VSS.t1099 a_20015_19381# a_20682_19020# VSS.t1098 sg13_lv_nmos ad=0.1406p pd=1.12u as=0.2516p ps=2.16u w=0.74u l=0.13u
X2143 a_4823_17137# a_4127_17016# a_4917_16904# VSS.t1495 sg13_lv_nmos ad=0.1296p pd=1.52u as=79.8f ps=0.8u w=0.42u l=0.13u
X2144 sg13cmos5l_o21ai_1_9.A2 sg13cmos5l_a21oi_1_4.A1 VDD.t690 VDD.t19 sg13_lv_pmos ad=0.2128p pd=1.5u as=0.3808p ps=2.92u w=1.12u l=0.13u
X2145 VSS.t83 a_19430_9190# a_19542_9254# VSS.t1585 sg13_lv_nmos ad=0.1426p pd=1.16u as=0.1428p ps=1.52u w=0.42u l=0.5u
X2146 code1 a_15400_15272# VDD.t727 VDD.t16 sg13_lv_pmos ad=0.42p pd=2.99u as=0.2114p ps=1.54u w=1.12u l=0.13u
X2147 a_16742_15234# a_17547_15356# a_17002_15457# VDD.t16 sg13_lv_pmos ad=0.1428p pd=1.52u as=79.8f ps=0.8u w=0.42u l=0.13u
X2148 sg13cmos5l_nand4_1_3.B sg13cmos5l_dfrbpq_1_24.Q a_8898_14020# VDD.t19 sg13_lv_pmos ad=0.4368p pd=3.02u as=0.2128p ps=1.5u w=1.12u l=0.13u
X2149 VDD.t962 sg13cmos5l_nand4_1_5.D sg13cmos5l_a21oi_1_24.A2 VDD.t310 sg13_lv_pmos ad=0.3808p pd=2.92u as=0.2128p ps=1.5u w=1.12u l=0.13u
X2150 a_16838_9948# a_16568_9989# VSS.t174 VSS.t1590 sg13_lv_nmos ad=0.1428p pd=1.52u as=79.8f ps=0.8u w=0.42u l=0.5u
X2151 VDD.t456 VSS.t291 VDD.t455 VDD.t5 sg13_lv_pmos ad=0.34p pd=2.68u as=0 ps=0 w=1u l=1u
X2152 a_3626_16434# a_3319_15960# a_3532_16434# VSS.t227 sg13_lv_nmos ad=37.8f pd=0.6u as=0.1428p ps=1.52u w=0.42u l=0.13u
X2153 bn5 a_14536_14484# VSS.t239 VSS.t1386 sg13_lv_nmos ad=0.2886p pd=2.26u as=0.14875p ps=1.16u w=0.74u l=0.13u
X2154 VSS.t2158 VDD.t2384 VSS.t2160 VSS.t2159 sg13_lv_nmos ad=79.8f pd=0.8u as=0 ps=0 w=0.42u l=1u
X2155 a_16186_6888# sg13cmos5l_nand2b_1_3.B VDD.t1250 VDD.t2 sg13_lv_pmos ad=0.1428p pd=1.52u as=0.1523p ps=1.38u w=0.42u l=0.13u
X2156 VSS.t2518 a_15014_19020# a_15126_19044# VSS.t305 sg13_lv_nmos ad=0.1426p pd=1.16u as=0.1428p ps=1.52u w=0.42u l=0.5u
X2157 sg13cmos5l_a21oi_1_15.A2 sg13cmos5l_nand4_1_1.C VDD.t1636 VDD.t19 sg13_lv_pmos ad=0.2128p pd=1.5u as=0.2128p ps=1.5u w=1.12u l=0.13u
X2158 a_1294_19959# a_1409_19960# VSS.t400 VSS.t696 sg13_lv_nmos ad=0.1428p pd=1.52u as=0.1426p ps=1.16u w=0.42u l=0.5u
X2159 a_19365_5423# sg13cmos5l_inv_1_2.A VSS.t271 VSS.t270 sg13_lv_nmos ad=0.2516p pd=2.16u as=4.02307p ps=25.55u w=0.74u l=0.13u
X2160 VSS.t242 a_14181_17519# a_14283_17519# VSS.t628 sg13_lv_nmos ad=4.1963p pd=27.415u as=0.2516p ps=2.16u w=0.74u l=0.13u
X2161 VDD.t16 a_18544_15454# a_18489_15549# VDD.t16 sg13_lv_pmos ad=2.07625p pd=13.51u as=93.45f ps=0.865u w=0.42u l=0.13u
X2162 VSS.t86 sg13cmos5l_buf_8_2.A a_12987_10318# VSS.t872 sg13_lv_nmos ad=0.1406p pd=1.12u as=0.2553p ps=2.17u w=0.74u l=0.13u
X2163 a_16773_5423# sg13cmos5l_inv_1_5.A VDD.t5 VDD.t5 sg13_lv_pmos ad=0.4088p pd=2.97u as=1.96072p ps=12.69u w=1.12u l=0.13u
X2164 a_17126_7362# sg13cmos5l_dfrbpq_1_9.D VDD.t1991 VDD.t2 sg13_lv_pmos ad=79.8f pd=0.8u as=0.1428p ps=1.52u w=0.42u l=0.13u
X2165 VSS.t1865 VDD.t2466 VSS.t1867 VSS.t1866 sg13_lv_nmos ad=79.8f pd=0.8u as=0 ps=0 w=0.42u l=1u
X2166 code6 a_4744_19808# VSS.t369 VSS.t370 sg13_lv_nmos ad=0.2886p pd=2.26u as=0.14875p ps=1.16u w=0.74u l=0.13u
X2167 VDD.t664 sg13cmos5l_buf_1_45.X.t15 a_13958_19770# VDD.t270 sg13_lv_pmos ad=0.36237p pd=2.605u as=79.8f ps=0.8u w=0.42u l=0.13u
X2168 VDD.t1594 sg13cmos5l_buf_1_42.A a_15976_12972# VDD.t83 sg13_lv_pmos ad=0.2114p pd=1.54u as=0.2856p ps=2.36u w=0.84u l=0.13u
X2169 a_18188_4614# sg13cmos5l_buf_1_16.A VSS.t850 VSS.t1406 sg13_lv_nmos ad=0.187p pd=1.78u as=0.14875p ps=1.16u w=0.55u l=0.13u
X2170 a_8246_6175# a_7068_6126# a_7850_6320# VSS.t1578 sg13_lv_nmos ad=37.8f pd=0.6u as=0.1428p ps=1.52u w=0.42u l=0.13u
X2171 a_12082_7302# sg13cmos5l_o21ai_1_0.Y sg13cmos5l_o21ai_1_4.Y VSS.t250 sg13_lv_nmos ad=0.1406p pd=1.12u as=0.2516p ps=2.16u w=0.74u l=0.15u
X2172 a_10500_9952# a_11019_9959# a_11759_10309# VSS.t2459 sg13_lv_nmos ad=0.3473p pd=2.71u as=0.12665p ps=1.145u w=0.74u l=0.13u
X2173 a_12414_7996# sg13cmos5l_nand3_1_0.A sg13cmos5l_a22oi_1_2.Y VDD.t8 sg13_lv_pmos ad=0.2716p pd=1.605u as=0.2128p ps=1.5u w=1.12u l=0.13u
X2174 a_17030_8874# a_17835_8447# a_17290_8404# VDD.t8 sg13_lv_pmos ad=0.1428p pd=1.52u as=79.8f ps=0.8u w=0.42u l=0.13u
X2175 VDD.t247 VSS.t1830 VDD.t246 VDD.t8 sg13_lv_pmos ad=0.19p pd=1.38u as=0 ps=0 w=1u l=1u
X2176 a_20015_17869# a_19173_17519# a_18756_17512# VDD.t310 sg13_lv_pmos ad=0.2048p pd=1.63u as=0.34p ps=2.68u w=1u l=0.13u
X2177 VSS.t201 sg13cmos5l_buf_1_59.A a_15400_15272# VSS.t626 sg13_lv_nmos ad=0.14875p pd=1.16u as=0.187p ps=1.78u w=0.55u l=0.13u
X2178 a_6863_13333# a_6021_12983# a_6769_13333# VSS.t149 sg13_lv_nmos ad=0.12665p pd=1.145u as=0.1428p ps=1.52u w=0.42u l=0.13u
X2179 VSS.t111 a_10895_12287# a_11562_12508# VSS.t2229 sg13_lv_nmos ad=0.1406p pd=1.12u as=0.2516p ps=2.16u w=0.74u l=0.13u
X2180 VDD.t1932 a_13212_5773# a_14235_5459# VDD.t5 sg13_lv_pmos ad=0.1563p pd=1.22u as=63f ps=0.72u w=0.42u l=0.13u
X2181 a_21911_16043# sg13cmos5l_buf_1_15.A.t3 VDD.t1195 VDD.t16 sg13_lv_pmos ad=79.8f pd=0.8u as=0.36237p ps=2.605u w=0.42u l=0.13u
X2182 sg13cmos5l_nor2_1_16.Y sg13cmos5l_nor4_1_2.Y a_12458_17044# VDD.t310 sg13_lv_pmos ad=0.3808p pd=2.92u as=0.1176p ps=1.33u w=1.12u l=0.13u
X2183 VDD.t298 VSS.t1700 VDD.t291 VDD.t83 sg13_lv_pmos ad=0.19p pd=1.38u as=0 ps=0 w=1u l=1u
X2184 VDD.t1200 a_22522_3106# a_22241_3328# VDD.t13 sg13_lv_pmos ad=0.1523p pd=1.38u as=0.34p ps=2.68u w=1u l=0.5u
X2185 sg13cmos5l_inv_1_1.Y sg13cmos5l_inv_1_1.A VDD.t752 VDD.t5 sg13_lv_pmos ad=0.3808p pd=2.92u as=0.3808p ps=2.92u w=1.12u l=0.13u
X2186 VSS.t1693 VDD.t2527 VSS.t1692 VSS.t1691 sg13_lv_nmos ad=0.1428p pd=1.52u as=0 ps=0 w=0.42u l=1u
X2187 VSS.t2133 VDD.t2389 VSS.t2132 VSS.t2131 sg13_lv_nmos ad=0.1428p pd=1.52u as=0 ps=0 w=0.42u l=1u
X2188 VSS.t362 a_6442_10666# sg13cmos5l_dfrbpq_1_15.CLK VSS.t2401 sg13_lv_nmos ad=0.1406p pd=1.12u as=0.1406p ps=1.12u w=0.74u l=0.13u
X2189 a_7812_19445# a_7524_19024# a_7750_19445# VSS.t1168 sg13_lv_nmos ad=0.1428p pd=1.52u as=37.8f ps=0.6u w=0.42u l=0.13u
X2190 VDD.t1626 sg13cmos5l_nand3b_1_3.C a_6968_17549# VDD.t310 sg13_lv_pmos ad=0.1523p pd=1.38u as=0.1428p ps=1.52u w=0.42u l=0.13u
X2191 VDD.t913 a_19035_16750# sg13cmos5l_inv_1_31.A VDD.t310 sg13_lv_pmos ad=0.2128p pd=1.5u as=0.2128p ps=1.5u w=1.12u l=0.13u
X2192 a_20580_9952# a_20554_9916# VDD.t1037 VDD.t52 sg13_lv_pmos ad=0.34p pd=2.68u as=0.36237p ps=2.605u w=1u l=0.13u
X2193 VSS.t37 a_22096_7166# a_21745_7285# VSS.t36 sg13_lv_nmos ad=79.8f pd=0.8u as=0.1428p ps=1.52u w=0.42u l=0.13u
X2194 VDD.t2180 a_11756_19734# code4 VDD.t270 sg13_lv_pmos ad=0.2114p pd=1.54u as=0.42p ps=2.99u w=1.12u l=0.13u
X2195 VSS.t1099 a_19642_19738# a_19361_19960# VSS.t1416 sg13_lv_nmos ad=79.8f pd=0.8u as=0.1428p ps=1.52u w=0.42u l=0.5u
X2196 VSS.t1987 VDD.t2429 VSS.t1987 VSS.t1990 sg13_lv_nmos ad=0.1428p pd=1.52u as=0 ps=0 w=0.42u l=1u
X2197 a_13191_5499# a_13343_5383# VDD.t5 VDD.t5 sg13_lv_pmos ad=0.3864p pd=2.93u as=1.96072p ps=12.69u w=1.12u l=0.13u
X2198 VDD.t299 VSS.t2085 VDD.t269 VDD.t13 sg13_lv_pmos ad=0.19p pd=1.38u as=0 ps=0 w=1u l=1u
X2199 a_5158_19445# sg13cmos5l_dfrbpq_1_24.RESET_B VSS.t369 VSS.t1128 sg13_lv_nmos ad=37.8f pd=0.6u as=0.1701p ps=1.65u w=0.42u l=0.13u
X2200 VDD.t736 sg13cmos5l_mux2_1_0.A1 a_5660_14040# VDD.t19 sg13_lv_pmos ad=0.3808p pd=2.92u as=0.2128p ps=1.5u w=1.12u l=0.15u
X2201 sg13cmos5l_a21oi_1_17.Y sg13cmos5l_and2_1_5.X a_16085_12508# VDD.t83 sg13_lv_pmos ad=0.3808p pd=2.92u as=0.2128p ps=1.5u w=1.12u l=0.13u
X2202 a_12814_19959# a_12929_19960# VSS.t107 VSS.t805 sg13_lv_nmos ad=0.1428p pd=1.52u as=0.1426p ps=1.16u w=0.42u l=0.5u
X2203 VDD.t802 sg13cmos5l_nor4_1_1.D a_10833_14874# VDD.t19 sg13_lv_pmos ad=0.2044p pd=1.53u as=0.1848p ps=1.28u w=0.84u l=0.13u
X2204 a_8006_13726# a_7736_13726# VSS.t67 VSS.t66 sg13_lv_nmos ad=0.1428p pd=1.52u as=79.8f ps=0.8u w=0.42u l=0.5u
X2205 a_18948_5416# a_18922_5380# VDD.t379 VDD.t5 sg13_lv_pmos ad=0.34p pd=2.68u as=0.36237p ps=2.605u w=1u l=0.13u
X2206 a_18470_19458# sg13cmos5l_dfrbpq_1_35.D VDD.t1774 VDD.t231 sg13_lv_pmos ad=79.8f pd=0.8u as=0.1428p ps=1.52u w=0.42u l=0.13u
X2207 a_16006_18271# sg13cmos5l_buf_1_45.X.t9 VSS.t113 VSS.t427 sg13_lv_nmos ad=37.8f pd=0.6u as=0.1701p ps=1.65u w=0.42u l=0.13u
X2208 a_16556_15960# sg13cmos5l_nand4_1_16.D VDD.t1191 VDD.t16 sg13_lv_pmos ad=0.2856p pd=2.36u as=0.2114p ps=1.54u w=0.84u l=0.13u
X2209 VSS.t1707 VDD.t2524 VSS.t1707 VSS.t1718 sg13_lv_nmos ad=0.1428p pd=1.52u as=0 ps=0 w=0.42u l=1u
X2210 VDD.t1147 sg13cmos5l_dfrbpq_1_48.Q a_13304_18262# VDD.t231 sg13_lv_pmos ad=0.1523p pd=1.38u as=0.1428p ps=1.52u w=0.42u l=0.13u
X2211 VSS.t2103 VDD.t2395 VSS.t2105 VSS.t2104 sg13_lv_nmos ad=79.8f pd=0.8u as=0 ps=0 w=0.42u l=1u
X2212 a_20810_16434# a_20503_15960# a_20716_16434# VSS.t338 sg13_lv_nmos ad=37.8f pd=0.6u as=0.1428p ps=1.52u w=0.42u l=0.13u
X2213 a_20868_13735# a_20580_14040# a_20806_13735# VSS.t128 sg13_lv_nmos ad=0.1428p pd=1.52u as=37.8f ps=0.6u w=0.42u l=0.13u
X2214 a_8635_13362# sg13cmos5l_mux2_1_1.A1 a_8533_13362# VSS.t149 sg13_lv_nmos ad=0.1408p pd=1.08u as=0.1216p ps=1.02u w=0.64u l=0.13u
X2215 a_13574_18262# a_13304_18262# VDD.t1147 VDD.t231 sg13_lv_pmos ad=0.34p pd=2.68u as=0.1523p ps=1.38u w=1u l=0.5u
X2216 a_7354_19738# sg13cmos5l_o21ai_1_7.Y VSS.t1127 VSS.t2422 sg13_lv_nmos ad=0.1428p pd=1.52u as=79.8f ps=0.8u w=0.42u l=0.13u
X2217 sg13cmos5l_dfrbpq_1_48.Q a_12906_18556# VSS.t380 VSS.t1286 sg13_lv_nmos ad=0.2516p pd=2.16u as=0.1406p ps=1.12u w=0.74u l=0.13u
X2218 VDD.t2155 a_6442_10666# sg13cmos5l_dfrbpq_1_15.CLK VDD.t0 sg13_lv_pmos ad=0.2128p pd=1.5u as=0.2128p ps=1.5u w=1.12u l=0.13u
X2219 VDD.t947 a_21254_10702# a_21366_10766# VDD.t0 sg13_lv_pmos ad=0.2254p pd=1.53u as=0.34p ps=2.68u w=1u l=0.5u
X2220 VDD.t1034 sg13cmos5l_buf_1_13.X a_20554_9916# VDD.t52 sg13_lv_pmos ad=0.1563p pd=1.22u as=0.147p ps=1.54u w=0.42u l=0.13u
X2221 a_14774_13735# a_13596_13686# a_14378_13880# VSS.t1354 sg13_lv_nmos ad=37.8f pd=0.6u as=0.1428p ps=1.52u w=0.42u l=0.13u
X2222 VSS.t58 a_9734_17508# a_9846_17532# VSS.t1356 sg13_lv_nmos ad=0.1426p pd=1.16u as=0.1428p ps=1.52u w=0.42u l=0.5u
X2223 VSS.t1757 VDD.t2516 VSS.t60 VSS.t1758 sg13_lv_nmos ad=79.8f pd=0.8u as=0 ps=0 w=0.42u l=1u
X2224 a_6794_6162# a_6487_6126# a_6700_6162# VSS.t257 sg13_lv_nmos ad=37.8f pd=0.6u as=0.1428p ps=1.52u w=0.42u l=0.13u
X2225 a_15280_16238# a_15023_16357# a_15442_16434# VSS.t371 sg13_lv_nmos ad=0.1428p pd=1.52u as=37.8f ps=0.6u w=0.42u l=0.13u
X2226 VDD.t2271 sg13cmos5l_nand3_1_0.B sg13cmos5l_dlygate4sd3_1_13.A VDD.t83 sg13_lv_pmos ad=0.3808p pd=2.92u as=0.2128p ps=1.5u w=1.12u l=0.13u
X2227 a_17345_17856# sg13cmos5l_a21oi_1_24.A1 sg13cmos5l_a21oi_1_24.Y VSS.t179 sg13_lv_nmos ad=0.1406p pd=1.12u as=0.1406p ps=1.12u w=0.74u l=0.13u
X2228 VDD.t1746 sg13cmos5l_buf_8_2.A.t5 a_19035_16750# VDD.t310 sg13_lv_pmos ad=0.2128p pd=1.5u as=0.3808p ps=2.92u w=1.12u l=0.13u
X2229 a_15607_9150# a_16167_9404# a_16188_9150# VSS.t2314 sg13_lv_nmos ad=0.12665p pd=1.145u as=0.3473p ps=2.71u w=0.74u l=0.13u
X2230 a_22522_9154# sg13cmos5l_dlygate4sd3_1_20.A VDD.t826 VDD.t52 sg13_lv_pmos ad=0.1428p pd=1.52u as=0.1523p ps=1.38u w=0.42u l=0.13u
X2231 a_17030_8874# sg13cmos5l_dfrbpq_1_11.D VDD.t2105 VDD.t8 sg13_lv_pmos ad=79.8f pd=0.8u as=0.1428p ps=1.52u w=0.42u l=0.13u
X2232 a_11374_17775# a_11489_17774# VDD.t1326 VDD.t310 sg13_lv_pmos ad=0.34p pd=2.68u as=0.2254p ps=1.53u w=1u l=0.5u
X2233 a_20398_4167# a_20513_4166# VDD.t2139 VDD.t13 sg13_lv_pmos ad=0.34p pd=2.68u as=0.2254p ps=1.53u w=1u l=0.5u
X2234 VDD.t1691 a_12428_12936# sg13cmos5l_buf_1_66.X VDD.t83 sg13_lv_pmos ad=0.2114p pd=1.54u as=0.42p ps=2.99u w=1.12u l=0.13u
X2235 VDD.t539 VSS.t1058 VDD.t537 VDD.t0 sg13_lv_pmos ad=0.19p pd=1.38u as=0 ps=0 w=1u l=1u
X2236 a_7964_17064# sg13cmos5l_nor2_1_7.Y sg13cmos5l_dlygate4sd3_1_62.A VDD.t310 sg13_lv_pmos ad=0.2128p pd=1.5u as=0.2128p ps=1.5u w=1.12u l=0.15u
X2237 VDD.t1138 clk a_12987_12214# VDD.t83 sg13_lv_pmos ad=0.2128p pd=1.5u as=0.2128p ps=1.5u w=1.12u l=0.13u
X2238 a_14328_7992# sg13cmos5l_nand2b_1_0.B VDD.t1346 VDD.t8 sg13_lv_pmos ad=0.2128p pd=1.5u as=0.3808p ps=2.92u w=1.12u l=0.15u
X2239 a_12662_7656# sg13cmos5l_nand2b_1_0.B sg13cmos5l_a22oi_1_2.Y VSS.t974 sg13_lv_nmos ad=0.13875p pd=1.115u as=0.2664p ps=1.46u w=0.74u l=0.13u
X2240 a_20026_15202# sg13cmos5l_dlygate4sd3_1_74.A VSS.t634 VSS.t392 sg13_lv_nmos ad=0.1428p pd=1.52u as=79.8f ps=0.8u w=0.42u l=0.13u
X2241 VDD.t1948 a_21839_11821# a_22506_11460# VDD.t0 sg13_lv_pmos ad=0.2128p pd=1.5u as=0.3864p ps=2.93u w=1.12u l=0.13u
X2242 a_15986_13730# sg13cmos5l_nand4_1_18.D VSS.t519 VSS.t128 sg13_lv_nmos ad=0.1406p pd=1.12u as=0.2516p ps=2.16u w=0.74u l=0.13u
X2243 sg13cmos5l_nor2_1_4.Y sg13cmos5l_a21oi_1_12.Y VSS.t839 VSS.t1340 sg13_lv_nmos ad=0.1406p pd=1.12u as=0.2516p ps=2.16u w=0.74u l=0.13u
X2244 a_10872_11016# sg13cmos5l_o21ai_1_5.A1 VDD.t1354 VDD.t0 sg13_lv_pmos ad=0.2128p pd=1.5u as=0.3808p ps=2.92u w=1.12u l=0.15u
X2245 VSS.t273 sg13cmos5l_buf_1_2.A sg13cmos5l_inv_1_3.Y VSS.t683 sg13_lv_nmos ad=0.2516p pd=2.16u as=0.2516p ps=2.16u w=0.74u l=0.13u
X2246 VDD.t792 a_15404_6888# sg13cmos5l_buf_1_13.A VDD.t2 sg13_lv_pmos ad=0.2114p pd=1.54u as=0.42p ps=2.99u w=1.12u l=0.13u
X2247 sg13cmos5l_nor3_1_2.B sg13cmos5l_a22oi_1_0.B2 a_13566_8412# VDD.t8 sg13_lv_pmos ad=0.2128p pd=1.5u as=0.2744p ps=1.61u w=1.12u l=0.13u
X2248 a_5880_15552# sg13cmos5l_buf_1_66.X VDD.t1230 VDD.t16 sg13_lv_pmos ad=0.2128p pd=1.5u as=0.3808p ps=2.92u w=1.12u l=0.15u
X2249 VSS.t362 sg13cmos5l_dfrbpq_1_13.RESET_B a_7428_10386# VSS.t1209 sg13_lv_nmos ad=0.1626p pd=1.415u as=60.89999f ps=0.71u w=0.42u l=0.13u
X2250 a_17015_9577# a_16319_9456# a_17109_9344# VSS.t2204 sg13_lv_nmos ad=0.1296p pd=1.52u as=79.8f ps=0.8u w=0.42u l=0.13u
X2251 a_22337_5760# sg13cmos5l_inv_1_6.Y sg13cmos5l_dlygate4sd3_1_2.A VSS.t10 sg13_lv_nmos ad=0.1406p pd=1.12u as=0.1406p ps=1.12u w=0.74u l=0.13u
X2252 a_16070_5850# sg13cmos5l_inv_1_8.Y VDD.t886 VDD.t5 sg13_lv_pmos ad=79.8f pd=0.8u as=0.1428p ps=1.52u w=0.42u l=0.13u
X2253 VSS.t825 sg13cmos5l_buf_1_13.A a_12938_5850# VSS.t2371 sg13_lv_nmos ad=79.8f pd=0.8u as=37.8f ps=0.6u w=0.42u l=0.13u
X2254 a_9636_5837# a_9348_5416# a_9574_5837# VSS.t2509 sg13_lv_nmos ad=0.1428p pd=1.52u as=37.8f ps=0.6u w=0.42u l=0.13u
X2255 sg13cmos5l_nand2b_1_4.B a_8118_7742# VDD.t2044 VDD.t8 sg13_lv_pmos ad=0.4256p pd=3u as=0.2254p ps=1.53u w=1.12u l=0.13u
X2256 sg13cmos5l_a21oi_1_10.A2 sg13cmos5l_nand2_1_6.A VDD.t2240 VDD.t8 sg13_lv_pmos ad=0.2128p pd=1.5u as=0.3808p ps=2.92u w=1.12u l=0.13u
X2257 a_9348_20088# a_9322_19993# VSS.t1130 VSS.t2513 sg13_lv_nmos ad=0.2516p pd=2.16u as=0.1626p ps=1.415u w=0.74u l=0.13u
X2258 a_10864_19990# sg13cmos5l_buf_1_15.A.t5 VDD.t270 VDD.t270 sg13_lv_pmos ad=79.8f pd=0.8u as=2.69447p ps=17.64u w=0.42u l=0.13u
X2259 VSS.t159 sg13cmos5l_dfrbpq_1_24.Q sg13cmos5l_nor4_1_2.Y VSS.t66 sg13_lv_nmos ad=0.23757p pd=2.16u as=0.1406p ps=1.12u w=0.74u l=0.13u
X2260 a_15170_13722# sg13cmos5l_buf_1_45.X.t1 VSS.t245 VSS.t928 sg13_lv_nmos ad=60.89999f pd=0.71u as=0.1626p ps=1.415u w=0.42u l=0.13u
X2261 VSS.t362 a_7726_10887# sg13cmos5l_dfrbpq_1_14.D VSS.t2481 sg13_lv_nmos ad=0.1426p pd=1.16u as=0.2516p ps=2.16u w=0.74u l=0.13u
X2262 VDD.t82 VSS.t2145 VDD.t31 VDD.t13 sg13_lv_pmos ad=0.19p pd=1.38u as=0 ps=0 w=1u l=1u
X2263 VSS.t2118 VDD.t2392 VSS.t2117 VSS.t2116 sg13_lv_nmos ad=0.1428p pd=1.52u as=0 ps=0 w=0.42u l=1u
X2264 a_13910_9194# sg13cmos5l_nand2_1_0.A a_13808_9194# VSS.t709 sg13_lv_nmos ad=0.1406p pd=1.12u as=0.1406p ps=1.12u w=0.74u l=0.13u
X2265 VDD.t634 VSS.t1862 VDD.t176 VDD.t2 sg13_lv_pmos ad=0.19p pd=1.38u as=0 ps=0 w=1u l=1u
X2266 a_22330_10666# sg13cmos5l_a21oi_1_6.Y VSS.t76 VSS.t75 sg13_lv_nmos ad=0.1428p pd=1.52u as=79.8f ps=0.8u w=0.42u l=0.13u
X2267 a_19534_4839# a_19649_4840# VSS.t273 VSS.t452 sg13_lv_nmos ad=0.1428p pd=1.52u as=0.1426p ps=1.16u w=0.42u l=0.5u
X2268 a_7941_19031# sg13cmos5l_dfrbpq_1_19.CLK VDD.t231 VDD.t231 sg13_lv_pmos ad=0.4088p pd=2.97u as=1.4953p ps=9.545u w=1.12u l=0.13u
X2269 VDD.t137 VSS.t1999 VDD.t136 VDD.t5 sg13_lv_pmos ad=0.34p pd=2.68u as=0 ps=0 w=1u l=1u
X2270 a_13738_17476# a_14181_17519# a_13478_17946# VSS.t627 sg13_lv_nmos ad=79.8f pd=0.8u as=0.1296p ps=1.52u w=0.42u l=0.13u
X2271 VSS.t132 a_19534_16263# sg13cmos5l_buf_1_53.A VSS.t1398 sg13_lv_nmos ad=0.1426p pd=1.16u as=0.2516p ps=2.16u w=0.74u l=0.13u
X2272 a_11269_7314# sg13cmos5l_a21oi_1_9.A2 a_11167_7314# VSS.t2332 sg13_lv_nmos ad=0.1216p pd=1.02u as=0.1216p ps=1.02u w=0.64u l=0.13u
X2273 VDD.t1254 sg13cmos5l_dfrbpq_1_28.RESET_B.t10 a_18730_17476# VDD.t310 sg13_lv_pmos ad=0.1563p pd=1.22u as=0.147p ps=1.54u w=0.42u l=0.13u
X2274 a_9190_15996# sg13cmos5l_a21oi_1_12.Y a_9096_15996# VDD.t16 sg13_lv_pmos ad=0.19p pd=1.38u as=0.34p ps=2.68u w=1u l=0.13u
X2275 VDD.t812 sg13cmos5l_buf_1_4.A a_20488_3176# VDD.t13 sg13_lv_pmos ad=0.2114p pd=1.54u as=0.2856p ps=2.36u w=0.84u l=0.13u
X2276 a_9040_19262# sg13cmos5l_dfrbpq_1_24.RESET_B VDD.t231 VDD.t231 sg13_lv_pmos ad=79.8f pd=0.8u as=1.4953p ps=9.545u w=0.42u l=0.13u
X2277 VDD.t76 VSS.t1784 VDD.t75 VDD.t0 sg13_lv_pmos ad=0.34p pd=2.68u as=0 ps=0 w=1u l=1u
X2278 VDD.t16 a_15280_16238# a_15225_16119# VDD.t16 sg13_lv_pmos ad=2.07625p pd=13.51u as=93.45f ps=0.865u w=0.42u l=0.13u
X2279 a_18970_14448# sg13cmos5l_dlygate4sd3_1_77.A VSS.t500 VSS.t432 sg13_lv_nmos ad=0.1428p pd=1.52u as=79.8f ps=0.8u w=0.42u l=0.13u
X2280 a_21839_4727# a_20997_4629# a_21745_4727# VSS.t42 sg13_lv_nmos ad=0.12665p pd=1.145u as=0.1428p ps=1.52u w=0.42u l=0.13u
X2281 a_18634_7897# a_19077_7653# a_18374_7674# VSS.t23 sg13_lv_nmos ad=79.8f pd=0.8u as=0.1296p ps=1.52u w=0.42u l=0.13u
X2282 sg13cmos5l_o21ai_1_17.Y sg13cmos5l_o21ai_1_17.B1 a_10774_17886# VSS.t952 sg13_lv_nmos ad=0.2516p pd=2.16u as=0.1406p ps=1.12u w=0.74u l=0.15u
X2283 VSS.t585 sg13cmos5l_o21ai_1_11.A2 a_6418_15230# VSS.t584 sg13_lv_nmos ad=0.1406p pd=1.12u as=0.1406p ps=1.12u w=0.74u l=0.15u
X2284 VSS.t172 sg13cmos5l_and2_1_3.X a_16840_12972# VSS.t128 sg13_lv_nmos ad=0.14875p pd=1.16u as=0.187p ps=1.78u w=0.55u l=0.13u
X2285 a_7332_19458# sg13cmos5l_dfrbpq_1_21.D a_7238_19458# VSS.t2421 sg13_lv_nmos ad=60.89999f pd=0.71u as=0.1428p ps=1.52u w=0.42u l=0.13u
X2286 a_17621_12972# sg13cmos5l_inv_1_12.Y VDD.t1073 VDD.t83 sg13_lv_pmos ad=0.2128p pd=1.5u as=0.2128p ps=1.5u w=1.12u l=0.13u
X2287 VDD.t78 VSS.t1784 VDD.t77 VDD.t52 sg13_lv_pmos ad=0.34p pd=2.68u as=0 ps=0 w=1u l=1u
X2288 VDD.t270 a_9765_19749# a_9867_19892# VDD.t270 sg13_lv_pmos ad=2.69447p pd=17.64u as=0.3864p ps=2.93u w=1.12u l=0.13u
X2289 a_17458_18258# sg13cmos5l_buf_1_45.X.t8 VSS.t922 VSS.t92 sg13_lv_nmos ad=37.8f pd=0.6u as=79.8f ps=0.8u w=0.42u l=0.13u
X2290 a_20626_5850# sg13cmos5l_buf_1_7.X VSS.t11 VSS.t10 sg13_lv_nmos ad=37.8f pd=0.6u as=79.8f ps=0.8u w=0.42u l=0.13u
X2291 VDD.t240 VSS.t1833 VDD.t239 VDD.t8 sg13_lv_pmos ad=0.19p pd=1.38u as=0 ps=0 w=1u l=1u
X2292 a_8719_5782# a_8637_5682# sg13cmos5l_a21oi_1_8.A1 VSS.t2589 sg13_lv_nmos ad=0.1406p pd=1.12u as=0.333p ps=2.38u w=0.74u l=0.13u
X2293 a_14548_12508# sg13cmos5l_a21oi_1_4.A1 VDD.t694 VDD.t83 sg13_lv_pmos ad=0.2128p pd=1.5u as=0.3808p ps=2.92u w=1.12u l=0.13u
X2294 a_22041_11583# a_21099_11471# a_21839_11821# VDD.t0 sg13_lv_pmos ad=93.45f pd=0.865u as=0.2048p ps=1.63u w=0.42u l=0.13u
X2295 a_22126_6351# a_22241_6352# VDD.t1166 VDD.t2 sg13_lv_pmos ad=0.34p pd=2.68u as=0.2254p ps=1.53u w=1u l=0.5u
X2296 VSS.t253 a_5829_7653# a_5931_7796# VSS.t2341 sg13_lv_nmos ad=4.7455p pd=30.71u as=0.2516p ps=2.16u w=0.74u l=0.13u
X2297 VSS.t206 sg13cmos5l_buf_1_13.A a_14390_5837# VSS.t2370 sg13_lv_nmos ad=0.1701p pd=1.65u as=37.8f ps=0.6u w=0.42u l=0.13u
X2298 VDD.t62 VSS.t1987 VDD.t60 VDD.t5 sg13_lv_pmos ad=0.19p pd=1.38u as=0 ps=0 w=1u l=1u
X2299 sg13cmos5l_dlygate4sd3_1_43.A sg13cmos5l_a22oi_1_1.B2 a_8671_7656# VSS.t84 sg13_lv_nmos ad=0.2664p pd=1.46u as=0.13875p ps=1.115u w=0.74u l=0.13u
X2300 VDD.t480 VSS.t850 VDD.t478 VDD.t13 sg13_lv_pmos ad=0.19p pd=1.38u as=0 ps=0 w=1u l=1u
X2301 a_8614_8436# sg13cmos5l_or4_1_0.D a_8520_8436# VDD.t8 sg13_lv_pmos ad=0.19p pd=1.38u as=0.34p ps=2.68u w=1u l=0.13u
X2302 sg13cmos5l_a21oi_1_20.A2 sg13cmos5l_nand4_1_5.D VDD.t961 VDD.t16 sg13_lv_pmos ad=0.2128p pd=1.5u as=0.3808p ps=2.92u w=1.12u l=0.13u
X2303 a_15012_6175# a_15243_6284# a_14698_6385# VSS.t205 sg13_lv_nmos ad=0.2373p pd=1.97u as=79.8f ps=0.8u w=0.42u l=0.13u
X2304 VDD.t1609 a_9070_18447# sg13cmos5l_dlygate4sd3_1_58.X VDD.t231 sg13_lv_pmos ad=0.2254p pd=1.53u as=0.4256p ps=3u w=1.12u l=0.13u
X2305 VSS.t1643 VDD.t2551 VSS.t1644 VSS.t1641 sg13_lv_nmos ad=79.8f pd=0.8u as=0 ps=0 w=0.42u l=1u
X2306 VSS.t407 a_6490_16714# a_6209_16936# VSS.t501 sg13_lv_nmos ad=79.8f pd=0.8u as=0.1428p ps=1.52u w=0.42u l=0.5u
X2307 VDD.t2053 sg13cmos5l_a21oi_1_27.B1 a_7907_15532# VDD.t16 sg13_lv_pmos ad=0.3808p pd=2.92u as=0.2464p ps=1.56u w=1.12u l=0.13u
X2308 VDD.t934 sg13cmos5l_mux2_1_0.S sg13cmos5l_a21oi_1_27.A1 VDD.t0 sg13_lv_pmos ad=0.2198p pd=1.53u as=0.2128p ps=1.5u w=1.12u l=0.13u
X2309 a_13575_13940# a_13727_13992# VSS.t948 VSS.t947 sg13_lv_nmos ad=0.2516p pd=2.16u as=6.29922p ps=42.355u w=0.74u l=0.13u
X2310 a_5604_12976# a_5578_12940# VDD.t1492 VDD.t83 sg13_lv_pmos ad=0.34p pd=2.68u as=0.36237p ps=2.605u w=1u l=0.13u
X2311 a_1690_9154# rst_n VSS.t89 VSS.t88 sg13_lv_nmos ad=0.1428p pd=1.52u as=79.8f ps=0.8u w=0.42u l=0.13u
X2312 VSS.t931 a_18095_19847# a_18762_20068# VSS.t2427 sg13_lv_nmos ad=0.1406p pd=1.12u as=0.2516p ps=2.16u w=0.74u l=0.13u
X2313 sg13cmos5l_o21ai_1_9.Y sg13cmos5l_o21ai_1_9.B1 VDD.t1061 VDD.t19 sg13_lv_pmos ad=0.2128p pd=1.5u as=0.3808p ps=2.92u w=1.12u l=0.15u
X2314 a_10833_14874# sg13cmos5l_and4_1_1.A VDD.t1054 VDD.t19 sg13_lv_pmos ad=0.1596p pd=1.22u as=0.2856p ps=2.36u w=0.84u l=0.13u
X2315 VDD.t2338 sg13cmos5l_dfrbpq_1_3.D a_17015_9577# VDD.t52 sg13_lv_pmos ad=0.1428p pd=1.52u as=79.8f ps=0.8u w=0.42u l=0.13u
X2316 VDD.t579 VSS.t2090 VDD.t300 VDD.t13 sg13_lv_pmos ad=0.19p pd=1.38u as=0 ps=0 w=1u l=1u
X2317 VSS.t2148 VDD.t2386 VSS.t2150 VSS.t2149 sg13_lv_nmos ad=79.8f pd=0.8u as=0 ps=0 w=0.42u l=1u
X2318 VSS.t407 a_6682_15960# a_6401_16262# VSS.t406 sg13_lv_nmos ad=79.8f pd=0.8u as=0.1428p ps=1.52u w=0.42u l=0.5u
X2319 a_5700_7687# a_5931_7796# a_5386_7897# VSS.t747 sg13_lv_nmos ad=0.2373p pd=1.97u as=79.8f ps=0.8u w=0.42u l=0.13u
X2320 sg13cmos5l_and2_1_3.X a_15597_12256# VSS.t222 VSS.t2326 sg13_lv_nmos ad=0.2516p pd=2.16u as=0.1331p ps=1.12u w=0.74u l=0.13u
X2321 a_21839_4727# a_20997_4629# a_20580_4968# VDD.t5 sg13_lv_pmos ad=0.2048p pd=1.63u as=0.34p ps=2.68u w=1u l=0.13u
X2322 a_11874_14484# sg13cmos5l_nor4_1_4.C a_11772_14484# VDD.t19 sg13_lv_pmos ad=0.2128p pd=1.5u as=0.2128p ps=1.5u w=1.12u l=0.13u
X2323 VSS.t2 a_7173_11471# a_7275_11471# VSS.t1 sg13_lv_nmos ad=4.7455p pd=30.71u as=0.2516p ps=2.16u w=0.74u l=0.13u
X2324 VDD.t504 VSS.t46 VDD.t503 VDD.t19 sg13_lv_pmos ad=0.34p pd=2.68u as=0 ps=0 w=1u l=1u
X2325 a_21839_13799# a_20997_13701# a_20580_14040# VDD.t19 sg13_lv_pmos ad=0.2048p pd=1.63u as=0.34p ps=2.68u w=1u l=0.13u
X2326 sg13cmos5l_buf_1_65.A a_7912_12972# VSS.t67 VSS.t149 sg13_lv_nmos ad=0.2886p pd=2.26u as=0.14875p ps=1.16u w=0.74u l=0.13u
X2327 a_9054_17874# sg13cmos5l_nand3b_1_1.C VSS.t56 VSS.t55 sg13_lv_nmos ad=0.1406p pd=1.12u as=0.18575p ps=1.26u w=0.74u l=0.13u
X2328 sg13cmos5l_nand4_1_17.Y sg13cmos5l_nand4_1_18.B VDD.t2047 VDD.t16 sg13_lv_pmos ad=0.2128p pd=1.5u as=0.2128p ps=1.5u w=1.12u l=0.13u
X2329 VDD.t740 a_13478_11460# a_13590_11484# VDD.t0 sg13_lv_pmos ad=0.2254p pd=1.53u as=0.34p ps=2.68u w=1u l=0.5u
X2330 VSS.t99 a_15790_7191# sg13cmos5l_a21oi_1_9.A2 VSS.t2260 sg13_lv_nmos ad=0.1426p pd=1.16u as=0.2516p ps=2.16u w=0.74u l=0.13u
X2331 VDD.t1536 sg13cmos5l_buf_1_15.A.t6 a_9322_19993# VDD.t270 sg13_lv_pmos ad=0.1563p pd=1.22u as=0.147p ps=1.54u w=0.42u l=0.13u
X2332 bn3 a_10696_15272# VDD.t1480 VDD.t16 sg13_lv_pmos ad=0.42p pd=2.99u as=0.2114p ps=1.54u w=1.12u l=0.13u
X2333 VSS.t887 a_21839_11821# a_22506_11460# VSS.t16 sg13_lv_nmos ad=0.1406p pd=1.12u as=0.2516p ps=2.16u w=0.74u l=0.13u
X2334 a_5124_9504# a_5098_9409# VSS.t1215 VSS.t88 sg13_lv_nmos ad=0.2516p pd=2.16u as=0.1626p ps=1.415u w=0.74u l=0.13u
X2335 VDD.t988 a_17098_6130# sg13cmos5l_inv_1_5.A VDD.t2 sg13_lv_pmos ad=0.2128p pd=1.5u as=0.2128p ps=1.5u w=1.12u l=0.13u
X2336 sg13cmos5l_o21ai_1_28.A1 sg13cmos5l_nand3b_1_1.C VDD.t387 VDD.t16 sg13_lv_pmos ad=0.3808p pd=2.92u as=0.3808p ps=2.92u w=1.12u l=0.13u
X2337 VDD.t698 sg13cmos5l_a21o_1_2.A1 a_7078_14044# VDD.t19 sg13_lv_pmos ad=0.19p pd=1.38u as=0.2125p ps=1.425u w=1u l=0.13u
X2338 VSS.t1742 VDD.t2508 VSS.t1741 VSS.t1740 sg13_lv_nmos ad=0.1428p pd=1.52u as=0 ps=0 w=0.42u l=1u
X2339 VSS.t380 sg13cmos5l_buf_1_45.X.t7 a_13572_17946# VSS.t932 sg13_lv_nmos ad=0.1626p pd=1.415u as=60.89999f ps=0.71u w=0.42u l=0.13u
X2340 VDD.t1325 a_21084_16710# a_22107_17137# VDD.t310 sg13_lv_pmos ad=0.1563p pd=1.22u as=63f ps=0.72u w=0.42u l=0.13u
X2341 a_1690_15202# start VDD.t746 VDD.t16 sg13_lv_pmos ad=0.1428p pd=1.52u as=0.1523p ps=1.38u w=0.42u l=0.13u
X2342 a_15790_7191# a_15905_7190# VDD.t2019 VDD.t2 sg13_lv_pmos ad=0.34p pd=2.68u as=0.2254p ps=1.53u w=1u l=0.5u
X2343 code7 a_4360_19808# VDD.t927 VDD.t270 sg13_lv_pmos ad=0.42p pd=2.99u as=0.2114p ps=1.54u w=1.12u l=0.13u
X2344 sg13cmos5l_a21oi_1_6.A2 sg13cmos5l_nand4_1_6.B VDD.t1707 VDD.t19 sg13_lv_pmos ad=0.2128p pd=1.5u as=0.2128p ps=1.5u w=1.12u l=0.13u
X2345 a_21839_10309# a_20997_9959# a_21745_10309# VSS.t546 sg13_lv_nmos ad=0.12665p pd=1.145u as=0.1428p ps=1.52u w=0.42u l=0.13u
X2346 a_6191_19381# a_5349_19031# a_4932_19024# VDD.t231 sg13_lv_pmos ad=0.2048p pd=1.63u as=0.34p ps=2.68u w=1u l=0.13u
X2347 VSS.t569 a_12826_9154# a_12545_9376# VSS.t2602 sg13_lv_nmos ad=79.8f pd=0.8u as=0.1428p ps=1.52u w=0.42u l=0.5u
X2348 VDD.t5 a_20464_5654# a_20409_5535# VDD.t5 sg13_lv_pmos ad=1.96072p pd=12.69u as=93.45f ps=0.865u w=0.42u l=0.13u
X2349 VDD.t206 VSS.t1215 VDD.t447 VDD.t8 sg13_lv_pmos ad=0.34p pd=2.68u as=0 ps=0 w=1u l=1u
X2350 sg13cmos5l_dfrbpq_1_13.CLK a_12987_10318# VDD.t1468 VDD.t52 sg13_lv_pmos ad=0.2128p pd=1.5u as=0.2128p ps=1.5u w=1.12u l=0.13u
X2351 VSS.t199 sg13cmos5l_buf_1_26.A a_10696_15272# VSS.t1104 sg13_lv_nmos ad=0.14875p pd=1.16u as=0.187p ps=1.78u w=0.55u l=0.13u
X2352 VDD.t466 VSS.t291 VDD.t464 VDD.t13 sg13_lv_pmos ad=0.19p pd=1.38u as=0 ps=0 w=1u l=1u
X2353 VDD.t1050 sg13cmos5l_inv_1_18.A sg13cmos5l_inv_1_18.Y VDD.t8 sg13_lv_pmos ad=0.3808p pd=2.92u as=0.3808p ps=2.92u w=1.12u l=0.13u
X2354 VDD.t826 a_22522_9154# a_22241_9376# VDD.t52 sg13_lv_pmos ad=0.1523p pd=1.38u as=0.34p ps=2.68u w=1u l=0.5u
X2355 VDD.t881 a_19054_18447# sg13cmos5l_dfrbpq_1_39.D VDD.t231 sg13_lv_pmos ad=0.2254p pd=1.53u as=0.4256p ps=3u w=1.12u l=0.13u
X2356 VSS.t1058 VDD.t2497 VSS.t1058 VSS.t1809 sg13_lv_nmos ad=79.8f pd=0.8u as=0 ps=0 w=0.42u l=1u
X2357 a_12844_5850# a_12631_5376# VDD.t5 VDD.t5 sg13_lv_pmos ad=79.8f pd=0.8u as=1.96072p ps=12.69u w=0.42u l=0.13u
X2358 sg13cmos5l_inv_1_5.A a_17098_6130# VDD.t984 VDD.t2 sg13_lv_pmos ad=0.2128p pd=1.5u as=0.2128p ps=1.5u w=1.12u l=0.13u
X2359 VDD.t1295 sg13cmos5l_buf_1_17.A a_1192_8436# VDD.t8 sg13_lv_pmos ad=0.2114p pd=1.54u as=0.2856p ps=2.36u w=0.84u l=0.13u
X2360 a_6286_8703# a_6401_8702# VSS.t260 VSS.t2417 sg13_lv_nmos ad=0.1428p pd=1.52u as=0.1426p ps=1.16u w=0.42u l=0.5u
X2361 a_18104_12218# sg13cmos5l_nand4_1_18.C a_18002_12218# VSS.t1228 sg13_lv_nmos ad=0.1406p pd=1.12u as=0.1406p ps=1.12u w=0.74u l=0.13u
X2362 VSS.t740 sg13cmos5l_o21ai_1_5.A1 a_10774_10694# VSS.t983 sg13_lv_nmos ad=0.1406p pd=1.12u as=0.2516p ps=2.16u w=0.74u l=0.15u
X2363 VDD.t759 sg13cmos5l_buf_1_21.A sg13cmos5l_nand3_1_1.Y VDD.t0 sg13_lv_pmos ad=0.2128p pd=1.5u as=0.2128p ps=1.5u w=1.12u l=0.13u
X2364 a_15023_17869# a_14181_17519# a_13764_17512# VDD.t310 sg13_lv_pmos ad=0.2048p pd=1.63u as=0.34p ps=2.68u w=1u l=0.13u
X2365 a_22258_13722# sg13cmos5l_dfrbpq_1_28.RESET_B.t3 VSS.t163 VSS.t869 sg13_lv_nmos ad=37.8f pd=0.6u as=79.8f ps=0.8u w=0.42u l=0.13u
X2366 VDD.t140 VSS.t2102 VDD.t220 VDD.t13 sg13_lv_pmos ad=0.34p pd=2.68u as=0 ps=0 w=1u l=1u
X2367 a_18886_7687# sg13cmos5l_buf_1_7.X VSS.t19 VSS.t23 sg13_lv_nmos ad=37.8f pd=0.6u as=0.1701p ps=1.65u w=0.42u l=0.13u
X2368 a_15694_7674# a_15436_7674# VSS.t99 VSS.t883 sg13_lv_nmos ad=0.1428p pd=1.52u as=79.8f ps=0.8u w=0.42u l=0.13u
X2369 VDD.t1509 a_3996_16710# a_5019_17137# VDD.t310 sg13_lv_pmos ad=0.1563p pd=1.22u as=63f ps=0.72u w=0.42u l=0.13u
X2370 VSS.t48 sg13cmos5l_nand2_1_11.B a_9096_15996# VSS.t1322 sg13_lv_nmos ad=0.16755p pd=1.165u as=0.1045p ps=0.93u w=0.55u l=0.13u
X2371 VSS.t222 sg13cmos5l_nor3_1_0.Y a_15499_11808# VSS.t721 sg13_lv_nmos ad=0.1331p pd=1.12u as=0.1216p ps=1.02u w=0.64u l=0.13u
X2372 VDD.t1466 a_12987_10318# sg13cmos5l_dfrbpq_1_13.CLK VDD.t52 sg13_lv_pmos ad=0.2128p pd=1.5u as=0.2128p ps=1.5u w=1.12u l=0.13u
X2373 VDD.t1454 a_20384_16921# sg13cmos5l_dlygate4sd3_1_74.A VDD.t310 sg13_lv_pmos ad=0.2128p pd=1.5u as=0.3808p ps=2.92u w=1.12u l=0.13u
X2374 VSS.t245 sg13cmos5l_buf_1_45.X.t1 a_14774_13735# VSS.t929 sg13_lv_nmos ad=0.1701p pd=1.65u as=37.8f ps=0.6u w=0.42u l=0.13u
X2375 VDD.t35 VSS.t1981 VDD.t34 VDD.t5 sg13_lv_pmos ad=0.19p pd=1.38u as=0 ps=0 w=1u l=1u
X2376 VSS.t1885 VDD.t2462 VSS.t1884 VSS.t1897 sg13_lv_nmos ad=0.1428p pd=1.52u as=0 ps=0 w=0.42u l=1u
X2377 VSS.t58 a_10118_18262# a_10230_18326# VSS.t185 sg13_lv_nmos ad=0.1426p pd=1.16u as=0.1428p ps=1.52u w=0.42u l=0.5u
X2378 VSS.t2123 VDD.t2391 VSS.t2122 VSS.t2121 sg13_lv_nmos ad=0.1428p pd=1.52u as=0 ps=0 w=0.42u l=1u
X2379 a_17098_6130# sg13cmos5l_buf_8_2.A.t1 VSS.t39 VSS.t285 sg13_lv_nmos ad=0.2553p pd=2.17u as=0.1406p ps=1.12u w=0.74u l=0.13u
X2380 a_15436_7674# a_15223_7638# VDD.t8 VDD.t8 sg13_lv_pmos ad=79.8f pd=0.8u as=1.8716p ps=12.115u w=0.42u l=0.13u
X2381 a_22258_8874# sg13cmos5l_buf_1_7.X VSS.t15 VSS.t14 sg13_lv_nmos ad=37.8f pd=0.6u as=79.8f ps=0.8u w=0.42u l=0.13u
X2382 sg13cmos5l_dfrbpq_1_19.CLK a_7498_18226# VSS.t5 VSS.t2271 sg13_lv_nmos ad=0.1406p pd=1.12u as=0.1406p ps=1.12u w=0.74u l=0.13u
X2383 VDD.t8 a_5829_7653# a_5931_7796# VDD.t8 sg13_lv_pmos ad=1.8716p pd=12.115u as=0.3864p ps=2.93u w=1.12u l=0.13u
X2384 a_18778_6130# sg13cmos5l_dlygate4sd3_1_29.A VDD.t781 VDD.t2 sg13_lv_pmos ad=0.1428p pd=1.52u as=0.1523p ps=1.38u w=0.42u l=0.13u
X2385 VDD.t788 sg13cmos5l_buf_1_9.A sg13cmos5l_inv_1_9.Y VDD.t8 sg13_lv_pmos ad=0.3808p pd=2.92u as=0.3808p ps=2.92u w=1.12u l=0.13u
X2386 a_16469_14484# sg13cmos5l_inv_1_16.Y VDD.t685 VDD.t19 sg13_lv_pmos ad=0.2128p pd=1.5u as=0.2128p ps=1.5u w=1.12u l=0.13u
X2387 a_13486_14037# a_13228_13722# VDD.t19 VDD.t19 sg13_lv_pmos ad=93.45f pd=0.865u as=2.1916p ps=14.26u w=0.42u l=0.13u
X2388 VSS.t81 a_16454_8436# a_16566_8460# VSS.t1007 sg13_lv_nmos ad=0.1426p pd=1.16u as=0.1428p ps=1.52u w=0.42u l=0.5u
X2389 VDD.t13 VSS.t2075 VDD.t13 VDD.t13 sg13_lv_pmos ad=0.19p pd=1.38u as=0 ps=0 w=1u l=1u
X2390 VSS.t2133 VDD.t2389 VSS.t2135 VSS.t2134 sg13_lv_nmos ad=79.8f pd=0.8u as=0 ps=0 w=0.42u l=1u
X2391 a_10694_18258# a_11499_18380# a_10954_18481# VDD.t231 sg13_lv_pmos ad=0.1428p pd=1.52u as=79.8f ps=0.8u w=0.42u l=0.13u
X2392 a_12694_16742# sg13cmos5l_nor2_1_16.Y VSS.t52 VSS.t431 sg13_lv_nmos ad=0.1406p pd=1.12u as=0.1406p ps=1.12u w=0.74u l=0.15u
X2393 a_12987_10318# sg13cmos5l_buf_8_2.A VDD.t1260 VDD.t52 sg13_lv_pmos ad=0.2128p pd=1.5u as=0.2128p ps=1.5u w=1.12u l=0.13u
X2394 a_5028_14909# a_4740_14488# a_4966_14909# VSS.t1308 sg13_lv_nmos ad=0.1428p pd=1.52u as=37.8f ps=0.6u w=0.42u l=0.13u
X2395 VDD.t1187 sg13cmos5l_dfrbpq_1_13.RESET_B a_7594_9916# VDD.t52 sg13_lv_pmos ad=0.1563p pd=1.22u as=0.147p ps=1.54u w=0.42u l=0.13u
X2396 VSS.t11 a_19246_6351# sg13cmos5l_dfrbpq_1_1.D VSS.t694 sg13_lv_nmos ad=0.1426p pd=1.16u as=0.2516p ps=2.16u w=0.74u l=0.13u
X2397 a_18575_8797# a_17733_8447# a_17316_8440# VDD.t8 sg13_lv_pmos ad=0.2048p pd=1.63u as=0.34p ps=2.68u w=1u l=0.13u
X2398 VDD.t1010 sg13cmos5l_inv_1_0.A sg13cmos5l_inv_1_0.Y VDD.t13 sg13_lv_pmos ad=0.3808p pd=2.92u as=0.3808p ps=2.92u w=1.12u l=0.13u
X2399 VDD.t893 sg13cmos5l_buf_1_45.X.t11 a_12394_18988# VDD.t231 sg13_lv_pmos ad=0.1563p pd=1.22u as=0.147p ps=1.54u w=0.42u l=0.13u
X2400 a_11770_17472# sg13cmos5l_dlygate4sd3_1_69.A VDD.t860 VDD.t310 sg13_lv_pmos ad=0.1428p pd=1.52u as=0.1523p ps=1.38u w=0.42u l=0.13u
X2401 a_20974_16746# a_20716_16746# VSS.t863 VSS.t1191 sg13_lv_nmos ad=0.1428p pd=1.52u as=79.8f ps=0.8u w=0.42u l=0.13u
X2402 VSS.t1742 VDD.t2519 VSS.t1741 VSS.t1740 sg13_lv_nmos ad=0.1428p pd=1.52u as=0 ps=0 w=0.42u l=1u
X2403 sg13cmos5l_inv_1_5.A a_17098_6130# VDD.t981 VDD.t2 sg13_lv_pmos ad=0.2128p pd=1.5u as=0.3864p ps=2.93u w=1.12u l=0.13u
X2404 VSS.t26 sg13cmos5l_a21oi_1_2.B1 sg13cmos5l_dlygate4sd3_1_29.A VSS.t900 sg13_lv_nmos ad=0.2516p pd=2.16u as=0.1406p ps=1.12u w=0.74u l=0.13u
X2405 sg13cmos5l_dfrbpq_1_40.Q a_18762_20068# VDD.t1413 VDD.t270 sg13_lv_pmos ad=0.3808p pd=2.92u as=0.2128p ps=1.5u w=1.12u l=0.13u
X2406 sg13cmos5l_dfrbpq_1_35.Q a_20682_19020# VDD.t1475 VDD.t231 sg13_lv_pmos ad=0.3808p pd=2.92u as=0.2128p ps=1.5u w=1.12u l=0.13u
X2407 VDD.t874 a_3296_16921# sg13cmos5l_dfrbpq_1_23.Q VDD.t310 sg13_lv_pmos ad=0.2128p pd=1.5u as=0.3808p ps=2.92u w=1.12u l=0.13u
X2408 a_19534_13239# a_19649_13238# VSS.t949 VSS.t128 sg13_lv_nmos ad=0.1428p pd=1.52u as=0.1426p ps=1.16u w=0.42u l=0.5u
X2409 a_20997_12189# sg13cmos5l_dfrbpq_1_5.CLK VSS.t2 VSS.t1562 sg13_lv_nmos ad=0.2516p pd=2.16u as=4.21822p ps=27.295u w=0.74u l=0.13u
X2410 VDD.t309 VSS.t1620 VDD.t426 VDD.t231 sg13_lv_pmos ad=0.19p pd=1.38u as=0 ps=0 w=1u l=1u
X2411 a_12120_8416# sg13cmos5l_nor4_1_0.C VDD.t1974 VDD.t8 sg13_lv_pmos ad=0.2128p pd=1.5u as=0.3808p ps=2.92u w=1.12u l=0.15u
X2412 a_22522_17472# sg13cmos5l_dfrbpq_1_29.Q VSS.t455 VSS.t140 sg13_lv_nmos ad=0.1428p pd=1.52u as=79.8f ps=0.8u w=0.42u l=0.13u
X2413 sg13cmos5l_nor2_1_6.Y sg13cmos5l_a21oi_1_27.B1 VSS.t1498 VSS.t2287 sg13_lv_nmos ad=0.1406p pd=1.12u as=0.2516p ps=2.16u w=0.74u l=0.13u
X2414 VDD.t83 a_21839_12287# a_22096_12430# VDD.t83 sg13_lv_pmos ad=2.51485p pd=16.46u as=79.8f ps=0.8u w=0.42u l=0.13u
X2415 VSS.t1870 VDD.t2465 VSS.t1869 VSS.t1868 sg13_lv_nmos ad=0.1428p pd=1.52u as=0 ps=0 w=0.42u l=1u
X2416 a_1690_19738# comp VDD.t1243 VDD.t270 sg13_lv_pmos ad=0.1428p pd=1.52u as=0.1523p ps=1.38u w=0.42u l=0.13u
X2417 sg13cmos5l_a21oi_1_21.A1 sg13cmos5l_buf_1_63.A VDD.t2068 VDD.t270 sg13_lv_pmos ad=0.3808p pd=2.92u as=0.3808p ps=2.92u w=1.12u l=0.13u
X2418 VSS.t850 VDD.t2398 VSS.t850 VSS.t2065 sg13_lv_nmos ad=0.1428p pd=1.52u as=0 ps=0 w=0.42u l=1u
X2419 a_14542_7191# a_14657_7190# VSS.t99 VSS.t768 sg13_lv_nmos ad=0.1428p pd=1.52u as=0.1426p ps=1.16u w=0.42u l=0.5u
X2420 VSS.t199 sg13cmos5l_nor4_1_1.D a_11131_14874# VSS.t1473 sg13_lv_nmos ad=0.1447p pd=1.15u as=0.1408p ps=1.08u w=0.64u l=0.13u
X2421 VDD.t52 sg13cmos5l_buf_1_13.A a_15820_9186# VDD.t52 sg13_lv_pmos ad=1.8716p pd=12.115u as=79.8f ps=0.8u w=0.42u l=0.13u
X2422 VDD.t239 VSS.t1830 VDD.t248 VDD.t8 sg13_lv_pmos ad=0.34p pd=2.68u as=0 ps=0 w=1u l=1u
X2423 VDD.t1122 sg13cmos5l_buf_1_30.A a_1192_19020# VDD.t231 sg13_lv_pmos ad=0.2114p pd=1.54u as=0.2856p ps=2.36u w=0.84u l=0.13u
X2424 a_19630_15423# a_19745_15424# VDD.t969 VDD.t16 sg13_lv_pmos ad=0.34p pd=2.68u as=0.2254p ps=1.53u w=1u l=0.5u
X2425 VSS.t74 a_8411_12252# a_8848_12214# VSS.t615 sg13_lv_nmos ad=0.148p pd=1.14u as=0.3367p ps=1.65u w=0.74u l=0.13u
X2426 a_7498_18226# sg13cmos5l_buf_8_2.A.t7 VDD.t1741 VDD.t231 sg13_lv_pmos ad=0.3808p pd=2.92u as=0.2128p ps=1.5u w=1.12u l=0.13u
X2427 a_14470_19783# sg13cmos5l_buf_1_45.X.t15 VSS.t420 VSS.t419 sg13_lv_nmos ad=37.8f pd=0.6u as=0.1701p ps=1.65u w=0.42u l=0.13u
X2428 VDD.t989 a_15214_10215# sg13cmos5l_o21ai_1_3.A2 VDD.t52 sg13_lv_pmos ad=0.2254p pd=1.53u as=0.4256p ps=3u w=1.12u l=0.13u
X2429 a_11314_12210# sg13cmos5l_dfrbpq_1_13.RESET_B VSS.t1206 VSS.t1205 sg13_lv_nmos ad=37.8f pd=0.6u as=79.8f ps=0.8u w=0.42u l=0.13u
X2430 a_5098_9409# a_5541_9165# a_5481_9577# VDD.t52 sg13_lv_pmos ad=79.8f pd=0.8u as=63f ps=0.72u w=0.42u l=0.13u
X2431 VSS.t400 a_1294_19959# sg13cmos5l_buf_1_30.A VSS.t399 sg13_lv_nmos ad=0.1426p pd=1.16u as=0.2516p ps=2.16u w=0.74u l=0.13u
X2432 bn6 a_14152_14484# VDD.t753 VDD.t19 sg13_lv_pmos ad=0.42p pd=2.99u as=0.2114p ps=1.54u w=1.12u l=0.13u
X2433 VDD.t231 a_12239_18335# a_12496_18478# VDD.t231 sg13_lv_pmos ad=1.54512p pd=9.865u as=79.8f ps=0.8u w=0.42u l=0.13u
X2434 sg13cmos5l_and2_1_5.X a_15405_11808# VDD.t790 VDD.t0 sg13_lv_pmos ad=0.3808p pd=2.92u as=0.1918p ps=1.5u w=1.12u l=0.13u
X2435 VDD.t1166 a_22126_6351# sg13cmos5l_buf_1_4.A VDD.t2 sg13_lv_pmos ad=0.2254p pd=1.53u as=0.4256p ps=3u w=1.12u l=0.13u
X2436 a_9967_7294# a_9885_7194# sg13cmos5l_a21oi_1_10.A1 VSS.t2489 sg13_lv_nmos ad=0.1406p pd=1.12u as=0.333p ps=2.38u w=0.74u l=0.13u
X2437 VSS.t2183 VDD.t2379 VSS.t2182 VSS.t2181 sg13_lv_nmos ad=0.1428p pd=1.52u as=0 ps=0 w=0.42u l=1u
X2438 a_1294_15423# a_1409_15424# VDD.t1059 VDD.t16 sg13_lv_pmos ad=0.34p pd=2.68u as=0.2254p ps=1.53u w=1u l=0.5u
X2439 VDD.t300 VSS.t2087 VDD.t299 VDD.t13 sg13_lv_pmos ad=0.34p pd=2.68u as=0 ps=0 w=1u l=1u
X2440 a_3200_16283# a_3319_15960# VSS.t309 VSS.t227 sg13_lv_nmos ad=0.2516p pd=2.16u as=0.1406p ps=1.12u w=0.74u l=0.13u
X2441 a_12896_13897# a_13015_13686# VDD.t700 VDD.t19 sg13_lv_pmos ad=0.3864p pd=2.93u as=0.2128p ps=1.5u w=1.12u l=0.13u
X2442 sg13cmos5l_buf_1_16.A a_19048_12248# VDD.t1368 VDD.t83 sg13_lv_pmos ad=0.42p pd=2.99u as=0.2114p ps=1.54u w=1.12u l=0.13u
X2443 a_18478_10215# a_18593_10214# VSS.t161 VSS.t885 sg13_lv_nmos ad=0.1428p pd=1.52u as=0.1426p ps=1.16u w=0.42u l=0.5u
X2444 a_22258_4650# sg13cmos5l_buf_1_7.X VSS.t22 VSS.t42 sg13_lv_nmos ad=37.8f pd=0.6u as=79.8f ps=0.8u w=0.42u l=0.13u
X2445 a_15494_18258# sg13cmos5l_dfrbpq_1_33.D VDD.t1776 VDD.t231 sg13_lv_pmos ad=79.8f pd=0.8u as=0.1428p ps=1.52u w=0.42u l=0.13u
X2446 a_18544_15454# sg13cmos5l_dfrbpq_1_28.RESET_B VDD.t16 VDD.t16 sg13_lv_pmos ad=79.8f pd=0.8u as=2.07625p ps=13.51u w=0.42u l=0.13u
X2447 VSS.t196 a_10316_12936# sg13cmos5l_mux2_1_1.A1 VSS.t149 sg13_lv_nmos ad=0.14875p pd=1.16u as=0.2886p ps=2.26u w=0.74u l=0.13u
X2448 VDD.t2171 a_6490_19738# a_6209_19960# VDD.t270 sg13_lv_pmos ad=0.1523p pd=1.38u as=0.34p ps=2.68u w=1u l=0.5u
X2449 a_4220_17488# sg13cmos5l_nand3_1_5.Y sg13cmos5l_o21ai_1_20.Y VDD.t310 sg13_lv_pmos ad=0.2128p pd=1.5u as=0.2128p ps=1.5u w=1.12u l=0.15u
X2450 a_18094_9375# a_18209_9376# VSS.t545 VSS.t544 sg13_lv_nmos ad=0.1428p pd=1.52u as=0.1426p ps=1.16u w=0.42u l=0.5u
X2451 sg13cmos5l_dfrbpq_1_6.D a_19542_9254# VSS.t83 VSS.t2560 sg13_lv_nmos ad=0.2516p pd=2.16u as=0.1426p ps=1.16u w=0.74u l=0.13u
X2452 VDD.t1602 a_21531_13342# sg13cmos5l_dfrbpq_1_5.CLK VDD.t83 sg13_lv_pmos ad=0.2128p pd=1.5u as=0.2128p ps=1.5u w=1.12u l=0.13u
X2453 bp3 a_21256_3176# VSS.t762 VSS.t2262 sg13_lv_nmos ad=0.2886p pd=2.26u as=0.14875p ps=1.16u w=0.74u l=0.13u
X2454 a_7750_19445# sg13cmos5l_dfrbpq_1_24.RESET_B VSS.t1127 VSS.t1126 sg13_lv_nmos ad=37.8f pd=0.6u as=0.1701p ps=1.65u w=0.42u l=0.13u
X2455 VDD.t1793 a_14218_18226# sg13cmos5l_dfrbpq_1_41.CLK VDD.t231 sg13_lv_pmos ad=0.2128p pd=1.5u as=0.2128p ps=1.5u w=1.12u l=0.13u
X2456 VDD.t1450 sg13cmos5l_nand3b_1_3.C a_14957_15532# VDD.t16 sg13_lv_pmos ad=0.3822p pd=1.84u as=0.1575p ps=1.315u w=1u l=0.13u
X2457 VDD.t780 a_13786_7642# a_13505_7864# VDD.t8 sg13_lv_pmos ad=0.1523p pd=1.38u as=0.34p ps=2.68u w=1u l=0.5u
X2458 a_12708_19445# a_12939_19031# a_12394_18988# VSS.t2534 sg13_lv_nmos ad=0.2373p pd=1.97u as=79.8f ps=0.8u w=0.42u l=0.13u
X2459 sg13cmos5l_dfrbpq_1_44.Q a_14346_19020# VSS.t420 VSS.t2516 sg13_lv_nmos ad=0.2516p pd=2.16u as=0.1406p ps=1.12u w=0.74u l=0.13u
X2460 a_21911_17137# sg13cmos5l_dfrbpq_1_28.RESET_B.t7 VDD.t1102 VDD.t310 sg13_lv_pmos ad=79.8f pd=0.8u as=0.36237p ps=2.605u w=0.42u l=0.13u
X2461 VDD.t1964 a_19342_10215# sg13cmos5l_buf_1_5.A VDD.t52 sg13_lv_pmos ad=0.2254p pd=1.53u as=0.4256p ps=3u w=1.12u l=0.13u
X2462 a_11840_9389# sg13cmos5l_o21ai_1_1.B1 a_11977_9232# VSS.t1466 sg13_lv_nmos ad=0.2176p pd=1.96u as=0.1216p ps=1.02u w=0.64u l=0.13u
X2463 a_20716_18258# a_20503_18222# VDD.t231 VDD.t231 sg13_lv_pmos ad=79.8f pd=0.8u as=1.54512p ps=9.865u w=0.42u l=0.13u
X2464 a_15983_6239# a_15141_6141# a_15889_6239# VSS.t2540 sg13_lv_nmos ad=0.12665p pd=1.145u as=0.1428p ps=1.52u w=0.42u l=0.13u
X2465 VSS.t7 sg13cmos5l_nor3_1_7.Y a_19048_12248# VSS.t999 sg13_lv_nmos ad=0.14875p pd=1.16u as=0.187p ps=1.78u w=0.55u l=0.13u
X2466 VSS.t56 sg13cmos5l_dlygate4sd3_1_65.A a_9464_17549# VSS.t1156 sg13_lv_nmos ad=79.8f pd=0.8u as=0.1428p ps=1.52u w=0.42u l=0.13u
X2467 a_16385_17856# sg13cmos5l_a21oi_1_26.A1 sg13cmos5l_a21oi_1_26.Y VSS.t183 sg13_lv_nmos ad=0.1406p pd=1.12u as=0.1406p ps=1.12u w=0.74u l=0.13u
X2468 sg13cmos5l_dfrbpq_1_15.CLK a_6442_10666# VSS.t362 VSS.t2402 sg13_lv_nmos ad=0.1406p pd=1.12u as=0.1406p ps=1.12u w=0.74u l=0.13u
X2469 a_21934_10887# a_22049_10888# VDD.t649 VDD.t0 sg13_lv_pmos ad=0.34p pd=2.68u as=0.2254p ps=1.53u w=1u l=0.5u
X2470 VDD.t8 a_22096_8678# a_22041_8559# VDD.t8 sg13_lv_pmos ad=1.8716p pd=12.115u as=93.45f ps=0.865u w=0.42u l=0.13u
X2471 sg13cmos5l_nand4_1_15.B sg13cmos5l_nor3_1_4.A VSS.t196 VSS.t66 sg13_lv_nmos ad=0.1406p pd=1.12u as=0.2516p ps=2.16u w=0.74u l=0.13u
X2472 VSS.t107 a_12814_19959# sg13cmos5l_o21ai_1_17.B1 VSS.t2295 sg13_lv_nmos ad=0.1426p pd=1.16u as=0.2516p ps=2.16u w=0.74u l=0.13u
X2473 VSS.t468 VDD.t2563 VSS.t468 VSS.t1607 sg13_lv_nmos ad=0.1428p pd=1.52u as=0 ps=0 w=0.42u l=1u
X2474 VDD.t146 VSS.t2107 VDD.t413 VDD.t13 sg13_lv_pmos ad=0.34p pd=2.68u as=0 ps=0 w=1u l=1u
X2475 sg13cmos5l_a21oi_1_24.A2 sg13cmos5l_buf_1_42.A VDD.t1589 VDD.t310 sg13_lv_pmos ad=0.2128p pd=1.5u as=0.3808p ps=2.92u w=1.12u l=0.13u
X2476 a_20554_8404# a_20997_8447# a_20937_8483# VDD.t8 sg13_lv_pmos ad=79.8f pd=0.8u as=63f ps=0.72u w=0.42u l=0.13u
X2477 VDD.t1578 sg13cmos5l_a21oi_1_6.A2 a_19829_8436# VDD.t8 sg13_lv_pmos ad=0.2128p pd=1.5u as=0.3808p ps=2.92u w=1.12u l=0.13u
X2478 VDD.t1273 a_19919_10775# a_20586_10996# VDD.t0 sg13_lv_pmos ad=0.2128p pd=1.5u as=0.3864p ps=2.93u w=1.12u l=0.13u
X2479 a_13749_9386# sg13cmos5l_inv_1_18.A VSS.t97 VSS.t612 sg13_lv_nmos ad=0.187p pd=1.78u as=0.18575p ps=1.26u w=0.55u l=0.13u
X2480 VSS.t1124 sg13cmos5l_dfrbpq_1_24.RESET_B a_5654_18271# VSS.t1110 sg13_lv_nmos ad=0.1701p pd=1.65u as=37.8f ps=0.6u w=0.42u l=0.13u
X2481 a_13764_16000# a_13738_15964# VSS.t204 VSS.t783 sg13_lv_nmos ad=0.2516p pd=2.16u as=0.1626p ps=1.415u w=0.74u l=0.13u
X2482 a_21911_16043# sg13cmos5l_dfrbpq_1_30.D a_22658_16434# VSS.t588 sg13_lv_nmos ad=0.1428p pd=1.52u as=60.89999f ps=0.71u w=0.42u l=0.13u
X2483 a_19550_13730# sg13cmos5l_nor3_1_6.Y a_19448_13730# VSS.t128 sg13_lv_nmos ad=0.1406p pd=1.12u as=0.1406p ps=1.12u w=0.74u l=0.13u
X2484 a_15214_10215# a_15329_10214# VDD.t989 VDD.t52 sg13_lv_pmos ad=0.34p pd=2.68u as=0.2254p ps=1.53u w=1u l=0.5u
X2485 VDD.t235 VSS.t997 VDD.t234 VDD.t231 sg13_lv_pmos ad=0.34p pd=2.68u as=0 ps=0 w=1u l=1u
X2486 VSS.t831 a_22005_18416# a_21084_18222# VSS.t140 sg13_lv_nmos ad=0.1626p pd=1.415u as=0.2516p ps=2.16u w=0.74u l=0.13u
X2487 VSS.t134 sg13cmos5l_a21oi_1_19.A2 a_17153_16344# VSS.t133 sg13_lv_nmos ad=0.2516p pd=2.16u as=0.1406p ps=1.12u w=0.74u l=0.13u
X2488 VSS.t519 sg13cmos5l_buf_1_42.A a_15976_12972# VSS.t128 sg13_lv_nmos ad=0.14875p pd=1.16u as=0.187p ps=1.78u w=0.55u l=0.13u
X2489 VDD.t39 VSS.t1981 VDD.t37 VDD.t5 sg13_lv_pmos ad=0.19p pd=1.38u as=0 ps=0 w=1u l=1u
X2490 a_9062_19770# sg13cmos5l_dlygate4sd3_1_58.X VDD.t2045 VDD.t270 sg13_lv_pmos ad=79.8f pd=0.8u as=0.1428p ps=1.52u w=0.42u l=0.13u
X2491 VDD.t1757 sg13cmos5l_dfrbpq_1_28.RESET_B.t14 a_18470_19458# VDD.t231 sg13_lv_pmos ad=0.36237p pd=2.605u as=79.8f ps=0.8u w=0.42u l=0.13u
X2492 VDD.t96 VSS.t2010 VDD.t94 VDD.t13 sg13_lv_pmos ad=0.19p pd=1.38u as=0 ps=0 w=1u l=1u
X2493 VSS.t2128 VDD.t2390 VSS.t2127 VSS.t2126 sg13_lv_nmos ad=0.1428p pd=1.52u as=0 ps=0 w=0.42u l=1u
X2494 a_17244_16754# sg13cmos5l_nor4_1_2.Y a_17142_16754# VSS.t1279 sg13_lv_nmos ad=0.1406p pd=1.12u as=0.1406p ps=1.12u w=0.74u l=0.13u
X2495 a_11097_12525# a_10155_12332# a_10895_12287# VDD.t83 sg13_lv_pmos ad=93.45f pd=0.865u as=0.2048p ps=1.63u w=0.42u l=0.13u
X2496 a_15442_16434# sg13cmos5l_buf_1_45.X.t4 VSS.t373 VSS.t923 sg13_lv_nmos ad=37.8f pd=0.6u as=79.8f ps=0.8u w=0.42u l=0.13u
X2497 a_2156_19734# sg13cmos5l_dlygate4sd3_1_64.X VSS.t997 VSS.t996 sg13_lv_nmos ad=0.187p pd=1.78u as=0.14875p ps=1.16u w=0.55u l=0.13u
X2498 a_6094_19959# a_6209_19960# VSS.t369 VSS.t2470 sg13_lv_nmos ad=0.1428p pd=1.52u as=0.1426p ps=1.16u w=0.42u l=0.5u
X2499 a_19246_19959# a_19361_19960# VSS.t931 VSS.t1417 sg13_lv_nmos ad=0.1428p pd=1.52u as=0.1426p ps=1.16u w=0.42u l=0.5u
X2500 VDD.t1789 a_14218_18226# sg13cmos5l_dfrbpq_1_41.CLK VDD.t231 sg13_lv_pmos ad=0.2128p pd=1.5u as=0.2128p ps=1.5u w=1.12u l=0.13u
X2501 a_4823_17137# sg13cmos5l_dfrbpq_1_24.RESET_B VDD.t1510 VDD.t310 sg13_lv_pmos ad=79.8f pd=0.8u as=0.36237p ps=2.605u w=0.42u l=0.13u
X2502 sg13cmos5l_nand4_1_6.B sg13cmos5l_nor3_1_4.A VSS.t199 VSS.t651 sg13_lv_nmos ad=0.1406p pd=1.12u as=0.2516p ps=2.16u w=0.74u l=0.13u
X2503 VDD.t1598 a_21531_13342# sg13cmos5l_dfrbpq_1_5.CLK VDD.t83 sg13_lv_pmos ad=0.2128p pd=1.5u as=0.2128p ps=1.5u w=1.12u l=0.13u
X2504 a_20580_6928# a_20554_6892# VDD.t364 VDD.t2 sg13_lv_pmos ad=0.34p pd=2.68u as=0.36237p ps=2.605u w=1u l=0.13u
X2505 a_20868_7349# a_21099_6935# a_20554_6892# VSS.t282 sg13_lv_nmos ad=0.2373p pd=1.97u as=79.8f ps=0.8u w=0.42u l=0.13u
X2506 a_12420_19024# a_12939_19031# a_13679_19381# VSS.t2535 sg13_lv_nmos ad=0.3473p pd=2.71u as=0.12665p ps=1.145u w=0.74u l=0.13u
X2507 sg13cmos5l_nor3_1_2.C sg13cmos5l_dfrbpq_1_15.Q VDD.t1183 VDD.t8 sg13_lv_pmos ad=0.2128p pd=1.5u as=0.3808p ps=2.92u w=1.12u l=0.13u
X2508 VSS.t1646 VDD.t2550 VSS.t1647 VSS.t1641 sg13_lv_nmos ad=79.8f pd=0.8u as=0 ps=0 w=0.42u l=1u
X2509 sg13cmos5l_dfrbpq_1_15.CLK a_6442_10666# VDD.t2155 VDD.t0 sg13_lv_pmos ad=0.2128p pd=1.5u as=0.2128p ps=1.5u w=1.12u l=0.13u
X2510 sg13cmos5l_nand2_1_13.Y sg13cmos5l_nand2_1_13.A VDD.t1284 VDD.t83 sg13_lv_pmos ad=0.2128p pd=1.5u as=0.3808p ps=2.92u w=1.12u l=0.13u
X2511 a_10917_9959# sg13cmos5l_dfrbpq_1_13.CLK VDD.t52 VDD.t52 sg13_lv_pmos ad=0.4088p pd=2.97u as=1.8716p ps=12.115u w=1.12u l=0.13u
X2512 sg13cmos5l_o21ai_1_14.Y sg13cmos5l_o21ai_1_21.Y VDD.t1210 VDD.t310 sg13_lv_pmos ad=0.2128p pd=1.5u as=0.3808p ps=2.92u w=1.12u l=0.15u
X2513 VDD.t1710 sg13cmos5l_o21ai_1_1.B1 sg13cmos5l_nand3_1_2.Y VDD.t0 sg13_lv_pmos ad=0.2128p pd=1.5u as=0.2128p ps=1.5u w=1.12u l=0.13u
X2514 VDD.t24 VSS.t1864 VDD.t33 VDD.t2 sg13_lv_pmos ad=0.34p pd=2.68u as=0 ps=0 w=1u l=1u
X2515 a_9765_12972# sg13cmos5l_and4_1_1.A VDD.t1058 VDD.t83 sg13_lv_pmos ad=0.2464p pd=1.56u as=0.3808p ps=2.92u w=1.12u l=0.13u
X2516 sg13cmos5l_dfrbpq_1_15.CLK a_6442_10666# VSS.t362 VSS.t2398 sg13_lv_nmos ad=0.1406p pd=1.12u as=0.2516p ps=2.16u w=0.74u l=0.13u
X2517 VSS.t922 sg13cmos5l_a21oi_1_24.A2 a_17345_17856# VSS.t179 sg13_lv_nmos ad=0.2516p pd=2.16u as=0.1406p ps=1.12u w=0.74u l=0.13u
X2518 VDD.t596 VSS.t362 VDD.t594 VDD.t52 sg13_lv_pmos ad=0.19p pd=1.38u as=0 ps=0 w=1u l=1u
X2519 VDD.t1312 a_10906_18984# a_10625_19286# VDD.t231 sg13_lv_pmos ad=0.1523p pd=1.38u as=0.34p ps=2.68u w=1u l=0.5u
X2520 bn6 a_14152_14484# VSS.t239 VSS.t2219 sg13_lv_nmos ad=0.2886p pd=2.26u as=0.14875p ps=1.16u w=0.74u l=0.13u
X2521 a_1294_19959# a_1409_19960# VDD.t872 VDD.t270 sg13_lv_pmos ad=0.34p pd=2.68u as=0.2254p ps=1.53u w=1u l=0.5u
X2522 VDD.t955 a_18287_15311# a_18954_15532# VDD.t16 sg13_lv_pmos ad=0.2128p pd=1.5u as=0.3864p ps=2.93u w=1.12u l=0.13u
X2523 a_20494_15423# a_20609_15424# VDD.t1013 VDD.t16 sg13_lv_pmos ad=0.34p pd=2.68u as=0.2254p ps=1.53u w=1u l=0.5u
X2524 VSS.t196 sg13cmos5l_nor3_1_4.A sg13cmos5l_buf_1_20.A VSS.t149 sg13_lv_nmos ad=0.2618p pd=2.22u as=0.1694p ps=1.21u w=0.77u l=0.13u
X2525 a_8859_8436# sg13cmos5l_dfrbpq_1_17.Q a_8716_8436# VDD.t8 sg13_lv_pmos ad=0.19p pd=1.38u as=0.2925p ps=1.585u w=1u l=0.13u
X2526 a_17434_14448# sg13cmos5l_a21oi_1_20.Y VDD.t687 VDD.t19 sg13_lv_pmos ad=0.1428p pd=1.52u as=0.1523p ps=1.38u w=0.42u l=0.13u
X2527 VDD.t990 a_8576_10901# sg13cmos5l_dlygate4sd3_1_37.A VDD.t0 sg13_lv_pmos ad=0.1918p pd=1.5u as=0.3808p ps=2.92u w=1.12u l=0.13u
X2528 sg13cmos5l_dlygate4sd3_1_82.A sg13cmos5l_a21oi_1_18.B1 a_17717_19020# VDD.t231 sg13_lv_pmos ad=0.3808p pd=2.92u as=0.2128p ps=1.5u w=1.12u l=0.13u
X2529 VSS.t850 VDD.t2418 VSS.t850 VSS.t2015 sg13_lv_nmos ad=0.1428p pd=1.52u as=0 ps=0 w=0.42u l=1u
X2530 VDD.t775 sg13cmos5l_inv_1_2.A sg13cmos5l_inv_1_2.Y VDD.t13 sg13_lv_pmos ad=0.3808p pd=2.92u as=0.3808p ps=2.92u w=1.12u l=0.13u
X2531 VDD.t310 a_20272_17750# a_20217_17631# VDD.t310 sg13_lv_pmos ad=2.1916p pd=14.26u as=93.45f ps=0.865u w=0.42u l=0.13u
X2532 a_10927_14874# sg13cmos5l_and4_1_1.A a_10833_14874# VSS.t617 sg13_lv_nmos ad=0.1216p pd=1.02u as=0.2176p ps=1.96u w=0.64u l=0.13u
X2533 VSS.t1875 VDD.t2464 VSS.t1874 VSS.t1873 sg13_lv_nmos ad=0.1428p pd=1.52u as=0 ps=0 w=0.42u l=1u
X2534 a_13478_11460# a_13208_11501# VDD.t695 VDD.t0 sg13_lv_pmos ad=0.34p pd=2.68u as=0.1523p ps=1.38u w=1u l=0.5u
X2535 VDD.t0 a_20176_10918# a_20121_11013# VDD.t0 sg13_lv_pmos ad=2.1916p pd=14.26u as=93.45f ps=0.865u w=0.42u l=0.13u
X2536 VSS.t2113 VDD.t2393 VSS.t2112 VSS.t2111 sg13_lv_nmos ad=0.1428p pd=1.52u as=0 ps=0 w=0.42u l=1u
X2537 a_7977_9995# a_7620_9952# VDD.t1187 VDD.t52 sg13_lv_pmos ad=63f pd=0.72u as=0.1563p ps=1.22u w=0.42u l=0.13u
X2538 bp7 a_20104_3176# VDD.t675 VDD.t13 sg13_lv_pmos ad=0.42p pd=2.99u as=0.2114p ps=1.54u w=1.12u l=0.13u
X2539 VSS.t1204 VDD.t2441 VSS.t1204 VSS.t1960 sg13_lv_nmos ad=79.8f pd=0.8u as=0 ps=0 w=0.42u l=1u
X2540 VDD.t164 VSS.t1834 VDD.t200 VDD.t8 sg13_lv_pmos ad=0.34p pd=2.68u as=0 ps=0 w=1u l=1u
X2541 VDD.t1323 a_19534_13239# sg13cmos5l_inv_1_12.A VDD.t83 sg13_lv_pmos ad=0.2254p pd=1.53u as=0.4256p ps=3u w=1.12u l=0.13u
X2542 a_9934_9375# a_10049_9376# VSS.t190 VSS.t2556 sg13_lv_nmos ad=0.1428p pd=1.52u as=0.1426p ps=1.16u w=0.42u l=0.5u
X2543 a_13039_7294# a_12957_7194# sg13cmos5l_nand2_1_6.A VSS.t772 sg13_lv_nmos ad=0.1406p pd=1.12u as=0.333p ps=2.38u w=0.74u l=0.13u
X2544 a_13676_19734# sg13cmos5l_o21ai_1_26.B1 VSS.t915 VSS.t914 sg13_lv_nmos ad=0.187p pd=1.78u as=0.14875p ps=1.16u w=0.55u l=0.13u
X2545 VDD.t1798 sg13cmos5l_nand2_1_15.Y a_14423_14113# VDD.t19 sg13_lv_pmos ad=0.1428p pd=1.52u as=79.8f ps=0.8u w=0.42u l=0.13u
X2546 a_22522_6130# sg13cmos5l_dlygate4sd3_1_24.A VDD.t1246 VDD.t2 sg13_lv_pmos ad=0.1428p pd=1.52u as=0.1523p ps=1.38u w=0.42u l=0.13u
X2547 a_5157_14495# sg13cmos5l_dfrbpq_1_15.CLK VDD.t19 VDD.t19 sg13_lv_pmos ad=0.4088p pd=2.97u as=2.1916p ps=14.26u w=1.12u l=0.13u
X2548 VSS.t72 a_22096_14726# a_21745_14845# VSS.t394 sg13_lv_nmos ad=79.8f pd=0.8u as=0.1428p ps=1.52u w=0.42u l=0.13u
X2549 VDD.t267 VSS.t1726 VDD.t266 VDD.t0 sg13_lv_pmos ad=0.34p pd=2.68u as=0 ps=0 w=1u l=1u
X2550 VDD.t1796 sg13cmos5l_dfrbpq_1_33.Q a_18104_18262# VDD.t231 sg13_lv_pmos ad=0.1523p pd=1.38u as=0.1428p ps=1.52u w=0.42u l=0.13u
X2551 sg13cmos5l_dlygate4sd3_1_24.A a_22506_8436# VSS.t342 VSS.t14 sg13_lv_nmos ad=0.2516p pd=2.16u as=0.1406p ps=1.12u w=0.74u l=0.13u
X2552 a_12140_19734# sg13cmos5l_o21ai_1_18.B1 VSS.t107 VSS.t2308 sg13_lv_nmos ad=0.187p pd=1.78u as=0.14875p ps=1.16u w=0.55u l=0.13u
X2553 sg13cmos5l_o21ai_1_22.Y sg13cmos5l_o21ai_1_14.A1 a_9624_17064# VDD.t310 sg13_lv_pmos ad=0.2128p pd=1.5u as=0.2128p ps=1.5u w=1.12u l=0.15u
X2554 VDD.t707 a_4821_16043# a_3900_16357# VDD.t16 sg13_lv_pmos ad=0.36237p pd=2.605u as=0.34p ps=2.68u w=1u l=0.13u
X2555 VSS.t273 sg13cmos5l_a21oi_1_0.A2 a_18689_4676# VSS.t1332 sg13_lv_nmos ad=0.2516p pd=2.16u as=0.1406p ps=1.12u w=0.74u l=0.13u
X2556 a_9322_5380# a_9765_5423# a_9062_5850# VSS.t94 sg13_lv_nmos ad=79.8f pd=0.8u as=0.1296p ps=1.52u w=0.42u l=0.13u
X2557 a_14230_7670# sg13cmos5l_nor4_1_0.Y VSS.t99 VSS.t875 sg13_lv_nmos ad=0.1406p pd=1.12u as=0.1406p ps=1.12u w=0.74u l=0.15u
X2558 a_10980_18576# a_11499_18380# a_12239_18335# VSS.t1257 sg13_lv_nmos ad=0.3473p pd=2.71u as=0.12665p ps=1.145u w=0.74u l=0.13u
X2559 a_18374_18262# a_18104_18262# VDD.t1796 VDD.t231 sg13_lv_pmos ad=0.34p pd=2.68u as=0.1523p ps=1.38u w=1u l=0.5u
X2560 sg13cmos5l_dfrbpq_1_15.CLK a_6442_10666# VDD.t2152 VDD.t0 sg13_lv_pmos ad=0.2128p pd=1.5u as=0.3864p ps=2.93u w=1.12u l=0.13u
X2561 a_5349_19031# sg13cmos5l_dfrbpq_1_19.CLK VDD.t231 VDD.t231 sg13_lv_pmos ad=0.4088p pd=2.97u as=1.4953p ps=9.545u w=1.12u l=0.13u
X2562 sg13cmos5l_dfrbpq_1_5.CLK a_21531_13342# VSS.t163 VSS.t1246 sg13_lv_nmos ad=0.1406p pd=1.12u as=0.1406p ps=1.12u w=0.74u l=0.13u
X2563 a_13862_6166# a_13592_6166# VSS.t825 VSS.t2600 sg13_lv_nmos ad=0.1428p pd=1.52u as=79.8f ps=0.8u w=0.42u l=0.5u
X2564 a_19246_6351# a_19361_6352# VSS.t11 VSS.t737 sg13_lv_nmos ad=0.1428p pd=1.52u as=0.1426p ps=1.16u w=0.42u l=0.5u
X2565 a_6191_19381# a_5349_19031# a_6097_19381# VSS.t1303 sg13_lv_nmos ad=0.12665p pd=1.145u as=0.1428p ps=1.52u w=0.42u l=0.13u
X2566 a_8642_6162# sg13cmos5l_dfrbpq_1_13.RESET_B VSS.t293 VSS.t1220 sg13_lv_nmos ad=60.89999f pd=0.71u as=0.1626p ps=1.415u w=0.42u l=0.13u
X2567 a_6448_19262# sg13cmos5l_dfrbpq_1_24.RESET_B VDD.t231 VDD.t231 sg13_lv_pmos ad=79.8f pd=0.8u as=1.4953p ps=9.545u w=0.42u l=0.13u
X2568 VSS.t2153 VDD.t2385 VSS.t2152 VSS.t2151 sg13_lv_nmos ad=0.1428p pd=1.52u as=0 ps=0 w=0.42u l=1u
X2569 sg13cmos5l_nand2b_1_3.B a_16650_6460# VDD.t1134 VDD.t2 sg13_lv_pmos ad=0.3808p pd=2.92u as=0.2128p ps=1.5u w=1.12u l=0.13u
X2570 a_12239_18335# a_11397_18237# a_10980_18576# VDD.t231 sg13_lv_pmos ad=0.2048p pd=1.63u as=0.34p ps=2.68u w=1u l=0.13u
X2571 sg13cmos5l_nand2_1_19.Y sg13cmos5l_nand2_1_19.A a_12538_10702# VSS.t333 sg13_lv_nmos ad=0.2516p pd=2.16u as=0.1406p ps=1.12u w=0.74u l=0.13u
X2572 VDD.t626 VSS.t2092 VDD.t617 VDD.t13 sg13_lv_pmos ad=0.34p pd=2.68u as=0 ps=0 w=1u l=1u
X2573 a_12814_19959# a_12929_19960# VDD.t1207 VDD.t270 sg13_lv_pmos ad=0.34p pd=2.68u as=0.2254p ps=1.53u w=1u l=0.5u
X2574 sg13cmos5l_o21ai_1_20.A1 sg13cmos5l_nor2b_1_1.A VDD.t383 VDD.t310 sg13_lv_pmos ad=0.2128p pd=1.5u as=0.2128p ps=1.5u w=1.12u l=0.13u
X2575 bn1 a_12616_14484# VDD.t1482 VDD.t19 sg13_lv_pmos ad=0.42p pd=2.99u as=0.2114p ps=1.54u w=1.12u l=0.13u
X2576 VSS.t159 a_12428_12936# sg13cmos5l_buf_1_66.X VSS.t149 sg13_lv_nmos ad=0.14875p pd=1.16u as=0.2886p ps=2.26u w=0.74u l=0.13u
X2577 VSS.t153 sg13cmos5l_nand2_1_19.Y sg13cmos5l_nand2b_1_1.A_N VSS.t655 sg13_lv_nmos ad=0.1406p pd=1.12u as=0.2516p ps=2.16u w=0.74u l=0.13u
X2578 a_11053_7314# sg13cmos5l_and4_1_0.D VSS.t759 VSS.t1014 sg13_lv_nmos ad=0.1408p pd=1.08u as=0.1447p ps=1.15u w=0.64u l=0.13u
X2579 a_4740_19458# sg13cmos5l_dlygate4sd3_1_51.X a_4646_19458# VSS.t1117 sg13_lv_nmos ad=60.89999f pd=0.71u as=0.1428p ps=1.52u w=0.42u l=0.13u
X2580 a_16172_15960# sg13cmos5l_buf_1_16.A VDD.t1077 VDD.t16 sg13_lv_pmos ad=0.2856p pd=2.36u as=0.2114p ps=1.54u w=0.84u l=0.13u
X2581 VDD.t1569 sg13cmos5l_dfrbpq_1_13.RESET_B a_10214_10386# VDD.t52 sg13_lv_pmos ad=0.36237p pd=2.605u as=79.8f ps=0.8u w=0.42u l=0.13u
X2582 a_10896_8052# sg13cmos5l_nand3_1_3.Y VSS.t759 VSS.t1077 sg13_lv_nmos ad=0.1045p pd=0.93u as=0.187p ps=1.78u w=0.55u l=0.13u
X2583 VSS.t1931 VDD.t2444 VSS.t1933 VSS.t1932 sg13_lv_nmos ad=79.8f pd=0.8u as=0 ps=0 w=0.42u l=1u
X2584 a_18514_19770# sg13cmos5l_buf_1_45.X.t12 VSS.t931 VSS.t930 sg13_lv_nmos ad=37.8f pd=0.6u as=79.8f ps=0.8u w=0.42u l=0.13u
X2585 a_6050_18258# sg13cmos5l_dfrbpq_1_24.RESET_B VSS.t1135 VSS.t1110 sg13_lv_nmos ad=60.89999f pd=0.71u as=0.1626p ps=1.415u w=0.42u l=0.13u
X2586 sg13cmos5l_o21ai_1_8.B1 sg13cmos5l_nand3b_1_1.Y VSS.t48 VSS.t2416 sg13_lv_nmos ad=0.1406p pd=1.12u as=0.2516p ps=2.16u w=0.74u l=0.13u
X2587 VDD.t818 sg13cmos5l_nand2_1_19.A sg13cmos5l_inv_1_32.Y VDD.t83 sg13_lv_pmos ad=0.3808p pd=2.92u as=0.3808p ps=2.92u w=1.12u l=0.13u
X2588 a_20580_4968# a_20554_4873# VSS.t22 VSS.t21 sg13_lv_nmos ad=0.2516p pd=2.16u as=0.1626p ps=1.415u w=0.74u l=0.13u
X2589 a_10709_6460# sg13cmos5l_a21oi_1_9.A1 VDD.t1112 VDD.t2 sg13_lv_pmos ad=0.2128p pd=1.5u as=0.2128p ps=1.5u w=1.12u l=0.13u
X2590 a_14181_17519# sg13cmos5l_dfrbpq_1_41.CLK VDD.t310 VDD.t310 sg13_lv_pmos ad=0.4088p pd=2.97u as=2.1916p ps=14.26u w=1.12u l=0.13u
X2591 a_18863_11821# a_18021_11471# a_18769_11821# VSS.t965 sg13_lv_nmos ad=0.12665p pd=1.145u as=0.1428p ps=1.52u w=0.42u l=0.13u
X2592 sg13cmos5l_dlygate4sd3_1_4.A a_20874_5412# VDD.t2211 VDD.t5 sg13_lv_pmos ad=0.3808p pd=2.92u as=0.2128p ps=1.5u w=1.12u l=0.13u
X2593 a_13212_5773# a_13343_5383# a_12631_5376# VDD.t5 sg13_lv_pmos ad=0.34p pd=2.68u as=0.2048p ps=1.63u w=1u l=0.13u
X2594 sg13cmos5l_a21oi_1_11.Y sg13cmos5l_a21oi_1_9.A1 a_10803_6188# VSS.t691 sg13_lv_nmos ad=0.1406p pd=1.12u as=0.1406p ps=1.12u w=0.74u l=0.13u
X2595 a_5386_7897# a_5829_7653# a_5769_8065# VDD.t8 sg13_lv_pmos ad=79.8f pd=0.8u as=63f ps=0.72u w=0.42u l=0.13u
X2596 a_13478_16434# a_14283_16007# a_13738_15964# VDD.t16 sg13_lv_pmos ad=0.1428p pd=1.52u as=79.8f ps=0.8u w=0.42u l=0.13u
X2597 a_20388_8874# sg13cmos5l_dfrbpq_1_6.D a_20294_8874# VSS.t2354 sg13_lv_nmos ad=60.89999f pd=0.71u as=0.1428p ps=1.52u w=0.42u l=0.13u
X2598 VDD.t1769 sg13cmos5l_nand4_1_17.Y a_19829_18556# VDD.t231 sg13_lv_pmos ad=0.2128p pd=1.5u as=0.3808p ps=2.92u w=1.12u l=0.13u
X2599 VSS.t1649 VDD.t2546 VSS.t1648 VSS.t227 sg13_lv_nmos ad=0.1428p pd=1.52u as=0 ps=0 w=0.42u l=1u
X2600 a_19534_13239# a_19649_13238# VDD.t1323 VDD.t83 sg13_lv_pmos ad=0.34p pd=2.68u as=0.2254p ps=1.53u w=1u l=0.5u
X2601 VDD.t1449 sg13cmos5l_a21oi_1_4.A2 a_14548_12508# VDD.t83 sg13_lv_pmos ad=0.3808p pd=2.92u as=0.2128p ps=1.5u w=1.12u l=0.13u
X2602 VSS.t31 sg13cmos5l_buf_1_7.X a_17220_7362# VSS.t30 sg13_lv_nmos ad=0.1626p pd=1.415u as=60.89999f ps=0.71u w=0.42u l=0.13u
X2603 a_16078_9186# a_15820_9186# VSS.t81 VSS.t2215 sg13_lv_nmos ad=0.1428p pd=1.52u as=79.8f ps=0.8u w=0.42u l=0.13u
X2604 bn9 a_21640_3176# VDD.t732 VDD.t13 sg13_lv_pmos ad=0.42p pd=2.99u as=0.2114p ps=1.54u w=1.12u l=0.13u
X2605 VSS.t161 a_18874_9912# a_18593_10214# VSS.t558 sg13_lv_nmos ad=79.8f pd=0.8u as=0.1428p ps=1.52u w=0.42u l=0.5u
X2606 VSS.t1966 VDD.t13 VSS.t1966 VSS.t1967 sg13_lv_nmos ad=79.8f pd=0.8u as=0 ps=0 w=0.42u l=1u
X2607 VDD.t5 a_10864_5654# a_10809_5535# VDD.t5 sg13_lv_pmos ad=1.96072p pd=12.69u as=93.45f ps=0.865u w=0.42u l=0.13u
X2608 VDD.t861 sg13cmos5l_dfrbpq_1_23.Q a_4952_17549# VDD.t310 sg13_lv_pmos ad=0.1523p pd=1.38u as=0.1428p ps=1.52u w=0.42u l=0.13u
X2609 a_13572_17946# sg13cmos5l_dlygate4sd3_1_97.X a_13478_17946# VSS.t660 sg13_lv_nmos ad=60.89999f pd=0.71u as=0.1428p ps=1.52u w=0.42u l=0.13u
X2610 VDD.t1781 sg13cmos5l_and2_1_3.X sg13cmos5l_a21oi_1_20.A2 VDD.t16 sg13_lv_pmos ad=0.2128p pd=1.5u as=0.2128p ps=1.5u w=1.12u l=0.13u
X2611 sg13cmos5l_nor4_1_2.Y sg13cmos5l_nor3_1_4.A VSS.t159 VSS.t66 sg13_lv_nmos ad=0.1406p pd=1.12u as=0.2516p ps=2.16u w=0.74u l=0.13u
X2612 a_11152_12430# a_10895_12287# a_11314_12210# VSS.t2228 sg13_lv_nmos ad=0.1428p pd=1.52u as=37.8f ps=0.6u w=0.42u l=0.13u
X2613 a_9754_7678# sg13cmos5l_nand3_1_4.Y VSS.t779 VSS.t797 sg13_lv_nmos ad=0.1406p pd=1.12u as=0.2516p ps=2.16u w=0.74u l=0.13u
X2614 VDD.t2216 a_7822_19959# sg13cmos5l_dfrbpq_1_21.D VDD.t270 sg13_lv_pmos ad=0.2254p pd=1.53u as=0.4256p ps=3u w=1.12u l=0.13u
X2615 VDD.t352 VSS.t1647 VDD.t325 VDD.t310 sg13_lv_pmos ad=0.19p pd=1.38u as=0 ps=0 w=1u l=1u
X2616 VDD.t817 sg13cmos5l_nand2_1_19.A sg13cmos5l_nand2_1_19.Y VDD.t0 sg13_lv_pmos ad=0.3808p pd=2.92u as=0.2128p ps=1.5u w=1.12u l=0.13u
X2617 bn7 a_21160_12972# VDD.t702 VDD.t83 sg13_lv_pmos ad=0.42p pd=2.99u as=0.2114p ps=1.54u w=1.12u l=0.13u
X2618 VDD.t13 VSS.t2077 VDD.t13 VDD.t13 sg13_lv_pmos ad=0.34p pd=2.68u as=0 ps=0 w=1u l=1u
X2619 a_9300_15280# sg13cmos5l_a21oi_1_12.A2 a_8844_15424# VSS.t323 sg13_lv_nmos ad=78.39999f pd=0.885u as=0.2176p ps=1.96u w=0.64u l=0.13u
X2620 a_8783_19381# a_7941_19031# a_7524_19024# VDD.t231 sg13_lv_pmos ad=0.2048p pd=1.63u as=0.34p ps=2.68u w=1u l=0.13u
X2621 a_4700_17488# sg13cmos5l_o21ai_1_21.A2 sg13cmos5l_o21ai_1_21.Y VDD.t310 sg13_lv_pmos ad=0.2128p pd=1.5u as=0.2128p ps=1.5u w=1.12u l=0.15u
X2622 a_22126_3327# a_22241_3328# VDD.t1430 VDD.t13 sg13_lv_pmos ad=0.34p pd=2.68u as=0.2254p ps=1.53u w=1u l=0.5u
X2623 VSS.t1860 VDD.t2467 VSS.t1859 VSS.t1858 sg13_lv_nmos ad=0.1428p pd=1.52u as=0 ps=0 w=0.42u l=1u
X2624 VSS.t201 sg13cmos5l_nand3b_1_3.C a_14761_15238# VSS.t1267 sg13_lv_nmos ad=0.13395p pd=1.12u as=0.198p ps=1.27u w=0.55u l=0.13u
X2625 sg13cmos5l_nand4_1_6.B sg13cmos5l_dfrbpq_1_24.Q a_11874_14484# VDD.t19 sg13_lv_pmos ad=0.4368p pd=3.02u as=0.2128p ps=1.5u w=1.12u l=0.13u
X2626 VDD.t172 VSS.t2014 VDD.t98 VDD.t13 sg13_lv_pmos ad=0.19p pd=1.38u as=0 ps=0 w=1u l=1u
X2627 VSS.t2098 VDD.t2396 VSS.t2097 VSS.t2096 sg13_lv_nmos ad=0.1428p pd=1.52u as=0 ps=0 w=0.42u l=1u
X2628 VDD.t1614 sg13cmos5l_dfrbpq_1_20.D a_5303_18649# VDD.t231 sg13_lv_pmos ad=0.1428p pd=1.52u as=79.8f ps=0.8u w=0.42u l=0.13u
X2629 VSS.t948 sg13cmos5l_dfrbpq_1_13.CLK a_13727_13992# VSS.t947 sg13_lv_nmos ad=6.29922p pd=42.355u as=0.2516p ps=2.16u w=0.74u l=0.13u
X2630 VSS.t1155 a_10510_19287# sg13cmos5l_o21ai_1_13.B1 VSS.t1163 sg13_lv_nmos ad=0.1426p pd=1.16u as=0.2516p ps=2.16u w=0.74u l=0.13u
X2631 a_9156_17874# sg13cmos5l_nor2b_1_1.A a_9054_17874# VSS.t43 sg13_lv_nmos ad=0.1406p pd=1.12u as=0.1406p ps=1.12u w=0.74u l=0.13u
X2632 sg13cmos5l_a21oi_1_12.Y sg13cmos5l_a21o_1_2.A1 VSS.t124 VSS.t154 sg13_lv_nmos ad=0.1406p pd=1.12u as=0.2516p ps=2.16u w=0.74u l=0.13u
X2633 VSS.t1683 VDD.t2535 VSS.t1685 VSS.t1684 sg13_lv_nmos ad=79.8f pd=0.8u as=0 ps=0 w=0.42u l=1u
X2634 a_4455_18476# a_4607_18528# VSS.t242 VSS.t1114 sg13_lv_nmos ad=0.2516p pd=2.16u as=4.1963p ps=27.415u w=0.74u l=0.13u
X2635 VSS.t46 VDD.t2536 VSS.t46 VSS.t1679 sg13_lv_nmos ad=0.1428p pd=1.52u as=0 ps=0 w=0.42u l=1u
X2636 VSS.t260 sg13cmos5l_a21o_1_1.A2 a_7886_9232# VSS.t288 sg13_lv_nmos ad=0.2176p pd=1.96u as=81.6f ps=0.895u w=0.64u l=0.13u
X2637 a_16865_17856# sg13cmos5l_inv_1_15.Y sg13cmos5l_a21oi_1_25.Y VSS.t1313 sg13_lv_nmos ad=0.1406p pd=1.12u as=0.1406p ps=1.12u w=0.74u l=0.13u
X2638 a_14548_12508# sg13cmos5l_inv_1_36.Y a_14446_12508# VDD.t83 sg13_lv_pmos ad=0.2128p pd=1.5u as=0.2128p ps=1.5u w=1.12u l=0.13u
X2639 a_18670_16263# a_18785_16262# VSS.t132 VSS.t1227 sg13_lv_nmos ad=0.1428p pd=1.52u as=0.1426p ps=1.16u w=0.42u l=0.5u
X2640 VSS.t1211 VDD.t2515 VSS.t60 VSS.t1759 sg13_lv_nmos ad=0.1428p pd=1.52u as=0 ps=0 w=0.42u l=1u
X2641 VDD.t233 VSS.t997 VDD.t232 VDD.t231 sg13_lv_pmos ad=0.19p pd=1.38u as=0 ps=0 w=1u l=1u
X2642 a_7804_12214# sg13cmos5l_mux2_1_0.A1 a_7310_12400# VSS.t216 sg13_lv_nmos ad=0.13135p pd=1.095u as=0.1628p ps=1.18u w=0.74u l=0.13u
X2643 VSS.t1058 VDD.t2489 VSS.t362 VSS.t1825 sg13_lv_nmos ad=79.8f pd=0.8u as=0 ps=0 w=0.42u l=1u
X2644 a_16402_6162# sg13cmos5l_buf_1_13.A VSS.t13 VSS.t2372 sg13_lv_nmos ad=37.8f pd=0.6u as=79.8f ps=0.8u w=0.42u l=0.13u
X2645 bn1 a_12616_14484# VSS.t79 VSS.t1447 sg13_lv_nmos ad=0.2886p pd=2.26u as=0.14875p ps=1.16u w=0.74u l=0.13u
X2646 a_20554_4873# a_20997_4629# a_20294_4650# VSS.t21 sg13_lv_nmos ad=79.8f pd=0.8u as=0.1296p ps=1.52u w=0.42u l=0.13u
X2647 sg13cmos5l_a21oi_1_8.Y sg13cmos5l_nor2_1_2.Y a_8021_5412# VDD.t5 sg13_lv_pmos ad=0.3808p pd=2.92u as=0.2128p ps=1.5u w=1.12u l=0.13u
X2648 VDD.t119 VSS.t2005 VDD.t117 VDD.t13 sg13_lv_pmos ad=0.19p pd=1.38u as=0 ps=0 w=1u l=1u
X2649 VSS.t273 sg13cmos5l_inv_1_2.A sg13cmos5l_inv_1_2.Y VSS.t272 sg13_lv_nmos ad=0.2516p pd=2.16u as=0.2516p ps=2.16u w=0.74u l=0.13u
X2650 a_18206_12218# sg13cmos5l_nand4_1_18.B a_18104_12218# VSS.t2284 sg13_lv_nmos ad=0.1406p pd=1.12u as=0.1406p ps=1.12u w=0.74u l=0.13u
X2651 a_20388_4650# sg13cmos5l_dfrbpq_1_0.D a_20294_4650# VSS.t1054 sg13_lv_nmos ad=60.89999f pd=0.71u as=0.1428p ps=1.52u w=0.42u l=0.13u
X2652 VSS.t1916 VDD.t2447 VSS.t1918 VSS.t1917 sg13_lv_nmos ad=79.8f pd=0.8u as=0 ps=0 w=0.42u l=1u
X2653 VDD.t161 VSS.t1837 VDD.t160 VDD.t8 sg13_lv_pmos ad=0.34p pd=2.68u as=0 ps=0 w=1u l=1u
X2654 a_10872_17488# sg13cmos5l_o21ai_1_20.A1 VDD.t1516 VDD.t310 sg13_lv_pmos ad=0.2128p pd=1.5u as=0.3808p ps=2.92u w=1.12u l=0.15u
X2655 a_18886_10711# sg13cmos5l_buf_1_13.X VSS.t161 VSS.t589 sg13_lv_nmos ad=37.8f pd=0.6u as=0.1701p ps=1.65u w=0.42u l=0.13u
X2656 VSS.t253 sg13cmos5l_inv_1_5.A a_15935_7944# VSS.t1034 sg13_lv_nmos ad=4.21822p pd=27.295u as=0.2516p ps=2.16u w=0.74u l=0.13u
X2657 a_18730_17476# a_19173_17519# a_19113_17555# VDD.t310 sg13_lv_pmos ad=79.8f pd=0.8u as=63f ps=0.72u w=0.42u l=0.13u
X2658 sg13cmos5l_nand3_1_5.Y sg13cmos5l_nand2_1_11.B VDD.t691 VDD.t16 sg13_lv_pmos ad=0.2128p pd=1.5u as=0.2128p ps=1.5u w=1.12u l=0.13u
X2659 VSS.t103 a_11372_10662# sg13cmos5l_o21ai_1_5.A2 VSS.t102 sg13_lv_nmos ad=0.14875p pd=1.16u as=0.2886p ps=2.26u w=0.74u l=0.13u
X2660 sg13cmos5l_nor2_1_0.Y sg13cmos5l_dlygate4sd3_1_8.X VSS.t97 VSS.t741 sg13_lv_nmos ad=0.1406p pd=1.12u as=0.2516p ps=2.16u w=0.74u l=0.13u
X2661 a_15530_7674# a_15223_7638# a_15436_7674# VSS.t2213 sg13_lv_nmos ad=37.8f pd=0.6u as=0.1428p ps=1.52u w=0.42u l=0.13u
X2662 VSS.t273 sg13cmos5l_inv_1_7.A a_19432_3900# VSS.t2545 sg13_lv_nmos ad=0.14875p pd=1.16u as=0.187p ps=1.78u w=0.55u l=0.13u
X2663 VDD.t327 VSS.t1647 VDD.t353 VDD.t16 sg13_lv_pmos ad=0.19p pd=1.38u as=0 ps=0 w=1u l=1u
X2664 a_9651_11808# sg13cmos5l_a21oi_1_27.A2 VSS.t50 VSS.t328 sg13_lv_nmos ad=0.1406p pd=1.12u as=0.2516p ps=2.16u w=0.74u l=0.13u
X2665 a_7594_9916# a_8037_9959# a_7334_10386# VSS.t814 sg13_lv_nmos ad=79.8f pd=0.8u as=0.1296p ps=1.52u w=0.42u l=0.13u
X2666 VSS.t887 a_21839_12287# a_22506_12508# VSS.t16 sg13_lv_nmos ad=0.1406p pd=1.12u as=0.2516p ps=2.16u w=0.74u l=0.13u
X2667 a_8206_9375# a_8321_9376# VSS.t190 VSS.t913 sg13_lv_nmos ad=0.1428p pd=1.52u as=0.1426p ps=1.16u w=0.42u l=0.5u
X2668 VSS.t1135 a_5397_18416# a_4476_18222# VSS.t1110 sg13_lv_nmos ad=0.1626p pd=1.415u as=0.2516p ps=2.16u w=0.74u l=0.13u
X2669 VDD.t809 sg13cmos5l_nor4_1_1.D a_8411_15532# VDD.t16 sg13_lv_pmos ad=0.2128p pd=1.5u as=0.2128p ps=1.5u w=1.12u l=0.13u
X2670 sg13cmos5l_a21oi_1_20.Y sg13cmos5l_a21oi_1_18.B1 a_16469_14484# VDD.t19 sg13_lv_pmos ad=0.3808p pd=2.92u as=0.2128p ps=1.5u w=1.12u l=0.13u
X2671 VSS.t2158 VDD.t2384 VSS.t2157 VSS.t2156 sg13_lv_nmos ad=0.1428p pd=1.52u as=0 ps=0 w=0.42u l=1u
X2672 sg13cmos5l_inv_1_12.Y sg13cmos5l_inv_1_12.A VSS.t15 VSS.t341 sg13_lv_nmos ad=0.2516p pd=2.16u as=0.2516p ps=2.16u w=0.74u l=0.13u
X2673 VSS.t407 a_6958_16935# sg13cmos5l_o21ai_1_11.B1 VSS.t1311 sg13_lv_nmos ad=0.1426p pd=1.16u as=0.2516p ps=2.16u w=0.74u l=0.13u
X2674 sg13cmos5l_nand4_1_18.B a_8337_13362# VSS.t67 VSS.t149 sg13_lv_nmos ad=0.3552p pd=2.44u as=0.1447p ps=1.15u w=0.74u l=0.13u
X2675 sg13cmos5l_o21ai_1_25.B1 a_15126_19044# VSS.t2518 VSS.t305 sg13_lv_nmos ad=0.2516p pd=2.16u as=0.1426p ps=1.16u w=0.74u l=0.13u
X2676 VDD.t362 sg13cmos5l_buf_1_7.X a_20554_4873# VDD.t5 sg13_lv_pmos ad=0.1563p pd=1.22u as=0.147p ps=1.54u w=0.42u l=0.13u
X2677 VSS.t1604 VDD.t2561 VSS.t997 VSS.t1611 sg13_lv_nmos ad=0.1428p pd=1.52u as=0 ps=0 w=0.42u l=1u
X2678 a_15023_16357# a_14181_16007# a_14929_16357# VSS.t1501 sg13_lv_nmos ad=0.12665p pd=1.145u as=0.1428p ps=1.52u w=0.42u l=0.13u
X2679 VDD.t1090 a_7310_12400# sg13cmos5l_dfrbpq_1_45.D VDD.t83 sg13_lv_pmos ad=0.2198p pd=1.52u as=0.6048p ps=3.32u w=1.12u l=0.13u
X2680 VSS.t222 sg13cmos5l_nand2b_1_0.B a_15691_12256# VSS.t971 sg13_lv_nmos ad=0.1331p pd=1.12u as=0.1216p ps=1.02u w=0.64u l=0.13u
X2681 comp_clk a_18952_3176# VSS.t122 VSS.t1594 sg13_lv_nmos ad=0.2886p pd=2.26u as=0.14875p ps=1.16u w=0.74u l=0.13u
X2682 a_10864_5654# a_10607_5773# a_11026_5850# VSS.t728 sg13_lv_nmos ad=0.1428p pd=1.52u as=37.8f ps=0.6u w=0.42u l=0.13u
X2683 VSS.t1936 VDD.t2443 VSS.t1938 VSS.t1937 sg13_lv_nmos ad=79.8f pd=0.8u as=0 ps=0 w=0.42u l=1u
X2684 a_11268_18271# a_10980_18576# a_11206_18271# VSS.t1137 sg13_lv_nmos ad=0.1428p pd=1.52u as=37.8f ps=0.6u w=0.42u l=0.13u
X2685 VDD.t230 VSS.t759 VDD.t229 VDD.t2 sg13_lv_pmos ad=0.34p pd=2.68u as=0 ps=0 w=1u l=1u
X2686 sg13cmos5l_a21oi_1_10.A1 a_9885_7194# VDD.t2238 VDD.t2 sg13_lv_pmos ad=0.2128p pd=1.5u as=0.3808p ps=2.92u w=1.12u l=0.13u
X2687 a_17098_6130# sg13cmos5l_buf_8_2.A.t1 VDD.t1744 VDD.t2 sg13_lv_pmos ad=0.3808p pd=2.92u as=0.2128p ps=1.5u w=1.12u l=0.13u
X2688 a_20868_14909# a_21099_14495# a_20554_14452# VSS.t851 sg13_lv_nmos ad=0.2373p pd=1.97u as=79.8f ps=0.8u w=0.42u l=0.13u
X2689 VSS.t331 sg13cmos5l_nand2_1_19.A sg13cmos5l_inv_1_32.Y VSS.t149 sg13_lv_nmos ad=0.2516p pd=2.16u as=0.2516p ps=2.16u w=0.74u l=0.13u
X2690 sg13cmos5l_dlygate4sd3_1_98.A sg13cmos5l_buf_1_16.A a_19829_18556# VDD.t231 sg13_lv_pmos ad=0.3808p pd=2.92u as=0.2128p ps=1.5u w=1.12u l=0.13u
X2691 VSS.t569 sg13cmos5l_nor4_1_0.C a_12022_8814# VSS.t2218 sg13_lv_nmos ad=0.1406p pd=1.12u as=0.2516p ps=2.16u w=0.74u l=0.15u
X2692 VSS.t245 sg13cmos5l_inv_1_8.A a_14347_13320# VSS.t244 sg13_lv_nmos ad=0.1331p pd=1.12u as=0.1216p ps=1.02u w=0.64u l=0.13u
X2693 sg13cmos5l_dlygate4sd3_1_54.A a_11274_20068# VSS.t937 VSS.t2429 sg13_lv_nmos ad=0.2516p pd=2.16u as=0.1406p ps=1.12u w=0.74u l=0.13u
X2694 VDD.t1041 sg13cmos5l_buf_1_13.X a_18634_10921# VDD.t0 sg13_lv_pmos ad=0.1563p pd=1.22u as=0.147p ps=1.54u w=0.42u l=0.13u
X2695 VDD.t227 VSS.t1665 VDD.t341 VDD.t19 sg13_lv_pmos ad=0.34p pd=2.68u as=0 ps=0 w=1u l=1u
X2696 a_5892_13397# a_5604_12976# a_5830_13397# VSS.t1537 sg13_lv_nmos ad=0.1428p pd=1.52u as=37.8f ps=0.6u w=0.42u l=0.13u
X2697 sg13cmos5l_buf_1_9.A a_21366_10766# VSS.t76 VSS.t489 sg13_lv_nmos ad=0.2516p pd=2.16u as=0.1426p ps=1.16u w=0.74u l=0.13u
X2698 a_4455_18476# a_4607_18528# VDD.t231 VDD.t231 sg13_lv_pmos ad=0.3864p pd=2.93u as=1.54512p ps=9.865u w=1.12u l=0.13u
X2699 VDD.t1472 a_12987_10318# sg13cmos5l_dfrbpq_1_13.CLK VDD.t52 sg13_lv_pmos ad=0.3864p pd=2.93u as=0.2128p ps=1.5u w=1.12u l=0.13u
X2700 VDD.t110 VSS.t2005 VDD.t112 VDD.t5 sg13_lv_pmos ad=0.19p pd=1.38u as=0 ps=0 w=1u l=1u
X2701 a_16186_6888# sg13cmos5l_nand2b_1_3.B VSS.t99 VSS.t859 sg13_lv_nmos ad=0.1428p pd=1.52u as=79.8f ps=0.8u w=0.42u l=0.13u
X2702 sg13cmos5l_nor2b_1_2.Y sg13cmos5l_nand2b_1_1.A_N a_12652_6924# VDD.t2 sg13_lv_pmos ad=0.3808p pd=2.92u as=0.1176p ps=1.33u w=1.12u l=0.13u
X2703 a_14218_18226# sg13cmos5l_buf_8_2.A.t6 VSS.t113 VSS.t2610 sg13_lv_nmos ad=0.2553p pd=2.17u as=0.1406p ps=1.12u w=0.74u l=0.13u
X2704 VSS.t1108 a_3776_18433# sg13cmos5l_dfrbpq_1_20.Q VSS.t1107 sg13_lv_nmos ad=0.1406p pd=1.12u as=0.2516p ps=2.16u w=0.74u l=0.13u
X2705 VDD.t683 sg13cmos5l_inv_1_24.Y a_17051_15996# VDD.t16 sg13_lv_pmos ad=0.2128p pd=1.5u as=0.2128p ps=1.5u w=1.12u l=0.13u
X2706 VDD.t1723 sg13cmos5l_nand4_1_1.C sg13cmos5l_a21oi_1_3.A2 VDD.t19 sg13_lv_pmos ad=0.2128p pd=1.5u as=0.2128p ps=1.5u w=1.12u l=0.13u
X2707 VSS.t2 a_20997_12189# a_21099_12332# VSS.t1009 sg13_lv_nmos ad=4.7455p pd=30.71u as=0.2516p ps=2.16u w=0.74u l=0.13u
X2708 VDD.t1184 sg13cmos5l_nand2b_1_4.B sg13cmos5l_nand3_1_4.Y VDD.t8 sg13_lv_pmos ad=0.2128p pd=1.5u as=0.2128p ps=1.5u w=1.12u l=0.13u
X2709 a_5124_9504# a_5098_9409# VDD.t1555 VDD.t52 sg13_lv_pmos ad=0.34p pd=2.68u as=0.36237p ps=2.605u w=1u l=0.13u
X2710 VDD.t269 VSS.t2082 VDD.t268 VDD.t13 sg13_lv_pmos ad=0.34p pd=2.68u as=0 ps=0 w=1u l=1u
X2711 a_22107_16043# a_21215_15967# a_22005_16043# VDD.t16 sg13_lv_pmos ad=63f pd=0.72u as=79.8f ps=0.8u w=0.42u l=0.13u
X2712 a_5124_9504# a_5643_9308# a_6383_9263# VSS.t2504 sg13_lv_nmos ad=0.3473p pd=2.71u as=0.12665p ps=1.145u w=0.74u l=0.13u
X2713 VDD.t1264 a_15488_9361# sg13cmos5l_nor2b_1_0.B_N VDD.t52 sg13_lv_pmos ad=0.2128p pd=1.5u as=0.3808p ps=2.92u w=1.12u l=0.13u
X2714 a_9348_5416# a_9322_5380# VSS.t293 VSS.t921 sg13_lv_nmos ad=0.2516p pd=2.16u as=0.1626p ps=1.415u w=0.74u l=0.13u
X2715 a_12188_6904# sg13cmos5l_nand2b_1_1.A_N sg13cmos5l_o21ai_1_4.Y VDD.t2 sg13_lv_pmos ad=0.2128p pd=1.5u as=0.2128p ps=1.5u w=1.12u l=0.15u
X2716 a_13936_19262# a_13679_19381# a_14098_19458# VSS.t2522 sg13_lv_nmos ad=0.1428p pd=1.52u as=37.8f ps=0.6u w=0.42u l=0.13u
X2717 VDD.t310 a_15280_17750# a_15225_17631# VDD.t310 sg13_lv_pmos ad=2.1916p pd=14.26u as=93.45f ps=0.865u w=0.42u l=0.13u
X2718 VDD.t390 sg13cmos5l_nand3b_1_1.C sg13cmos5l_nand3b_1_1.Y VDD.t16 sg13_lv_pmos ad=0.2198p pd=1.53u as=0.2128p ps=1.5u w=1.12u l=0.13u
X2719 VDD.t5 a_9765_5423# a_9867_5423# VDD.t5 sg13_lv_pmos ad=1.96072p pd=12.69u as=0.3864p ps=2.93u w=1.12u l=0.13u
X2720 a_18106_17472# sg13cmos5l_o21ai_1_23.B1 VSS.t1433 VSS.t179 sg13_lv_nmos ad=0.1428p pd=1.52u as=79.8f ps=0.8u w=0.42u l=0.13u
X2721 VDD.t710 a_17710_17775# sg13cmos5l_buf_1_54.A VDD.t310 sg13_lv_pmos ad=0.2254p pd=1.53u as=0.4256p ps=3u w=1.12u l=0.13u
X2722 VSS.t132 a_19035_16750# sg13cmos5l_inv_1_31.A VSS.t449 sg13_lv_nmos ad=0.2516p pd=2.16u as=0.1406p ps=1.12u w=0.74u l=0.13u
X2723 a_5541_9165# sg13cmos5l_dfrbpq_1_15.CLK VDD.t52 VDD.t52 sg13_lv_pmos ad=0.4088p pd=2.97u as=1.79022p ps=11.585u w=1.12u l=0.13u
X2724 VDD.t1370 sg13cmos5l_dfrbpq_1_17.Q a_7736_7678# VDD.t8 sg13_lv_pmos ad=0.1523p pd=1.38u as=0.1428p ps=1.52u w=0.42u l=0.13u
X2725 a_18352_19990# a_18095_19847# a_18514_19770# VSS.t930 sg13_lv_nmos ad=0.1428p pd=1.52u as=37.8f ps=0.6u w=0.42u l=0.13u
X2726 a_4298_15532# sg13cmos5l_a21oi_1_27.B1 VDD.t2048 VDD.t16 sg13_lv_pmos ad=0.1176p pd=1.33u as=0.4032p ps=2.96u w=1.12u l=0.13u
X2727 VDD.t139 VSS.t1999 VDD.t133 VDD.t13 sg13_lv_pmos ad=0.19p pd=1.38u as=0 ps=0 w=1u l=1u
X2728 VDD.t231 a_12837_19031# a_12939_19031# VDD.t231 sg13_lv_pmos ad=1.54512p pd=9.865u as=0.3864p ps=2.93u w=1.12u l=0.13u
X2729 VSS.t9 sg13cmos5l_buf_1_7.X a_20388_11898# VSS.t8 sg13_lv_nmos ad=0.1626p pd=1.415u as=60.89999f ps=0.71u w=0.42u l=0.13u
X2730 a_15494_18258# a_16299_18380# a_15754_18481# VDD.t231 sg13_lv_pmos ad=0.1428p pd=1.52u as=79.8f ps=0.8u w=0.42u l=0.13u
X2731 VSS.t1727 VDD.t2511 VSS.t1726 VSS.t1725 sg13_lv_nmos ad=0.1428p pd=1.52u as=0 ps=0 w=0.42u l=1u
X2732 VSS.t1112 sg13cmos5l_nand3_1_5.Y a_4114_17886# VSS.t1530 sg13_lv_nmos ad=0.1406p pd=1.12u as=0.1406p ps=1.12u w=0.74u l=0.15u
X2733 VDD.t8 sg13cmos5l_inv_1_5.A a_15935_7944# VDD.t8 sg13_lv_pmos ad=1.79022p pd=11.585u as=0.4088p ps=2.97u w=1.12u l=0.13u
X2734 sg13cmos5l_inv_1_31.A a_19035_16750# VSS.t132 VSS.t446 sg13_lv_nmos ad=0.1406p pd=1.12u as=0.1406p ps=1.12u w=0.74u l=0.13u
X2735 sg13cmos5l_nor4_1_4.C sg13cmos5l_nor2b_1_1.A VSS.t48 VSS.t47 sg13_lv_nmos ad=0.2516p pd=2.16u as=0.2516p ps=2.16u w=0.74u l=0.13u
X2736 a_9557_11460# sg13cmos5l_a21oi_1_27.A1 VDD.t814 VDD.t0 sg13_lv_pmos ad=0.2128p pd=1.5u as=0.2128p ps=1.5u w=1.12u l=0.13u
X2737 VDD.t409 VSS.t1731 VDD.t412 VDD.t0 sg13_lv_pmos ad=0.34p pd=2.68u as=0 ps=0 w=1u l=1u
X2738 a_10788_10373# a_11019_9959# a_10474_9916# VSS.t605 sg13_lv_nmos ad=0.2373p pd=1.97u as=79.8f ps=0.8u w=0.42u l=0.13u
X2739 VDD.t2206 a_17518_10215# sg13cmos5l_nand3_1_0.C VDD.t52 sg13_lv_pmos ad=0.2254p pd=1.53u as=0.4256p ps=3u w=1.12u l=0.13u
X2740 a_6766_7191# a_6881_7190# VSS.t702 VSS.t2525 sg13_lv_nmos ad=0.1428p pd=1.52u as=0.1426p ps=1.16u w=0.42u l=0.5u
X2741 a_6490_19738# sg13cmos5l_dfrbpq_1_25.Q VDD.t2171 VDD.t270 sg13_lv_pmos ad=0.1428p pd=1.52u as=0.1523p ps=1.38u w=0.42u l=0.13u
X2742 a_13486_13722# a_13727_13992# a_13015_13686# VSS.t66 sg13_lv_nmos ad=0.1428p pd=1.52u as=0.12665p ps=1.145u w=0.42u l=0.13u
X2743 VSS.t1800 VDD.t2500 VSS.t781 VSS.t1801 sg13_lv_nmos ad=79.8f pd=0.8u as=0 ps=0 w=0.42u l=1u
X2744 VDD.t1430 a_22126_3327# sg13cmos5l_buf_1_3.A VDD.t13 sg13_lv_pmos ad=0.2254p pd=1.53u as=0.4256p ps=3u w=1.12u l=0.13u
X2745 VSS.t2143 VDD.t2387 VSS.t2142 VSS.t2141 sg13_lv_nmos ad=0.1428p pd=1.52u as=0 ps=0 w=0.42u l=1u
X2746 VDD.t1740 a_7498_18226# sg13cmos5l_dfrbpq_1_19.CLK VDD.t231 sg13_lv_pmos ad=0.2128p pd=1.5u as=0.2128p ps=1.5u w=1.12u l=0.13u
X2747 VDD.t682 a_18670_16263# sg13cmos5l_buf_1_57.A VDD.t16 sg13_lv_pmos ad=0.2254p pd=1.53u as=0.4256p ps=3u w=1.12u l=0.13u
X2748 a_19430_9190# a_19160_9190# VDD.t994 VDD.t52 sg13_lv_pmos ad=0.34p pd=2.68u as=0.1523p ps=1.38u w=1u l=0.5u
X2749 a_13042_4646# sg13cmos5l_o21ai_1_0.A1 VSS.t2002 VSS.t2377 sg13_lv_nmos ad=0.2516p pd=2.16u as=0.1406p ps=1.12u w=0.74u l=0.15u
X2750 a_19305_5459# a_18948_5416# VDD.t369 VDD.t5 sg13_lv_pmos ad=63f pd=0.72u as=0.1563p ps=1.22u w=0.42u l=0.13u
X2751 VDD.t744 a_14842_11424# a_14561_11726# VDD.t0 sg13_lv_pmos ad=0.1523p pd=1.38u as=0.34p ps=2.68u w=1u l=0.5u
X2752 VSS.t1973 VDD.t300 VSS.t1973 VSS.t1976 sg13_lv_nmos ad=0.1428p pd=1.52u as=0 ps=0 w=0.42u l=1u
X2753 VDD.t1527 a_8783_19381# a_9450_19020# VDD.t231 sg13_lv_pmos ad=0.2128p pd=1.5u as=0.3864p ps=2.93u w=1.12u l=0.13u
X2754 VSS.t1315 sg13cmos5l_a21oi_1_26.A2 a_16385_17856# VSS.t1314 sg13_lv_nmos ad=0.2516p pd=2.16u as=0.1406p ps=1.12u w=0.74u l=0.13u
X2755 a_5578_12940# a_6021_12983# a_5318_13410# VSS.t1534 sg13_lv_nmos ad=79.8f pd=0.8u as=0.1296p ps=1.52u w=0.42u l=0.13u
X2756 VSS.t291 sg13cmos5l_nor2_1_2.A sg13cmos5l_nor2_1_2.Y VSS.t290 sg13_lv_nmos ad=0.2516p pd=2.16u as=0.1406p ps=1.12u w=0.74u l=0.13u
X2757 VSS.t97 sg13cmos5l_nand2_1_0.B a_13814_8828# VSS.t1022 sg13_lv_nmos ad=0.2553p pd=2.17u as=0.13875p ps=1.115u w=0.74u l=0.13u
X2758 a_10428_17874# sg13cmos5l_buf_1_65.A sg13cmos5l_o21ai_1_20.A1 VSS.t1547 sg13_lv_nmos ad=0.1406p pd=1.12u as=0.2516p ps=2.16u w=0.74u l=0.13u
X2759 a_18200_16362# sg13cmos5l_buf_1_43.X a_18098_16362# VSS.t2586 sg13_lv_nmos ad=0.1406p pd=1.12u as=0.1406p ps=1.12u w=0.74u l=0.13u
X2760 VSS.t1921 VDD.t2446 VSS.t1923 VSS.t1922 sg13_lv_nmos ad=79.8f pd=0.8u as=0 ps=0 w=0.42u l=1u
X2761 a_13990_17933# sg13cmos5l_buf_1_45.X.t7 VSS.t726 VSS.t933 sg13_lv_nmos ad=37.8f pd=0.6u as=0.1701p ps=1.65u w=0.42u l=0.13u
X2762 a_20388_10386# sg13cmos5l_dfrbpq_1_7.D a_20294_10386# VSS.t1082 sg13_lv_nmos ad=60.89999f pd=0.71u as=0.1428p ps=1.52u w=0.42u l=0.13u
X2763 VDD.t637 VSS.t1746 VDD.t1386 VDD.t0 sg13_lv_pmos ad=0.34p pd=2.68u as=0 ps=0 w=1u l=1u
X2764 a_20294_13722# sg13cmos5l_dlygate4sd3_1_76.X VDD.t2290 VDD.t19 sg13_lv_pmos ad=79.8f pd=0.8u as=0.1428p ps=1.52u w=0.42u l=0.13u
X2765 a_17109_9344# sg13cmos5l_buf_1_13.A VDD.t2126 VDD.t52 sg13_lv_pmos ad=0.147p pd=1.54u as=0.1563p ps=1.22u w=0.42u l=0.13u
X2766 VSS.t369 a_6094_19959# sg13cmos5l_o21ai_1_7.B1 VSS.t2463 sg13_lv_nmos ad=0.1426p pd=1.16u as=0.2516p ps=2.16u w=0.74u l=0.13u
X2767 VSS.t931 a_19246_19959# sg13cmos5l_dfrbpq_1_35.D VSS.t1031 sg13_lv_nmos ad=0.1426p pd=1.16u as=0.2516p ps=2.16u w=0.74u l=0.13u
X2768 VDD.t231 a_17039_18335# a_17296_18478# VDD.t231 sg13_lv_pmos ad=1.54512p pd=9.865u as=79.8f ps=0.8u w=0.42u l=0.13u
X2769 sg13cmos5l_nand4_1_12.Y sg13cmos5l_buf_1_43.X VDD.t885 VDD.t310 sg13_lv_pmos ad=0.2128p pd=1.5u as=0.2128p ps=1.5u w=1.12u l=0.13u
X2770 VDD.t667 a_10895_12287# a_11562_12508# VDD.t83 sg13_lv_pmos ad=0.2128p pd=1.5u as=0.3864p ps=2.93u w=1.12u l=0.13u
X2771 sg13cmos5l_a21oi_1_8.A1 a_8637_5682# VDD.t2334 VDD.t5 sg13_lv_pmos ad=0.2128p pd=1.5u as=0.3808p ps=2.92u w=1.12u l=0.13u
X2772 VSS.t369 a_4070_19020# a_4182_19044# VSS.t1119 sg13_lv_nmos ad=0.1426p pd=1.16u as=0.1428p ps=1.52u w=0.42u l=0.5u
X2773 a_16167_9404# a_16319_9456# VSS.t264 VSS.t1037 sg13_lv_nmos ad=0.2516p pd=2.16u as=5.26052p ps=34.445u w=0.74u l=0.13u
X2774 VDD.t1064 sg13cmos5l_buf_1_59.A sg13cmos5l_o21ai_1_24.Y VDD.t310 sg13_lv_pmos ad=0.3808p pd=2.92u as=0.2128p ps=1.5u w=1.12u l=0.15u
X2775 a_17346_16754# sg13cmos5l_buf_1_43.X a_17244_16754# VSS.t2583 sg13_lv_nmos ad=0.1406p pd=1.12u as=0.1406p ps=1.12u w=0.74u l=0.13u
X2776 a_21839_11821# a_20997_11471# a_21745_11821# VSS.t16 sg13_lv_nmos ad=0.12665p pd=1.145u as=0.1428p ps=1.52u w=0.42u l=0.13u
X2777 a_17700_7349# a_17412_6928# a_17638_7349# VSS.t579 sg13_lv_nmos ad=0.1428p pd=1.52u as=37.8f ps=0.6u w=0.42u l=0.13u
X2778 a_4070_19020# a_3800_19061# VDD.t1628 VDD.t231 sg13_lv_pmos ad=0.34p pd=2.68u as=0.1523p ps=1.38u w=1u l=0.5u
X2779 a_4923_16043# a_4031_15967# a_4821_16043# VDD.t16 sg13_lv_pmos ad=63f pd=0.72u as=79.8f ps=0.8u w=0.42u l=0.13u
X2780 VSS.t1683 VDD.t2529 VSS.t1685 VSS.t1684 sg13_lv_nmos ad=79.8f pd=0.8u as=0 ps=0 w=0.42u l=1u
X2781 VDD.t871 a_22330_10666# a_22049_10888# VDD.t0 sg13_lv_pmos ad=0.1523p pd=1.38u as=0.34p ps=2.68u w=1u l=0.5u
X2782 VSS.t19 a_18928_7166# a_18577_7285# VSS.t18 sg13_lv_nmos ad=79.8f pd=0.8u as=0.1428p ps=1.52u w=0.42u l=0.13u
X2783 sg13cmos5l_nand2_1_6.A a_12957_7194# VDD.t1179 VDD.t2 sg13_lv_pmos ad=0.2128p pd=1.5u as=0.3808p ps=2.92u w=1.12u l=0.13u
X2784 a_7498_18988# a_7941_19031# a_7238_19458# VSS.t1165 sg13_lv_nmos ad=79.8f pd=0.8u as=0.1296p ps=1.52u w=0.42u l=0.13u
X2785 VDD.t729 sg13cmos5l_buf_1_20.A a_13096_15996# VDD.t16 sg13_lv_pmos ad=0.2114p pd=1.54u as=0.2856p ps=2.36u w=0.84u l=0.13u
X2786 sg13cmos5l_dfrbpq_1_5.CLK a_21531_13342# VDD.t1598 VDD.t83 sg13_lv_pmos ad=0.2128p pd=1.5u as=0.2128p ps=1.5u w=1.12u l=0.13u
X2787 a_20974_6351# a_21089_6352# VSS.t479 VSS.t258 sg13_lv_nmos ad=0.1428p pd=1.52u as=0.1426p ps=1.16u w=0.42u l=0.5u
X2788 sg13cmos5l_nor3_1_2.Y sg13cmos5l_nor3_1_2.A VSS.t388 VSS.t1851 sg13_lv_nmos ad=0.1694p pd=1.21u as=0.2618p ps=2.22u w=0.77u l=0.13u
X2789 VSS.t2163 VDD.t2383 VSS.t2162 VSS.t2161 sg13_lv_nmos ad=0.1428p pd=1.52u as=0 ps=0 w=0.42u l=1u
X2790 a_7120_13214# sg13cmos5l_dfrbpq_1_24.RESET_B VDD.t83 VDD.t83 sg13_lv_pmos ad=79.8f pd=0.8u as=2.51485p ps=16.46u w=0.42u l=0.13u
X2791 VDD.t13 VSS.t2067 VDD.t13 VDD.t13 sg13_lv_pmos ad=0.34p pd=2.68u as=0 ps=0 w=1u l=1u
X2792 sg13cmos5l_nand2_1_12.Y sg13cmos5l_nand2_1_9.Y VDD.t1729 VDD.t310 sg13_lv_pmos ad=0.2128p pd=1.5u as=0.3808p ps=2.92u w=1.12u l=0.13u
X2793 a_21084_16710# a_21215_17016# a_20503_16710# VDD.t310 sg13_lv_pmos ad=0.34p pd=2.68u as=0.2048p ps=1.63u w=1u l=0.13u
X2794 a_8844_15424# sg13cmos5l_a21oi_1_12.A2 VDD.t810 VDD.t16 sg13_lv_pmos ad=0.1596p pd=1.22u as=0.2891p ps=1.695u w=0.84u l=0.13u
X2795 VSS.t653 VDD.t2542 VSS.t653 VSS.t1667 sg13_lv_nmos ad=0.1428p pd=1.52u as=0 ps=0 w=0.42u l=1u
X2796 a_16836_15234# sg13cmos5l_dlygate4sd3_1_81.X a_16742_15234# VSS.t1316 sg13_lv_nmos ad=60.89999f pd=0.71u as=0.1428p ps=1.52u w=0.42u l=0.13u
X2797 bp2 a_21256_3900# VSS.t22 VSS.t2329 sg13_lv_nmos ad=0.2886p pd=2.26u as=0.14875p ps=1.16u w=0.74u l=0.13u
X2798 VDD.t52 a_8037_9959# a_8139_9959# VDD.t52 sg13_lv_pmos ad=1.8716p pd=12.115u as=0.3864p ps=2.93u w=1.12u l=0.13u
X2799 sg13cmos5l_a21o_1_0.A2 sg13cmos5l_o21ai_1_5.A2 a_10872_11016# VDD.t0 sg13_lv_pmos ad=0.2128p pd=1.5u as=0.2128p ps=1.5u w=1.12u l=0.15u
X2800 sg13cmos5l_dfrbpq_1_9.Q a_19338_6924# VDD.t1282 VDD.t2 sg13_lv_pmos ad=0.3808p pd=2.92u as=0.2128p ps=1.5u w=1.12u l=0.13u
X2801 VSS.t1727 VDD.t2522 VSS.t1726 VSS.t1725 sg13_lv_nmos ad=0.1428p pd=1.52u as=0 ps=0 w=0.42u l=1u
X2802 VSS.t538 a_8576_10901# sg13cmos5l_dlygate4sd3_1_37.A VSS.t537 sg13_lv_nmos ad=0.1331p pd=1.12u as=0.2516p ps=2.16u w=0.74u l=0.13u
X2803 a_17518_10215# a_17633_10214# VDD.t2206 VDD.t52 sg13_lv_pmos ad=0.34p pd=2.68u as=0.2254p ps=1.53u w=1u l=0.5u
X2804 a_18660_7992# a_18634_7897# VSS.t19 VSS.t23 sg13_lv_nmos ad=0.2516p pd=2.16u as=0.1626p ps=1.415u w=0.74u l=0.13u
X2805 VDD.t336 VSS.t1648 VDD.t335 VDD.t16 sg13_lv_pmos ad=0.34p pd=2.68u as=0 ps=0 w=1u l=1u
X2806 sg13cmos5l_o21ai_1_12.Y sg13cmos5l_nor2_1_6.Y a_5880_15552# VDD.t16 sg13_lv_pmos ad=0.2128p pd=1.5u as=0.2128p ps=1.5u w=1.12u l=0.15u
X2807 VDD.t923 sg13cmos5l_dfrbpq_1_24.Q a_8337_13362# VDD.t83 sg13_lv_pmos ad=0.2044p pd=1.53u as=0.1848p ps=1.28u w=0.84u l=0.13u
X2808 a_6756_11464# a_6730_11428# VSS.t60 VSS.t59 sg13_lv_nmos ad=0.2516p pd=2.16u as=0.1626p ps=1.415u w=0.74u l=0.13u
X2809 a_15610_9912# sg13cmos5l_dlygate4sd3_1_14.A VDD.t674 VDD.t52 sg13_lv_pmos ad=0.1428p pd=1.52u as=0.1523p ps=1.38u w=0.42u l=0.13u
X2810 sample a_19336_3176# VDD.t991 VDD.t13 sg13_lv_pmos ad=0.42p pd=2.99u as=0.2114p ps=1.54u w=1.12u l=0.13u
X2811 VSS.t11 sg13cmos5l_dfrbpq_1_9.Q a_20024_6166# VSS.t258 sg13_lv_nmos ad=79.8f pd=0.8u as=0.1428p ps=1.52u w=0.42u l=0.13u
X2812 VDD.t842 a_17338_18984# a_17057_19286# VDD.t231 sg13_lv_pmos ad=0.1523p pd=1.38u as=0.34p ps=2.68u w=1u l=0.5u
X2813 sg13cmos5l_nor4_1_2.Y sg13cmos5l_dfrbpq_1_24.Q a_11490_14020# VDD.t19 sg13_lv_pmos ad=0.4368p pd=3.02u as=0.2128p ps=1.5u w=1.12u l=0.13u
X2814 a_10917_9959# sg13cmos5l_dfrbpq_1_13.CLK VSS.t266 VSS.t944 sg13_lv_nmos ad=0.2516p pd=2.16u as=4.90217p ps=31.68u w=0.74u l=0.13u
X2815 sg13cmos5l_dfrbpq_1_9.D a_16566_8460# VSS.t81 VSS.t1007 sg13_lv_nmos ad=0.2516p pd=2.16u as=0.1426p ps=1.16u w=0.74u l=0.13u
X2816 a_8783_19381# a_7941_19031# a_8689_19381# VSS.t1167 sg13_lv_nmos ad=0.12665p pd=1.145u as=0.1428p ps=1.52u w=0.42u l=0.13u
X2817 VSS.t1688 VDD.t2534 VSS.t1690 VSS.t1689 sg13_lv_nmos ad=79.8f pd=0.8u as=0 ps=0 w=0.42u l=1u
X2818 sg13cmos5l_nor2_1_3.Y sg13cmos5l_a22oi_1_0.B2 VSS.t248 VSS.t764 sg13_lv_nmos ad=0.1406p pd=1.12u as=0.2516p ps=2.16u w=0.74u l=0.13u
X2819 sg13cmos5l_dfrbpq_1_13.Q a_11274_5412# VDD.t1149 VDD.t5 sg13_lv_pmos ad=0.3808p pd=2.92u as=0.2128p ps=1.5u w=1.12u l=0.13u
X2820 VSS.t853 VDD.t2562 VSS.t997 VSS.t1610 sg13_lv_nmos ad=79.8f pd=0.8u as=0 ps=0 w=0.42u l=1u
X2821 a_5961_13019# a_5604_12976# VDD.t1514 VDD.t83 sg13_lv_pmos ad=63f pd=0.72u as=0.1563p ps=1.22u w=0.42u l=0.13u
X2822 a_8434_11898# sg13cmos5l_dfrbpq_1_13.RESET_B VSS.t74 VSS.t1212 sg13_lv_nmos ad=37.8f pd=0.6u as=79.8f ps=0.8u w=0.42u l=0.13u
X2823 VDD.t113 VSS.t2005 VDD.t115 VDD.t5 sg13_lv_pmos ad=0.19p pd=1.38u as=0 ps=0 w=1u l=1u
X2824 VSS.t1906 VDD.t2458 VSS.t1908 VSS.t1907 sg13_lv_nmos ad=79.8f pd=0.8u as=0 ps=0 w=0.42u l=1u
X2825 VSS.t72 sg13cmos5l_inv_1_31.A sg13cmos5l_inv_1_31.Y VSS.t2299 sg13_lv_nmos ad=0.2516p pd=2.16u as=0.2516p ps=2.16u w=0.74u l=0.13u
X2826 VDD.t1298 sg13cmos5l_dfrbpq_1_13.RESET_B a_9062_5850# VDD.t5 sg13_lv_pmos ad=0.36237p pd=2.605u as=79.8f ps=0.8u w=0.42u l=0.13u
X2827 a_3996_16710# a_4127_17016# a_3415_16710# VDD.t310 sg13_lv_pmos ad=0.34p pd=2.68u as=0.2048p ps=1.63u w=1u l=0.13u
X2828 VSS.t677 sg13cmos5l_dfrbpq_1_28.RESET_B.t7 a_22262_16759# VSS.t1273 sg13_lv_nmos ad=0.1701p pd=1.65u as=37.8f ps=0.6u w=0.42u l=0.13u
X2829 a_17434_14448# sg13cmos5l_a21oi_1_20.Y VSS.t136 VSS.t139 sg13_lv_nmos ad=0.1428p pd=1.52u as=79.8f ps=0.8u w=0.42u l=0.13u
X2830 VDD.t884 sg13cmos5l_nand4_1_1.C sg13cmos5l_a21oi_1_16.A2 VDD.t19 sg13_lv_pmos ad=0.2128p pd=1.5u as=0.2128p ps=1.5u w=1.12u l=0.13u
X2831 VDD.t2368 a_12987_12214# sg13cmos5l_buf_8_2.A VDD.t83 sg13_lv_pmos ad=0.3864p pd=2.93u as=0.2128p ps=1.5u w=1.12u l=0.13u
X2832 a_12512_5699# a_12631_5376# VSS.t279 VSS.t278 sg13_lv_nmos ad=0.2516p pd=2.16u as=0.1406p ps=1.12u w=0.74u l=0.13u
X2833 VSS.t83 sg13cmos5l_buf_1_1.A sg13cmos5l_inv_1_13.Y VSS.t208 sg13_lv_nmos ad=0.2516p pd=2.16u as=0.2516p ps=2.16u w=0.74u l=0.13u
X2834 VDD.t275 VSS.t1605 VDD.t235 VDD.t231 sg13_lv_pmos ad=0.19p pd=1.38u as=0 ps=0 w=1u l=1u
X2835 a_4548_14922# sg13cmos5l_a21o_1_2.X a_4454_14922# VSS.t376 sg13_lv_nmos ad=60.89999f pd=0.71u as=0.1428p ps=1.52u w=0.42u l=0.13u
X2836 VSS.t1966 VDD.t13 VSS.t1966 VSS.t1968 sg13_lv_nmos ad=0.1428p pd=1.52u as=0 ps=0 w=0.42u l=1u
X2837 VSS.t199 sg13cmos5l_buf_1_57.A sg13cmos5l_inv_1_25.Y VSS.t967 sg13_lv_nmos ad=0.2516p pd=2.16u as=0.2516p ps=2.16u w=0.74u l=0.13u
X2838 a_9500_8416# sg13cmos5l_nand3_1_4.Y sg13cmos5l_o21ai_1_6.Y VDD.t8 sg13_lv_pmos ad=0.2128p pd=1.5u as=0.2128p ps=1.5u w=1.12u l=0.15u
X2839 sg13cmos5l_nor4_1_0.C a_8520_8436# VDD.t1182 VDD.t8 sg13_lv_pmos ad=0.3808p pd=2.92u as=0.2144p ps=1.52u w=1.12u l=0.13u
X2840 VSS.t163 a_21531_13342# sg13cmos5l_dfrbpq_1_5.CLK VSS.t1247 sg13_lv_nmos ad=0.2516p pd=2.16u as=0.1406p ps=1.12u w=0.74u l=0.13u
X2841 a_8576_10901# sg13cmos5l_a21o_1_1.A2 a_8713_10744# VSS.t287 sg13_lv_nmos ad=0.2176p pd=1.96u as=0.1216p ps=1.02u w=0.64u l=0.13u
X2842 a_7908_10373# a_7620_9952# a_7846_10373# VSS.t782 sg13_lv_nmos ad=0.1428p pd=1.52u as=37.8f ps=0.6u w=0.42u l=0.13u
X2843 VSS.t1703 VDD.t2531 VSS.t1705 VSS.t1704 sg13_lv_nmos ad=79.8f pd=0.8u as=0 ps=0 w=0.42u l=1u
X2844 a_21839_12287# a_20997_12189# a_21745_12287# VSS.t16 sg13_lv_nmos ad=0.12665p pd=1.145u as=0.1428p ps=1.52u w=0.42u l=0.13u
X2845 sg13cmos5l_dfrbpq_1_3.D a_16950_9972# VSS.t174 VSS.t560 sg13_lv_nmos ad=0.2516p pd=2.16u as=0.1426p ps=1.16u w=0.74u l=0.13u
X2846 VDD.t2275 sg13cmos5l_dfrbpq_1_44.Q a_14744_19061# VDD.t231 sg13_lv_pmos ad=0.1523p pd=1.38u as=0.1428p ps=1.52u w=0.42u l=0.13u
X2847 VSS.t845 VDD.t2495 VSS.t1813 VSS.t1812 sg13_lv_nmos ad=79.8f pd=0.8u as=0 ps=0 w=0.42u l=1u
X2848 VSS.t69 a_5998_17775# sg13cmos5l_dfrbpq_1_23.D VSS.t68 sg13_lv_nmos ad=0.1426p pd=1.16u as=0.2516p ps=2.16u w=0.74u l=0.13u
X2849 VSS.t74 sg13cmos5l_mux2_1_0.A1 a_8411_12252# VSS.t217 sg13_lv_nmos ad=0.18945p pd=1.27u as=0.187p ps=1.78u w=0.55u l=0.13u
X2850 a_20554_12433# a_20997_12189# a_20937_12601# VDD.t83 sg13_lv_pmos ad=79.8f pd=0.8u as=63f ps=0.72u w=0.42u l=0.13u
X2851 VSS.t83 a_18832_8678# a_18481_8797# VSS.t892 sg13_lv_nmos ad=79.8f pd=0.8u as=0.1428p ps=1.52u w=0.42u l=0.13u
X2852 a_20506_19738# sg13cmos5l_dfrbpq_1_40.Q VDD.t1775 VDD.t270 sg13_lv_pmos ad=0.1428p pd=1.52u as=0.1523p ps=1.38u w=0.42u l=0.13u
X2853 VSS.t97 sg13cmos5l_a22oi_1_0.A2 a_14155_8784# VSS.t486 sg13_lv_nmos ad=0.1331p pd=1.12u as=0.1216p ps=1.02u w=0.64u l=0.13u
X2854 VDD.t60 VSS.t1987 VDD.t59 VDD.t5 sg13_lv_pmos ad=0.34p pd=2.68u as=0 ps=0 w=1u l=1u
X2855 a_6094_19959# a_6209_19960# VDD.t2213 VDD.t270 sg13_lv_pmos ad=0.34p pd=2.68u as=0.2254p ps=1.53u w=1u l=0.5u
X2856 a_15922_19770# sg13cmos5l_buf_1_45.X.t14 VSS.t927 VSS.t166 sg13_lv_nmos ad=37.8f pd=0.6u as=79.8f ps=0.8u w=0.42u l=0.13u
X2857 a_19246_19959# a_19361_19960# VDD.t1412 VDD.t270 sg13_lv_pmos ad=0.34p pd=2.68u as=0.2254p ps=1.53u w=1u l=0.5u
X2858 VDD.t419 VSS.t1739 VDD.t285 VDD.t83 sg13_lv_pmos ad=0.19p pd=1.38u as=0 ps=0 w=1u l=1u
X2859 a_12957_7194# sg13cmos5l_o21ai_1_0.A1 VDD.t1347 VDD.t2 sg13_lv_pmos ad=0.2856p pd=2.36u as=0.2198p ps=1.53u w=0.84u l=0.13u
X2860 VSS.t1058 sg13cmos5l_dlygate4sd3_1_33.X a_5416_9948# VSS.t2392 sg13_lv_nmos ad=0.14875p pd=1.16u as=0.187p ps=1.78u w=0.55u l=0.13u
X2861 VDD.t1185 a_9274_6888# a_8993_7190# VDD.t2 sg13_lv_pmos ad=0.1523p pd=1.38u as=0.34p ps=2.68u w=1u l=0.5u
X2862 sg13cmos5l_a21oi_1_6.Y sg13cmos5l_inv_1_11.Y a_19923_8784# VSS.t1598 sg13_lv_nmos ad=0.1406p pd=1.12u as=0.1406p ps=1.12u w=0.74u l=0.13u
X2863 a_9636_19783# a_9867_19892# a_9322_19993# VSS.t2479 sg13_lv_nmos ad=0.2373p pd=1.97u as=79.8f ps=0.8u w=0.42u l=0.13u
X2864 VDD.t1701 a_16954_11424# a_16673_11726# VDD.t0 sg13_lv_pmos ad=0.1523p pd=1.38u as=0.34p ps=2.68u w=1u l=0.5u
X2865 VSS.t2148 VDD.t2386 VSS.t2147 VSS.t2146 sg13_lv_nmos ad=0.1428p pd=1.52u as=0 ps=0 w=0.42u l=1u
X2866 VDD.t1703 sg13cmos5l_buf_1_43.X a_15496_13760# VDD.t19 sg13_lv_pmos ad=0.2114p pd=1.54u as=0.2856p ps=2.36u w=0.84u l=0.13u
X2867 a_16644_5837# a_16356_5416# a_16582_5837# VSS.t490 sg13_lv_nmos ad=0.1428p pd=1.52u as=37.8f ps=0.6u w=0.42u l=0.13u
X2868 a_21646_15423# a_21761_15424# VDD.t950 VDD.t16 sg13_lv_pmos ad=0.34p pd=2.68u as=0.2254p ps=1.53u w=1u l=0.5u
X2869 a_17038_14751# a_17153_14750# VSS.t136 VSS.t854 sg13_lv_nmos ad=0.1428p pd=1.52u as=0.1426p ps=1.16u w=0.42u l=0.5u
X2870 a_13210_12936# sg13cmos5l_nand2_1_18.A VDD.t696 VDD.t83 sg13_lv_pmos ad=0.1428p pd=1.52u as=0.1523p ps=1.38u w=0.42u l=0.13u
X2871 VSS.t39 a_17872_5654# a_17521_5773# VSS.t38 sg13_lv_nmos ad=79.8f pd=0.8u as=0.1428p ps=1.52u w=0.42u l=0.13u
X2872 VSS.t279 a_10607_5773# a_11274_5412# VSS.t729 sg13_lv_nmos ad=0.1406p pd=1.12u as=0.2516p ps=2.16u w=0.74u l=0.13u
X2873 a_16810_19993# a_17253_19749# a_16550_19770# VSS.t166 sg13_lv_nmos ad=79.8f pd=0.8u as=0.1296p ps=1.52u w=0.42u l=0.13u
X2874 a_9636_12528# a_9610_12433# VDD.t1557 VDD.t83 sg13_lv_pmos ad=0.34p pd=2.68u as=0.36237p ps=2.605u w=1u l=0.13u
X2875 a_19365_5423# sg13cmos5l_inv_1_2.A VDD.t5 VDD.t5 sg13_lv_pmos ad=0.4088p pd=2.97u as=1.8716p ps=12.115u w=1.12u l=0.13u
X2876 sg13cmos5l_nor3_1_2.Y sg13cmos5l_nor3_1_2.C VSS.t388 VSS.t387 sg13_lv_nmos ad=0.2618p pd=2.22u as=0.1463p ps=1.15u w=0.77u l=0.13u
X2877 VSS.t5 a_7066_18226# a_6785_18448# VSS.t2273 sg13_lv_nmos ad=79.8f pd=0.8u as=0.1428p ps=1.52u w=0.42u l=0.5u
X2878 a_20384_18433# a_20503_18222# VDD.t672 VDD.t231 sg13_lv_pmos ad=0.3864p pd=2.93u as=0.2128p ps=1.5u w=1.12u l=0.13u
X2879 VDD.t310 a_14181_17519# a_14283_17519# VDD.t310 sg13_lv_pmos ad=2.1916p pd=14.26u as=0.3864p ps=2.93u w=1.12u l=0.13u
X2880 VSS.t163 a_21531_13342# sg13cmos5l_dfrbpq_1_5.CLK VSS.t1243 sg13_lv_nmos ad=0.1406p pd=1.12u as=0.1406p ps=1.12u w=0.74u l=0.13u
X2881 VSS.t1926 VDD.t2445 VSS.t1928 VSS.t1927 sg13_lv_nmos ad=79.8f pd=0.8u as=0 ps=0 w=0.42u l=1u
X2882 a_12902_8436# a_12632_8477# VSS.t569 VSS.t2338 sg13_lv_nmos ad=0.1428p pd=1.52u as=79.8f ps=0.8u w=0.42u l=0.5u
X2883 a_1690_9154# rst_n VDD.t656 VDD.t52 sg13_lv_pmos ad=0.1428p pd=1.52u as=0.1523p ps=1.38u w=0.42u l=0.13u
X2884 a_15780_18576# a_16299_18380# a_17039_18335# VSS.t92 sg13_lv_nmos ad=0.3473p pd=2.71u as=0.12665p ps=1.145u w=0.74u l=0.13u
X2885 VSS.t1130 a_9040_19262# a_8689_19381# VSS.t1277 sg13_lv_nmos ad=79.8f pd=0.8u as=0.1428p ps=1.52u w=0.42u l=0.13u
X2886 VSS.t384 sg13cmos5l_o21ai_1_21.A2 a_4594_17886# VSS.t1148 sg13_lv_nmos ad=0.1406p pd=1.12u as=0.1406p ps=1.12u w=0.74u l=0.15u
X2887 VDD.t19 a_5999_14845# a_6256_14726# VDD.t19 sg13_lv_pmos ad=2.1916p pd=14.26u as=79.8f ps=0.8u w=0.42u l=0.13u
X2888 sg13cmos5l_buf_1_14.A a_12045_11808# VSS.t344 VSS.t343 sg13_lv_nmos ad=0.2516p pd=2.16u as=0.1331p ps=1.12u w=0.74u l=0.13u
X2889 VDD.t34 VSS.t1973 VDD.t611 VDD.t5 sg13_lv_pmos ad=0.34p pd=2.68u as=0 ps=0 w=1u l=1u
X2890 VDD.t1800 a_20110_19959# sg13cmos5l_buf_1_63.A VDD.t270 sg13_lv_pmos ad=0.2254p pd=1.53u as=0.4256p ps=3u w=1.12u l=0.13u
X2891 a_20937_6971# a_20580_6928# VDD.t377 VDD.t2 sg13_lv_pmos ad=63f pd=0.72u as=0.1563p ps=1.22u w=0.42u l=0.13u
X2892 a_12792_17064# sg13cmos5l_buf_1_47.X VDD.t1651 VDD.t310 sg13_lv_pmos ad=0.2128p pd=1.5u as=0.3808p ps=2.92u w=1.12u l=0.15u
X2893 sg13cmos5l_a21oi_1_26.A2 sg13cmos5l_buf_1_43.X VDD.t1708 VDD.t310 sg13_lv_pmos ad=0.2128p pd=1.5u as=0.2128p ps=1.5u w=1.12u l=0.13u
X2894 VDD.t52 a_22096_10190# a_22041_10071# VDD.t52 sg13_lv_pmos ad=1.8716p pd=12.115u as=93.45f ps=0.865u w=0.42u l=0.13u
X2895 VDD.t121 VSS.t2005 VDD.t120 VDD.t13 sg13_lv_pmos ad=0.34p pd=2.68u as=0 ps=0 w=1u l=1u
X2896 a_3895_18222# a_4455_18476# a_4476_18222# VSS.t1109 sg13_lv_nmos ad=0.12665p pd=1.145u as=0.3473p ps=2.71u w=0.74u l=0.13u
X2897 a_17039_18335# a_16197_18237# a_15780_18576# VDD.t231 sg13_lv_pmos ad=0.2048p pd=1.63u as=0.34p ps=2.68u w=1u l=0.13u
X2898 VDD.t1936 a_7726_8703# sg13cmos5l_nor3_1_2.A VDD.t8 sg13_lv_pmos ad=0.2254p pd=1.53u as=0.4256p ps=3u w=1.12u l=0.13u
X2899 a_17316_8440# a_17290_8404# VDD.t1044 VDD.t8 sg13_lv_pmos ad=0.34p pd=2.68u as=0.36237p ps=2.605u w=1u l=0.13u
X2900 a_14244_20088# a_14218_19993# VDD.t664 VDD.t270 sg13_lv_pmos ad=0.34p pd=2.68u as=0.36237p ps=2.605u w=1u l=0.13u
X2901 VSS.t435 a_20015_17869# a_20682_17508# VSS.t225 sg13_lv_nmos ad=0.1406p pd=1.12u as=0.2516p ps=2.16u w=0.74u l=0.13u
X2902 VSS.t89 a_1690_9154# a_1409_9376# VSS.t88 sg13_lv_nmos ad=79.8f pd=0.8u as=0.1428p ps=1.52u w=0.42u l=0.5u
X2903 sg13cmos5l_dlygate4sd3_1_62.A sg13cmos5l_dlygate4sd3_1_64.X VDD.t1367 VDD.t310 sg13_lv_pmos ad=0.2128p pd=1.5u as=0.3808p ps=2.92u w=1.12u l=0.15u
X2904 VSS.t256 a_6368_6337# sg13cmos5l_dfrbpq_1_15.Q VSS.t2452 sg13_lv_nmos ad=0.1406p pd=1.12u as=0.2516p ps=2.16u w=0.74u l=0.13u
X2905 VDD.t1379 sg13cmos5l_and4_1_0.D a_10990_8052# VDD.t8 sg13_lv_pmos ad=0.2226p pd=1.535u as=0.1596p ps=1.22u w=0.84u l=0.13u
X2906 sg13cmos5l_a22oi_1_1.B2 sg13cmos5l_nand3_1_4.Y VDD.t1199 VDD.t8 sg13_lv_pmos ad=0.2128p pd=1.5u as=0.3808p ps=2.92u w=1.12u l=0.13u
X2907 a_7750_9508# sg13cmos5l_a21o_1_1.A2 VDD.t784 VDD.t52 sg13_lv_pmos ad=0.34p pd=2.68u as=0.19p ps=1.38u w=1u l=0.13u
X2908 VSS.t13 a_15983_6239# a_16650_6460# VSS.t712 sg13_lv_nmos ad=0.1406p pd=1.12u as=0.2516p ps=2.16u w=0.74u l=0.13u
X2909 VSS.t1315 sg13cmos5l_a21oi_1_25.A2 a_16865_17856# VSS.t179 sg13_lv_nmos ad=0.2516p pd=2.16u as=0.1406p ps=1.12u w=0.74u l=0.13u
X2910 VDD.t398 VSS.t1687 VDD.t397 VDD.t19 sg13_lv_pmos ad=0.34p pd=2.68u as=0 ps=0 w=1u l=1u
X2911 a_10774_10694# sg13cmos5l_o21ai_1_5.A2 VSS.t740 VSS.t1341 sg13_lv_nmos ad=0.1406p pd=1.12u as=0.1406p ps=1.12u w=0.74u l=0.15u
X2912 a_10550_16362# sg13cmos5l_nor4_1_4.C a_10448_16362# VSS.t2575 sg13_lv_nmos ad=0.1406p pd=1.12u as=0.1406p ps=1.12u w=0.74u l=0.13u
X2913 sg13cmos5l_nand4_1_8.B sg13cmos5l_nor4_1_4.C VSS.t199 VSS.t2578 sg13_lv_nmos ad=0.1406p pd=1.12u as=0.1406p ps=1.12u w=0.74u l=0.13u
X2914 a_7989_6320# a_7047_6380# a_7895_6553# VDD.t2 sg13_lv_pmos ad=79.8f pd=0.8u as=0.1428p ps=1.52u w=0.42u l=0.13u
X2915 a_18928_7166# a_18671_7285# a_19090_7362# VSS.t18 sg13_lv_nmos ad=0.1428p pd=1.52u as=37.8f ps=0.6u w=0.42u l=0.13u
X2916 a_19544_14850# sg13cmos5l_nand4_1_1.C a_19442_14850# VSS.t432 sg13_lv_nmos ad=0.1406p pd=1.12u as=0.1406p ps=1.12u w=0.74u l=0.13u
X2917 VDD.t1113 sg13cmos5l_a21oi_1_9.A1 a_10811_4948# VDD.t5 sg13_lv_pmos ad=0.2128p pd=1.5u as=0.2128p ps=1.5u w=1.12u l=0.13u
X2918 VDD.t1021 a_9734_17508# a_9846_17532# VDD.t310 sg13_lv_pmos ad=0.2254p pd=1.53u as=0.34p ps=2.68u w=1u l=0.5u
X2919 a_14253_13320# sg13cmos5l_nand2_1_19.A VDD.t819 VDD.t83 sg13_lv_pmos ad=0.1596p pd=1.22u as=0.2856p ps=2.36u w=0.84u l=0.13u
X2920 bn7 a_21160_12972# VSS.t163 VSS.t2327 sg13_lv_nmos ad=0.2886p pd=2.26u as=0.14875p ps=1.16u w=0.74u l=0.13u
X2921 VSS.t1911 VDD.t2448 VSS.t1913 VSS.t1912 sg13_lv_nmos ad=79.8f pd=0.8u as=0 ps=0 w=0.42u l=1u
X2922 VDD.t451 VSS.t291 VDD.t448 VDD.t5 sg13_lv_pmos ad=0.19p pd=1.38u as=0 ps=0 w=1u l=1u
X2923 VSS.t1628 VDD.t2557 VSS.t1630 VSS.t1629 sg13_lv_nmos ad=79.8f pd=0.8u as=0 ps=0 w=0.42u l=1u
X2924 a_20384_16283# a_20503_15960# VSS.t132 VSS.t337 sg13_lv_nmos ad=0.2516p pd=2.16u as=0.1406p ps=1.12u w=0.74u l=0.13u
X2925 a_14842_13342# sg13cmos5l_nand2_1_15.B VSS.t245 VSS.t1395 sg13_lv_nmos ad=0.1406p pd=1.12u as=0.2516p ps=2.16u w=0.74u l=0.13u
X2926 sg13cmos5l_dlygate4sd3_1_33.X a_3894_9972# VSS.t820 VSS.t2214 sg13_lv_nmos ad=0.2516p pd=2.16u as=0.1426p ps=1.16u w=0.74u l=0.13u
X2927 VSS.t260 sg13cmos5l_nor2_1_2.B a_7362_8802# VSS.t2485 sg13_lv_nmos ad=0.2516p pd=2.16u as=0.1406p ps=1.12u w=0.74u l=0.13u
X2928 a_9136_10190# sg13cmos5l_dfrbpq_1_13.RESET_B VDD.t52 VDD.t52 sg13_lv_pmos ad=79.8f pd=0.8u as=1.79022p ps=11.585u w=0.42u l=0.13u
X2929 VSS.t239 a_13670_15238# a_13782_15302# VSS.t858 sg13_lv_nmos ad=0.1426p pd=1.16u as=0.1428p ps=1.52u w=0.42u l=0.5u
X2930 VSS.t1805 VDD.t2490 VSS.t1805 VSS.t1822 sg13_lv_nmos ad=0.1428p pd=1.52u as=0 ps=0 w=0.42u l=1u
X2931 a_15983_6239# a_15141_6141# a_14724_6480# VDD.t2 sg13_lv_pmos ad=0.2048p pd=1.63u as=0.34p ps=2.68u w=1u l=0.13u
X2932 a_22658_18258# sg13cmos5l_dfrbpq_1_28.RESET_B.t11 VSS.t831 VSS.t140 sg13_lv_nmos ad=60.89999f pd=0.71u as=0.1626p ps=1.415u w=0.42u l=0.13u
X2933 sg13cmos5l_a21oi_1_4.A2 a_13096_15996# VSS.t204 VSS.t1455 sg13_lv_nmos ad=0.2886p pd=2.26u as=0.14875p ps=1.16u w=0.74u l=0.13u
X2934 VSS.t1732 VDD.t2510 VSS.t1731 VSS.t1730 sg13_lv_nmos ad=0.1428p pd=1.52u as=0 ps=0 w=0.42u l=1u
X2935 a_7428_10386# sg13cmos5l_dfrbpq_1_14.D a_7334_10386# VSS.t1582 sg13_lv_nmos ad=60.89999f pd=0.71u as=0.1428p ps=1.52u w=0.42u l=0.13u
X2936 VSS.t1941 VDD.t2442 VSS.t1940 VSS.t1957 sg13_lv_nmos ad=0.1428p pd=1.52u as=0 ps=0 w=0.42u l=1u
X2937 VSS.t1140 sg13cmos5l_o21ai_1_20.A1 a_10774_17886# VSS.t1137 sg13_lv_nmos ad=0.1406p pd=1.12u as=0.2516p ps=2.16u w=0.74u l=0.15u
X2938 a_21839_10309# a_20997_9959# a_20580_9952# VDD.t52 sg13_lv_pmos ad=0.2048p pd=1.63u as=0.34p ps=2.68u w=1u l=0.13u
X2939 a_13322_13722# a_13015_13686# a_13228_13722# VSS.t66 sg13_lv_nmos ad=37.8f pd=0.6u as=0.1428p ps=1.52u w=0.42u l=0.13u
X2940 a_6418_15230# sg13cmos5l_o21ai_1_11.B1 sg13cmos5l_o21ai_1_11.Y VSS.t1307 sg13_lv_nmos ad=0.1406p pd=1.12u as=0.2516p ps=2.16u w=0.74u l=0.15u
X2941 a_20806_10373# sg13cmos5l_buf_1_13.X VSS.t596 VSS.t595 sg13_lv_nmos ad=37.8f pd=0.6u as=0.1701p ps=1.65u w=0.42u l=0.13u
X2942 a_18352_19990# sg13cmos5l_buf_1_45.X.t12 VDD.t270 VDD.t270 sg13_lv_pmos ad=79.8f pd=0.8u as=2.51485p ps=16.46u w=0.42u l=0.13u
X2943 a_17604_11464# a_17578_11428# VDD.t1039 VDD.t0 sg13_lv_pmos ad=0.34p pd=2.68u as=0.36237p ps=2.605u w=1u l=0.13u
X2944 VSS.t820 a_3782_9948# a_3894_9972# VSS.t819 sg13_lv_nmos ad=0.1426p pd=1.16u as=0.1428p ps=1.52u w=0.42u l=0.5u
X2945 sg13cmos5l_dlygate4sd3_1_14.A sg13cmos5l_a21oi_1_4.B1 VSS.t120 VSS.t303 sg13_lv_nmos ad=0.1406p pd=1.12u as=0.2516p ps=2.16u w=0.74u l=0.13u
X2946 sg13cmos5l_dfrbpq_1_17.Q a_7338_7972# VDD.t1125 VDD.t8 sg13_lv_pmos ad=0.3808p pd=2.92u as=0.2128p ps=1.5u w=1.12u l=0.13u
X2947 a_7726_8703# a_7841_8702# VDD.t1936 VDD.t8 sg13_lv_pmos ad=0.34p pd=2.68u as=0.2254p ps=1.53u w=1u l=0.5u
X2948 VSS.t1747 VDD.t2507 VSS.t1746 VSS.t1745 sg13_lv_nmos ad=0.1428p pd=1.52u as=0 ps=0 w=0.42u l=1u
X2949 a_20580_6928# a_21099_6935# a_21839_7285# VSS.t36 sg13_lv_nmos ad=0.3473p pd=2.71u as=0.12665p ps=1.145u w=0.74u l=0.13u
X2950 a_20997_8447# sg13cmos5l_inv_1_2.A VSS.t264 VSS.t263 sg13_lv_nmos ad=0.2516p pd=2.16u as=5.26052p ps=34.445u w=0.74u l=0.13u
X2951 VDD.t922 a_22522_17472# a_22241_17774# VDD.t310 sg13_lv_pmos ad=0.1523p pd=1.38u as=0.34p ps=2.68u w=1u l=0.5u
X2952 a_20997_14495# sg13cmos5l_dfrbpq_1_5.CLK VSS.t1542 VSS.t1565 sg13_lv_nmos ad=0.2516p pd=2.16u as=6.40482p ps=41.475u w=0.74u l=0.13u
X2953 VDD.t1008 a_16838_9948# a_16950_9972# VDD.t52 sg13_lv_pmos ad=0.2254p pd=1.53u as=0.34p ps=2.68u w=1u l=0.5u
X2954 VSS.t284 sg13cmos5l_nand2_1_0.B a_13018_7678# VSS.t1021 sg13_lv_nmos ad=0.2516p pd=2.16u as=0.1406p ps=1.12u w=0.74u l=0.13u
X2955 sg13cmos5l_dfrbpq_1_19.CLK a_7498_18226# VSS.t5 VSS.t2267 sg13_lv_nmos ad=0.1406p pd=1.12u as=0.1406p ps=1.12u w=0.74u l=0.13u
X2956 VDD.t1045 sg13cmos5l_a21oi_1_14.Y a_21911_18649# VDD.t231 sg13_lv_pmos ad=0.1428p pd=1.52u as=79.8f ps=0.8u w=0.42u l=0.13u
X2957 sg13cmos5l_dlygate4sd3_1_64.X a_5334_17532# VSS.t70 VSS.t68 sg13_lv_nmos ad=0.2516p pd=2.16u as=0.1426p ps=1.16u w=0.74u l=0.13u
X2958 sg13cmos5l_dlygate4sd3_1_29.A sg13cmos5l_a21oi_1_2.B1 a_19733_6924# VDD.t2 sg13_lv_pmos ad=0.3808p pd=2.92u as=0.2128p ps=1.5u w=1.12u l=0.13u
X2959 a_22005_16043# a_21063_16083# a_21911_16043# VDD.t16 sg13_lv_pmos ad=79.8f pd=0.8u as=0.1428p ps=1.52u w=0.42u l=0.13u
X2960 VDD.t532 VSS.t1751 VDD.t577 VDD.t0 sg13_lv_pmos ad=0.34p pd=2.68u as=0 ps=0 w=1u l=1u
X2961 a_5830_13397# sg13cmos5l_dfrbpq_1_24.RESET_B VSS.t182 VSS.t1121 sg13_lv_nmos ad=37.8f pd=0.6u as=0.1701p ps=1.65u w=0.42u l=0.13u
X2962 sg13cmos5l_mux2_1_1.X a_8734_12214# VSS.t74 VSS.t950 sg13_lv_nmos ad=0.4033p pd=2.57u as=0.148p ps=1.14u w=0.74u l=0.13u
X2963 VDD.t52 a_6640_9406# a_6585_9501# VDD.t52 sg13_lv_pmos ad=1.8716p pd=12.115u as=93.45f ps=0.865u w=0.42u l=0.13u
X2964 a_21063_18476# a_21215_18528# VSS.t242 VSS.t1372 sg13_lv_nmos ad=0.2516p pd=2.16u as=4.1963p ps=27.415u w=0.74u l=0.13u
X2965 a_12420_19024# a_12394_18988# VSS.t107 VSS.t1294 sg13_lv_nmos ad=0.2516p pd=2.16u as=0.1626p ps=1.415u w=0.74u l=0.13u
X2966 VDD.t1713 sg13cmos5l_nand4_1_18.A sg13cmos5l_a21oi_1_2.A2 VDD.t83 sg13_lv_pmos ad=0.3808p pd=2.92u as=0.2128p ps=1.5u w=1.12u l=0.13u
X2967 VDD.t680 sg13cmos5l_a21oi_1_17.Y a_17608_13760# VDD.t19 sg13_lv_pmos ad=0.2114p pd=1.54u as=0.2856p ps=2.36u w=0.84u l=0.13u
X2968 VSS.t1130 sg13cmos5l_buf_1_15.A.t6 a_9156_19770# VSS.t1177 sg13_lv_nmos ad=0.1626p pd=1.415u as=60.89999f ps=0.71u w=0.42u l=0.13u
X2969 a_18682_16714# sg13cmos5l_dfrbpq_1_30.Q VSS.t132 VSS.t575 sg13_lv_nmos ad=0.1428p pd=1.52u as=79.8f ps=0.8u w=0.42u l=0.13u
X2970 VDD.t400 VSS.t1687 VDD.t399 VDD.t83 sg13_lv_pmos ad=0.34p pd=2.68u as=0 ps=0 w=1u l=1u
X2971 a_19923_4248# sg13cmos5l_a21oi_1_2.A2 VSS.t273 VSS.t679 sg13_lv_nmos ad=0.1406p pd=1.12u as=0.2516p ps=2.16u w=0.74u l=0.13u
X2972 VDD.t1066 sg13cmos5l_dfrbpq_1_28.RESET_B.t6 a_20294_14922# VDD.t19 sg13_lv_pmos ad=0.36237p pd=2.605u as=79.8f ps=0.8u w=0.42u l=0.13u
X2973 VSS.t1688 VDD.t2528 VSS.t1690 VSS.t1689 sg13_lv_nmos ad=79.8f pd=0.8u as=0 ps=0 w=0.42u l=1u
X2974 sg13cmos5l_nand3b_1_1.C a_7350_17532# VSS.t5 VSS.t64 sg13_lv_nmos ad=0.2516p pd=2.16u as=0.1426p ps=1.16u w=0.74u l=0.13u
X2975 VSS.t1926 VDD.t2454 VSS.t1925 VSS.t1924 sg13_lv_nmos ad=0.1428p pd=1.52u as=0 ps=0 w=0.42u l=1u
X2976 a_14661_19749# sg13cmos5l_dfrbpq_1_41.CLK VSS.t169 VSS.t168 sg13_lv_nmos ad=0.2516p pd=2.16u as=3.5562p ps=22.685u w=0.74u l=0.13u
X2977 a_22523_15532# sg13cmos5l_a21oi_1_18.B1 sg13cmos5l_a21oi_1_14.Y VDD.t16 sg13_lv_pmos ad=0.2128p pd=1.5u as=0.3808p ps=2.92u w=1.12u l=0.13u
X2978 VDD.t1117 sg13cmos5l_a21oi_1_9.A1 a_10878_7180# VDD.t2 sg13_lv_pmos ad=0.2856p pd=2.36u as=0.1596p ps=1.22u w=0.84u l=0.13u
X2979 sg13cmos5l_buf_8_2.A a_12987_12214# VSS.t153 VSS.t2627 sg13_lv_nmos ad=0.1406p pd=1.12u as=0.1406p ps=1.12u w=0.74u l=0.13u
X2980 sg13cmos5l_a21oi_1_3.A2 sg13cmos5l_nand4_1_8.B VDD.t1723 VDD.t19 sg13_lv_pmos ad=0.2128p pd=1.5u as=0.2128p ps=1.5u w=1.12u l=0.13u
X2981 VDD.t1517 sg13cmos5l_o21ai_1_20.A1 a_4220_17488# VDD.t310 sg13_lv_pmos ad=0.3808p pd=2.92u as=0.2128p ps=1.5u w=1.12u l=0.15u
X2982 VDD.t1684 sg13cmos5l_nand4_1_1.A sg13cmos5l_a21oi_1_13.A2 VDD.t19 sg13_lv_pmos ad=0.3808p pd=2.92u as=0.2128p ps=1.5u w=1.12u l=0.13u
X2983 sg13cmos5l_a21o_1_1.A2 sg13cmos5l_nand2b_1_1.A_N a_9562_9190# VSS.t2221 sg13_lv_nmos ad=0.2516p pd=2.16u as=0.1406p ps=1.12u w=0.74u l=0.13u
X2984 a_12902_17508# a_12632_17549# VDD.t1092 VDD.t310 sg13_lv_pmos ad=0.34p pd=2.68u as=0.1523p ps=1.38u w=1u l=0.5u
X2985 a_18104_14850# sg13cmos5l_nand4_1_1.C a_18002_14850# VSS.t1359 sg13_lv_nmos ad=0.1406p pd=1.12u as=0.1406p ps=1.12u w=0.74u l=0.13u
X2986 VSS.t1732 VDD.t2521 VSS.t1731 VSS.t1730 sg13_lv_nmos ad=0.1428p pd=1.52u as=0 ps=0 w=0.42u l=1u
X2987 VDD.t52 a_11759_10309# a_12016_10190# VDD.t52 sg13_lv_pmos ad=1.8716p pd=12.115u as=79.8f ps=0.8u w=0.42u l=0.13u
X2988 a_22126_9375# a_22241_9376# VSS.t15 VSS.t341 sg13_lv_nmos ad=0.1428p pd=1.52u as=0.1426p ps=1.16u w=0.42u l=0.5u
X2989 VDD.t653 a_18490_9154# a_18209_9376# VDD.t52 sg13_lv_pmos ad=0.1523p pd=1.38u as=0.34p ps=2.68u w=1u l=0.5u
X2990 VSS.t293 a_9646_6351# sg13cmos5l_dfrbpq_1_13.D VSS.t559 sg13_lv_nmos ad=0.1426p pd=1.16u as=0.2516p ps=2.16u w=0.74u l=0.13u
X2991 VSS.t1703 VDD.t2525 VSS.t1705 VSS.t1704 sg13_lv_nmos ad=79.8f pd=0.8u as=0 ps=0 w=0.42u l=1u
X2992 VDD.t94 VSS.t2010 VDD.t93 VDD.t13 sg13_lv_pmos ad=0.34p pd=2.68u as=0 ps=0 w=1u l=1u
X2993 a_20012_14448# sg13cmos5l_buf_1_42.A VDD.t899 VDD.t19 sg13_lv_pmos ad=0.2856p pd=2.36u as=0.2114p ps=1.54u w=0.84u l=0.13u
X2994 a_22126_4167# a_22241_4166# VDD.t720 VDD.t13 sg13_lv_pmos ad=0.34p pd=2.68u as=0.2254p ps=1.53u w=1u l=0.5u
X2995 VDD.t906 a_12902_8436# a_13014_8460# VDD.t8 sg13_lv_pmos ad=0.2254p pd=1.53u as=0.34p ps=2.68u w=1u l=0.5u
X2996 a_14133_5459# a_13191_5499# a_13994_5692# VSS.t277 sg13_lv_nmos ad=79.8f pd=0.8u as=0.2373p ps=1.97u w=0.42u l=0.13u
X2997 a_17922_16754# sg13cmos5l_buf_1_43.X a_17820_16754# VSS.t2584 sg13_lv_nmos ad=0.1406p pd=1.12u as=0.1406p ps=1.12u w=0.74u l=0.13u
X2998 a_14446_9375# a_14561_9376# VDD.t2132 VDD.t52 sg13_lv_pmos ad=0.34p pd=2.68u as=0.2254p ps=1.53u w=1u l=0.5u
X2999 VSS.t1604 VDD.t2561 VSS.t1605 VSS.t1612 sg13_lv_nmos ad=79.8f pd=0.8u as=0 ps=0 w=0.42u l=1u
X3000 a_18680_12218# sg13cmos5l_nand4_1_1.C a_18578_12218# VSS.t1361 sg13_lv_nmos ad=0.1406p pd=1.12u as=0.1406p ps=1.12u w=0.74u l=0.13u
X3001 VDD.t8 a_6671_7751# a_6928_7894# VDD.t8 sg13_lv_pmos ad=1.8716p pd=12.115u as=79.8f ps=0.8u w=0.42u l=0.13u
X3002 a_16068_18271# a_15780_18576# a_16006_18271# VSS.t1019 sg13_lv_nmos ad=0.1428p pd=1.52u as=37.8f ps=0.6u w=0.42u l=0.13u
X3003 a_18780_13730# sg13cmos5l_nor4_1_2.Y a_18678_13730# VSS.t128 sg13_lv_nmos ad=0.1406p pd=1.12u as=0.1406p ps=1.12u w=0.74u l=0.13u
X3004 VDD.t1819 sg13cmos5l_o21ai_1_1.B1 a_11840_9389# VDD.t52 sg13_lv_pmos ad=0.2856p pd=2.36u as=0.1596p ps=1.22u w=0.84u l=0.13u
X3005 sg13cmos5l_a21oi_1_3.Y sg13cmos5l_a21oi_1_2.B1 a_17621_7972# VDD.t8 sg13_lv_pmos ad=0.3808p pd=2.92u as=0.2128p ps=1.5u w=1.12u l=0.13u
X3006 VSS.t199 a_11180_15198# sg13cmos5l_nor2b_1_1.A VSS.t1532 sg13_lv_nmos ad=0.14875p pd=1.16u as=0.2886p ps=2.26u w=0.74u l=0.13u
X3007 a_10710_14020# sg13cmos5l_nor3_1_4.A VDD.t1084 VDD.t19 sg13_lv_pmos ad=0.2128p pd=1.5u as=0.3808p ps=2.92u w=1.12u l=0.13u
X3008 a_16101_11460# sg13cmos5l_buf_1_14.A VDD.t741 VDD.t0 sg13_lv_pmos ad=0.2464p pd=1.56u as=0.3808p ps=2.92u w=1.12u l=0.13u
X3009 VSS.t132 a_19035_16750# sg13cmos5l_inv_1_31.A VSS.t447 sg13_lv_nmos ad=0.1406p pd=1.12u as=0.1406p ps=1.12u w=0.74u l=0.13u
X3010 VSS.t1747 VDD.t2518 VSS.t1746 VSS.t1745 sg13_lv_nmos ad=0.1428p pd=1.52u as=0 ps=0 w=0.42u l=1u
X3011 a_19077_10677# sg13cmos5l_dfrbpq_1_5.CLK VDD.t0 VDD.t0 sg13_lv_pmos ad=0.4088p pd=2.97u as=2.07625p ps=13.51u w=1.12u l=0.13u
X3012 VDD.t1610 sg13cmos5l_a21oi_1_24.A1 a_17243_17508# VDD.t310 sg13_lv_pmos ad=0.2128p pd=1.5u as=0.2128p ps=1.5u w=1.12u l=0.13u
X3013 VDD.t938 sg13cmos5l_buf_1_43.X a_17224_12972# VDD.t83 sg13_lv_pmos ad=0.2114p pd=1.54u as=0.2856p ps=2.36u w=0.84u l=0.13u
X3014 a_9157_9190# sg13cmos5l_nor3_1_2.C VSS.t190 VSS.t386 sg13_lv_nmos ad=0.1406p pd=1.12u as=0.14505p ps=1.15u w=0.74u l=0.13u
X3015 a_18756_5850# sg13cmos5l_dfrbpq_1_1.D a_18662_5850# VSS.t38 sg13_lv_nmos ad=60.89999f pd=0.71u as=0.1428p ps=1.52u w=0.42u l=0.13u
X3016 a_13670_15238# a_13400_15238# VDD.t1754 VDD.t16 sg13_lv_pmos ad=0.34p pd=2.68u as=0.1523p ps=1.38u w=1u l=0.5u
X3017 VSS.t636 sg13cmos5l_nand3_1_8.Y a_22625_15260# VSS.t197 sg13_lv_nmos ad=0.2516p pd=2.16u as=0.1406p ps=1.12u w=0.74u l=0.13u
X3018 sg13cmos5l_inv_1_36.A a_1192_14484# VDD.t803 VDD.t19 sg13_lv_pmos ad=0.42p pd=2.99u as=0.2114p ps=1.54u w=1.12u l=0.13u
X3019 VDD.t1198 a_5999_14845# a_6666_14484# VDD.t19 sg13_lv_pmos ad=0.2128p pd=1.5u as=0.3864p ps=2.93u w=1.12u l=0.13u
X3020 bp0 a_15208_12972# VDD.t882 VDD.t83 sg13_lv_pmos ad=0.42p pd=2.99u as=0.2114p ps=1.54u w=1.12u l=0.13u
X3021 VDD.t423 VSS.t1625 VDD.t472 VDD.t231 sg13_lv_pmos ad=0.19p pd=1.38u as=0 ps=0 w=1u l=1u
X3022 a_10788_18258# sg13cmos5l_dlygate4sd3_1_56.X a_10694_18258# VSS.t1263 sg13_lv_nmos ad=60.89999f pd=0.71u as=0.1428p ps=1.52u w=0.42u l=0.13u
X3023 VDD.t1146 a_13574_18262# a_13686_18326# VDD.t231 sg13_lv_pmos ad=0.2254p pd=1.53u as=0.34p ps=2.68u w=1u l=0.5u
X3024 VDD.t929 a_3500_19734# code8 VDD.t270 sg13_lv_pmos ad=0.2114p pd=1.54u as=0.42p ps=2.99u w=1.12u l=0.13u
X3025 VDD.t1628 sg13cmos5l_o21ai_1_20.Y a_3800_19061# VDD.t231 sg13_lv_pmos ad=0.1523p pd=1.38u as=0.1428p ps=1.52u w=0.42u l=0.13u
X3026 a_19930_15960# sg13cmos5l_nand2_1_1.A VDD.t1362 VDD.t16 sg13_lv_pmos ad=0.1428p pd=1.52u as=0.1523p ps=1.38u w=0.42u l=0.13u
X3027 sg13cmos5l_buf_8_2.A a_12987_12214# VSS.t153 VSS.t2623 sg13_lv_nmos ad=0.1406p pd=1.12u as=0.1406p ps=1.12u w=0.74u l=0.13u
X3028 VDD.t1657 a_6191_19381# a_6858_19020# VDD.t231 sg13_lv_pmos ad=0.2128p pd=1.5u as=0.3864p ps=2.93u w=1.12u l=0.13u
X3029 a_4454_14922# a_5259_14495# a_4714_14452# VDD.t19 sg13_lv_pmos ad=0.1428p pd=1.52u as=79.8f ps=0.8u w=0.42u l=0.13u
X3030 sg13cmos5l_inv_1_2.A a_19995_9190# VSS.t15 VSS.t353 sg13_lv_nmos ad=0.1406p pd=1.12u as=0.1406p ps=1.12u w=0.74u l=0.13u
X3031 a_15684_14850# sg13cmos5l_a21oi_1_4.A1 a_15582_14850# VSS.t144 sg13_lv_nmos ad=0.1406p pd=1.12u as=0.1406p ps=1.12u w=0.74u l=0.13u
X3032 a_8115_5760# sg13cmos5l_a21oi_1_8.A2 VSS.t1964 VSS.t2386 sg13_lv_nmos ad=0.1406p pd=1.12u as=0.2516p ps=2.16u w=0.74u l=0.13u
X3033 sg13cmos5l_dlygate4sd3_1_65.A a_9450_19020# VDD.t1527 VDD.t231 sg13_lv_pmos ad=0.3808p pd=2.92u as=0.2128p ps=1.5u w=1.12u l=0.13u
X3034 VSS.t72 a_22042_15202# a_21761_15424# VSS.t197 sg13_lv_nmos ad=79.8f pd=0.8u as=0.1428p ps=1.52u w=0.42u l=0.5u
X3035 a_9349_13342# sg13cmos5l_mux2_1_1.A1 VSS.t67 VSS.t149 sg13_lv_nmos ad=0.1406p pd=1.12u as=0.14505p ps=1.15u w=0.74u l=0.13u
X3036 VDD.t209 VSS.t820 VDD.t502 VDD.t0 sg13_lv_pmos ad=0.34p pd=2.68u as=0 ps=0 w=1u l=1u
X3037 a_20554_9916# a_20997_9959# a_20294_10386# VSS.t2383 sg13_lv_nmos ad=79.8f pd=0.8u as=0.1296p ps=1.52u w=0.42u l=0.13u
X3038 a_20294_13722# a_21099_13844# a_20554_13945# VDD.t19 sg13_lv_pmos ad=0.1428p pd=1.52u as=79.8f ps=0.8u w=0.42u l=0.13u
X3039 VSS.t1204 VDD.t2441 VSS.t256 VSS.t1959 sg13_lv_nmos ad=0.1428p pd=1.52u as=0 ps=0 w=0.42u l=1u
X3040 a_14181_16007# sg13cmos5l_dfrbpq_1_41.CLK VDD.t16 VDD.t16 sg13_lv_pmos ad=0.4088p pd=2.97u as=1.97245p ps=12.835u w=1.12u l=0.13u
X3041 VDD.t1130 a_13749_9386# sg13cmos5l_inv_1_8.A VDD.t52 sg13_lv_pmos ad=0.2128p pd=1.5u as=0.3808p ps=2.92u w=1.12u l=0.13u
X3042 VSS.t587 a_22126_17775# sg13cmos5l_inv_1_17.A VSS.t225 sg13_lv_nmos ad=0.1426p pd=1.16u as=0.2516p ps=2.16u w=0.74u l=0.13u
X3043 sg13cmos5l_or4_1_0.D a_7050_9484# VDD.t1985 VDD.t52 sg13_lv_pmos ad=0.3808p pd=2.92u as=0.2128p ps=1.5u w=1.12u l=0.13u
X3044 VDD.t449 VSS.t291 VDD.t448 VDD.t5 sg13_lv_pmos ad=0.34p pd=2.68u as=0 ps=0 w=1u l=1u
X3045 VDD.t980 a_19642_6130# a_19361_6352# VDD.t2 sg13_lv_pmos ad=0.1523p pd=1.38u as=0.34p ps=2.68u w=1u l=0.5u
X3046 sg13cmos5l_nand4_1_18.C a_17224_12972# VDD.t938 VDD.t83 sg13_lv_pmos ad=0.42p pd=2.99u as=0.2114p ps=1.54u w=1.12u l=0.13u
X3047 VDD.t860 a_11770_17472# a_11489_17774# VDD.t310 sg13_lv_pmos ad=0.1523p pd=1.38u as=0.34p ps=2.68u w=1u l=0.5u
X3048 a_10428_14484# sg13cmos5l_buf_1_65.A a_10326_14484# VDD.t19 sg13_lv_pmos ad=0.2128p pd=1.5u as=0.2128p ps=1.5u w=1.12u l=0.13u
X3049 VDD.t1002 sg13cmos5l_inv_1_6.Y a_22235_5412# VDD.t5 sg13_lv_pmos ad=0.2128p pd=1.5u as=0.2128p ps=1.5u w=1.12u l=0.13u
X3050 VSS.t15 a_19995_9190# sg13cmos5l_inv_1_2.A VSS.t350 sg13_lv_nmos ad=0.1406p pd=1.12u as=0.1406p ps=1.12u w=0.74u l=0.13u
X3051 a_21063_18476# a_21215_18528# VDD.t231 VDD.t231 sg13_lv_pmos ad=0.3864p pd=2.93u as=1.54512p ps=9.865u w=1.12u l=0.13u
X3052 a_20580_12528# a_21099_12332# a_21839_12287# VSS.t16 sg13_lv_nmos ad=0.3473p pd=2.71u as=0.12665p ps=1.145u w=0.74u l=0.13u
X3053 a_12381_13912# sg13cmos5l_buf_1_66.X VSS.t159 VSS.t66 sg13_lv_nmos ad=0.187p pd=1.78u as=0.14505p ps=1.15u w=0.55u l=0.13u
X3054 VSS.t132 a_19035_16750# sg13cmos5l_inv_1_31.A VSS.t443 sg13_lv_nmos ad=0.1406p pd=1.12u as=0.1406p ps=1.12u w=0.74u l=0.13u
X3055 VSS.t1911 VDD.t2457 VSS.t1910 VSS.t1909 sg13_lv_nmos ad=0.1428p pd=1.52u as=0 ps=0 w=0.42u l=1u
X3056 VDD.t89 VSS.t2010 VDD.t88 VDD.t5 sg13_lv_pmos ad=0.34p pd=2.68u as=0 ps=0 w=1u l=1u
X3057 a_20294_6166# a_20024_6166# VDD.t765 VDD.t2 sg13_lv_pmos ad=0.34p pd=2.68u as=0.1523p ps=1.38u w=1u l=0.5u
X3058 a_17193_20161# a_16836_20088# VDD.t892 VDD.t270 sg13_lv_pmos ad=63f pd=0.72u as=0.1563p ps=1.22u w=0.42u l=0.13u
X3059 a_21839_12287# a_20997_12189# a_20580_12528# VDD.t83 sg13_lv_pmos ad=0.2048p pd=1.63u as=0.34p ps=2.68u w=1u l=0.13u
X3060 a_12987_12214# clk VSS.t153 VSS.t715 sg13_lv_nmos ad=0.1406p pd=1.12u as=0.1406p ps=1.12u w=0.74u l=0.13u
X3061 a_18634_10921# a_19077_10677# a_19017_11089# VDD.t0 sg13_lv_pmos ad=79.8f pd=0.8u as=63f ps=0.72u w=0.42u l=0.13u
X3062 a_21063_16083# a_21215_15967# VDD.t16 VDD.t16 sg13_lv_pmos ad=0.3864p pd=2.93u as=2.07625p ps=13.51u w=1.12u l=0.13u
X3063 VDD.t253 VSS.t60 VDD.t252 VDD.t83 sg13_lv_pmos ad=0.19p pd=1.38u as=0 ps=0 w=1u l=1u
X3064 VDD.t1048 a_12597_11722# sg13cmos5l_nand2_1_19.A VDD.t0 sg13_lv_pmos ad=0.2128p pd=1.5u as=0.3808p ps=2.92u w=1.12u l=0.13u
X3065 a_19174_5837# sg13cmos5l_buf_1_7.X VSS.t11 VSS.t40 sg13_lv_nmos ad=37.8f pd=0.6u as=0.1701p ps=1.65u w=0.42u l=0.13u
X3066 VDD.t74 VSS.t825 VDD.t73 VDD.t2 sg13_lv_pmos ad=0.34p pd=2.68u as=0 ps=0 w=1u l=1u
X3067 VSS.t190 sg13cmos5l_or4_1_0.C a_8520_8436# VSS.t2388 sg13_lv_nmos ad=0.16755p pd=1.165u as=0.1045p ps=0.93u w=0.55u l=0.13u
X3068 a_6524_15552# sg13cmos5l_o21ai_1_11.A2 sg13cmos5l_o21ai_1_11.Y VDD.t16 sg13_lv_pmos ad=0.2128p pd=1.5u as=0.2128p ps=1.5u w=1.12u l=0.15u
X3069 a_22096_12430# a_21839_12287# a_22258_12210# VSS.t16 sg13_lv_nmos ad=0.1428p pd=1.52u as=37.8f ps=0.6u w=0.42u l=0.13u
X3070 VDD.t1968 a_8955_9228# sg13cmos5l_nand2b_1_5.Y VDD.t52 sg13_lv_pmos ad=0.3808p pd=2.92u as=0.2128p ps=1.5u w=1.12u l=0.13u
X3071 VDD.t1362 a_19930_15960# a_19649_16262# VDD.t16 sg13_lv_pmos ad=0.1523p pd=1.38u as=0.34p ps=2.68u w=1u l=0.5u
X3072 VSS.t190 a_9934_9375# sg13cmos5l_nand4_1_0.C VSS.t743 sg13_lv_nmos ad=0.1426p pd=1.16u as=0.2516p ps=2.16u w=0.74u l=0.13u
X3073 VDD.t431 VSS.t571 VDD.t204 VDD.t8 sg13_lv_pmos ad=0.19p pd=1.38u as=0 ps=0 w=1u l=1u
X3074 VDD.t791 sg13cmos5l_o21ai_1_22.B1 sg13cmos5l_o21ai_1_22.Y VDD.t310 sg13_lv_pmos ad=0.3808p pd=2.92u as=0.2128p ps=1.5u w=1.12u l=0.15u
X3075 a_7836_16362# sg13cmos5l_a21oi_1_4.A1 sg13cmos5l_nand3_1_5.Y VSS.t141 sg13_lv_nmos ad=0.1406p pd=1.12u as=0.2516p ps=2.16u w=0.74u l=0.13u
X3076 a_20012_14448# sg13cmos5l_buf_1_42.A VSS.t433 VSS.t432 sg13_lv_nmos ad=0.187p pd=1.78u as=0.14875p ps=1.16u w=0.55u l=0.13u
X3077 VDD.t1679 sg13cmos5l_nand4_1_1.A sg13cmos5l_a21oi_1_23.A2 VDD.t19 sg13_lv_pmos ad=0.3808p pd=2.92u as=0.2128p ps=1.5u w=1.12u l=0.13u
X3078 VDD.t1368 sg13cmos5l_nor3_1_7.Y a_19048_12248# VDD.t83 sg13_lv_pmos ad=0.2114p pd=1.54u as=0.2856p ps=2.36u w=0.84u l=0.13u
X3079 a_12656_11826# a_12597_11722# sg13cmos5l_nand2_1_19.A VSS.t939 sg13_lv_nmos ad=0.1406p pd=1.12u as=0.3404p ps=2.4u w=0.74u l=0.13u
X3080 a_6442_10666# sg13cmos5l_buf_8_2.A.t3 VSS.t362 VSS.t1025 sg13_lv_nmos ad=0.1406p pd=1.12u as=0.1406p ps=1.12u w=0.74u l=0.13u
X3081 VSS.t210 a_22522_3106# a_22241_3328# VSS.t798 sg13_lv_nmos ad=79.8f pd=0.8u as=0.1428p ps=1.52u w=0.42u l=0.5u
X3082 VSS.t19 a_18671_7285# a_19338_6924# VSS.t893 sg13_lv_nmos ad=0.1406p pd=1.12u as=0.2516p ps=2.16u w=0.74u l=0.13u
X3083 sg13cmos5l_dfrbpq_1_33.Q a_17706_18556# VSS.t180 VSS.t92 sg13_lv_nmos ad=0.2516p pd=2.16u as=0.1406p ps=1.12u w=0.74u l=0.13u
X3084 VSS.t103 sg13cmos5l_buf_1_10.A sg13cmos5l_inv_1_20.Y VSS.t195 sg13_lv_nmos ad=0.2516p pd=2.16u as=0.2516p ps=2.16u w=0.74u l=0.13u
X3085 a_22262_16759# a_21084_16710# a_21866_16904# VSS.t951 sg13_lv_nmos ad=37.8f pd=0.6u as=0.1428p ps=1.52u w=0.42u l=0.13u
X3086 a_17892_11885# a_17604_11464# a_17830_11885# VSS.t1363 sg13_lv_nmos ad=0.1428p pd=1.52u as=37.8f ps=0.6u w=0.42u l=0.13u
X3087 VDD.t794 a_13676_12936# sg13cmos5l_buf_1_45.X.t0 VDD.t83 sg13_lv_pmos ad=0.2114p pd=1.54u as=0.42p ps=2.99u w=1.12u l=0.13u
X3088 VDD.t174 VSS.t1862 VDD.t632 VDD.t8 sg13_lv_pmos ad=0.19p pd=1.38u as=0 ps=0 w=1u l=1u
X3089 a_20868_4663# a_20580_4968# a_20806_4663# VSS.t21 sg13_lv_nmos ad=0.1428p pd=1.52u as=37.8f ps=0.6u w=0.42u l=0.13u
X3090 VDD.t1363 sg13cmos5l_nand3_1_0.C sg13cmos5l_nand3_1_0.Y VDD.t2 sg13_lv_pmos ad=0.3808p pd=2.92u as=0.2128p ps=1.5u w=1.12u l=0.13u
X3091 VSS.t132 sg13cmos5l_buf_8_2.A.t5 a_19035_16750# VSS.t1380 sg13_lv_nmos ad=0.1406p pd=1.12u as=0.2553p ps=2.17u w=0.74u l=0.13u
X3092 VDD.t279 VSS.t1692 VDD.t282 VDD.t19 sg13_lv_pmos ad=0.34p pd=2.68u as=0 ps=0 w=1u l=1u
X3093 a_7846_10373# sg13cmos5l_dfrbpq_1_13.RESET_B VSS.t362 VSS.t1202 sg13_lv_nmos ad=37.8f pd=0.6u as=0.1701p ps=1.65u w=0.42u l=0.13u
X3094 a_13390_7863# a_13505_7864# VDD.t821 VDD.t8 sg13_lv_pmos ad=0.34p pd=2.68u as=0.2254p ps=1.53u w=1u l=0.5u
X3095 VDD.t231 a_13936_19262# a_13881_19143# VDD.t231 sg13_lv_pmos ad=1.54512p pd=9.865u as=93.45f ps=0.865u w=0.42u l=0.13u
X3096 sg13cmos5l_inv_1_36.A a_1192_14484# VSS.t312 VSS.t734 sg13_lv_nmos ad=0.2886p pd=2.26u as=0.14875p ps=1.16u w=0.74u l=0.13u
X3097 VSS.t124 a_5999_14845# a_6666_14484# VSS.t794 sg13_lv_nmos ad=0.1406p pd=1.12u as=0.2516p ps=2.16u w=0.74u l=0.13u
X3098 a_8879_10309# a_8037_9959# a_7620_9952# VDD.t52 sg13_lv_pmos ad=0.2048p pd=1.63u as=0.34p ps=2.68u w=1u l=0.13u
X3099 sg13cmos5l_o21ai_1_20.Y sg13cmos5l_o21ai_1_20.B1 VDD.t2170 VDD.t310 sg13_lv_pmos ad=0.2128p pd=1.5u as=0.3808p ps=2.92u w=1.12u l=0.15u
X3100 a_18374_7674# sg13cmos5l_dlygate4sd3_1_29.X VDD.t1123 VDD.t8 sg13_lv_pmos ad=79.8f pd=0.8u as=0.1428p ps=1.52u w=0.42u l=0.13u
X3101 a_20937_14531# a_20580_14488# VDD.t1026 VDD.t19 sg13_lv_pmos ad=63f pd=0.72u as=0.1563p ps=1.22u w=0.42u l=0.13u
X3102 a_10053_12189# sg13cmos5l_dfrbpq_1_13.CLK VSS.t2 VSS.t156 sg13_lv_nmos ad=0.2516p pd=2.16u as=4.21822p ps=27.295u w=0.74u l=0.13u
X3103 VSS.t266 a_10917_9959# a_11019_9959# VSS.t606 sg13_lv_nmos ad=4.90217p pd=31.68u as=0.2516p ps=2.16u w=0.74u l=0.13u
X3104 a_19236_5837# a_19467_5423# a_18922_5380# VSS.t2275 sg13_lv_nmos ad=0.2373p pd=1.97u as=79.8f ps=0.8u w=0.42u l=0.13u
X3105 VSS.t190 sg13cmos5l_nand3_1_4.Y a_9394_8814# VSS.t796 sg13_lv_nmos ad=0.1406p pd=1.12u as=0.1406p ps=1.12u w=0.74u l=0.15u
X3106 sg13cmos5l_inv_1_2.A a_19995_9190# VDD.t833 VDD.t52 sg13_lv_pmos ad=0.2128p pd=1.5u as=0.2128p ps=1.5u w=1.12u l=0.13u
X3107 VSS.t99 a_14938_6888# a_14657_7190# VSS.t773 sg13_lv_nmos ad=79.8f pd=0.8u as=0.1428p ps=1.52u w=0.42u l=0.5u
X3108 a_8122_10666# sg13cmos5l_dlygate4sd3_1_37.A VSS.t362 VSS.t1601 sg13_lv_nmos ad=0.1428p pd=1.52u as=79.8f ps=0.8u w=0.42u l=0.13u
X3109 sg13cmos5l_buf_1_7.X a_18952_4688# VSS.t273 VSS.t540 sg13_lv_nmos ad=0.2886p pd=2.26u as=0.14875p ps=1.16u w=0.74u l=0.13u
X3110 VDD.t98 VSS.t2010 VDD.t97 VDD.t13 sg13_lv_pmos ad=0.34p pd=2.68u as=0 ps=0 w=1u l=1u
X3111 VSS.t1931 VDD.t2444 VSS.t1930 VSS.t1929 sg13_lv_nmos ad=0.1428p pd=1.52u as=0 ps=0 w=0.42u l=1u
X3112 VSS.t759 sg13cmos5l_nand3_1_3.Y a_10522_7678# VSS.t1075 sg13_lv_nmos ad=0.2516p pd=2.16u as=0.1406p ps=1.12u w=0.74u l=0.13u
X3113 VDD.t270 a_14661_19749# a_14763_19892# VDD.t270 sg13_lv_pmos ad=2.69447p pd=17.64u as=0.3864p ps=2.93u w=1.12u l=0.13u
X3114 VDD.t1532 a_22426_18984# a_22145_19286# VDD.t231 sg13_lv_pmos ad=0.1523p pd=1.38u as=0.34p ps=2.68u w=1u l=0.5u
X3115 a_13574_18262# a_13304_18262# VSS.t380 VSS.t1285 sg13_lv_nmos ad=0.1428p pd=1.52u as=79.8f ps=0.8u w=0.42u l=0.5u
X3116 a_6442_10666# sg13cmos5l_buf_8_2.A.t3 VDD.t1406 VDD.t0 sg13_lv_pmos ad=0.2128p pd=1.5u as=0.2128p ps=1.5u w=1.12u l=0.13u
X3117 VSS.t122 sg13cmos5l_buf_1_3.A a_19720_3176# VSS.t1599 sg13_lv_nmos ad=0.14875p pd=1.16u as=0.187p ps=1.78u w=0.55u l=0.13u
X3118 a_5174_16759# a_3996_16710# a_4778_16904# VSS.t1459 sg13_lv_nmos ad=37.8f pd=0.6u as=0.1428p ps=1.52u w=0.42u l=0.13u
X3119 VSS.t2183 VDD.t2379 VSS.t2185 VSS.t2184 sg13_lv_nmos ad=79.8f pd=0.8u as=0 ps=0 w=0.42u l=1u
X3120 a_17700_7349# a_17931_6935# a_17386_6892# VSS.t2200 sg13_lv_nmos ad=0.2373p pd=1.97u as=79.8f ps=0.8u w=0.42u l=0.13u
X3121 sg13cmos5l_nand4_1_3.B sg13cmos5l_and4_1_1.A VSS.t67 VSS.t66 sg13_lv_nmos ad=0.1406p pd=1.12u as=0.2516p ps=2.16u w=0.74u l=0.13u
X3122 VDD.t157 VSS.t2125 VDD.t156 VDD.t13 sg13_lv_pmos ad=0.19p pd=1.38u as=0 ps=0 w=1u l=1u
X3123 a_18922_5380# a_19365_5423# a_19305_5459# VDD.t5 sg13_lv_pmos ad=79.8f pd=0.8u as=63f ps=0.72u w=0.42u l=0.13u
X3124 VDD.t167 VSS.t740 VDD.t166 VDD.t0 sg13_lv_pmos ad=0.34p pd=2.68u as=0 ps=0 w=1u l=1u
X3125 a_18374_10698# sg13cmos5l_dlygate4sd3_1_18.X VDD.t2309 VDD.t0 sg13_lv_pmos ad=79.8f pd=0.8u as=0.1428p ps=1.52u w=0.42u l=0.13u
X3126 VDD.t2026 a_6766_7191# sg13cmos5l_dlygate4sd3_1_43.X VDD.t2 sg13_lv_pmos ad=0.2254p pd=1.53u as=0.4256p ps=3u w=1.12u l=0.13u
X3127 a_11286_14020# sg13cmos5l_nor3_1_4.A VDD.t1082 VDD.t19 sg13_lv_pmos ad=0.2128p pd=1.5u as=0.3808p ps=2.92u w=1.12u l=0.13u
X3128 a_7238_17508# a_6968_17549# VDD.t1626 VDD.t310 sg13_lv_pmos ad=0.34p pd=2.68u as=0.1523p ps=1.38u w=1u l=0.5u
X3129 a_7726_10887# a_7841_10888# VSS.t362 VSS.t1596 sg13_lv_nmos ad=0.1428p pd=1.52u as=0.1426p ps=1.16u w=0.42u l=0.5u
X3130 VDD.t2108 a_14133_5459# a_13212_5773# VDD.t5 sg13_lv_pmos ad=0.36237p pd=2.605u as=0.34p ps=2.68u w=1u l=0.13u
X3131 VSS.t677 a_22005_16043# a_21084_16357# VSS.t676 sg13_lv_nmos ad=0.1626p pd=1.415u as=0.2516p ps=2.16u w=0.74u l=0.13u
X3132 sg13cmos5l_a21oi_1_5.A2 sg13cmos5l_nand4_1_15.B VDD.t749 VDD.t83 sg13_lv_pmos ad=0.2128p pd=1.5u as=0.2128p ps=1.5u w=1.12u l=0.13u
X3133 VSS.t420 sg13cmos5l_dfrbpq_1_44.Q a_14744_19061# VSS.t2530 sg13_lv_nmos ad=79.8f pd=0.8u as=0.1428p ps=1.52u w=0.42u l=0.13u
X3134 VDD.t1233 sg13cmos5l_buf_1_66.X a_4700_17488# VDD.t310 sg13_lv_pmos ad=0.3808p pd=2.92u as=0.2128p ps=1.5u w=1.12u l=0.15u
X3135 VSS.t953 a_11374_17775# sg13cmos5l_o21ai_1_22.B1 VSS.t952 sg13_lv_nmos ad=0.1426p pd=1.16u as=0.2516p ps=2.16u w=0.74u l=0.13u
X3136 VDD.t1514 sg13cmos5l_dfrbpq_1_24.RESET_B a_5578_12940# VDD.t83 sg13_lv_pmos ad=0.1563p pd=1.22u as=0.147p ps=1.54u w=0.42u l=0.13u
X3137 a_20974_18258# a_21215_18528# a_20503_18222# VSS.t118 sg13_lv_nmos ad=0.1428p pd=1.52u as=0.12665p ps=1.145u w=0.42u l=0.13u
X3138 a_12458_15996# sg13cmos5l_o21ai_1_5.A1 VDD.t1358 VDD.t16 sg13_lv_pmos ad=0.1176p pd=1.33u as=0.4032p ps=2.96u w=1.12u l=0.13u
X3139 a_20580_11464# a_20554_11428# VDD.t368 VDD.t0 sg13_lv_pmos ad=0.34p pd=2.68u as=0.36237p ps=2.605u w=1u l=0.13u
X3140 VSS.t1803 VDD.t2499 VSS.t820 VSS.t1802 sg13_lv_nmos ad=0.1428p pd=1.52u as=0 ps=0 w=0.42u l=1u
X3141 a_14218_19993# a_14661_19749# a_13958_19770# VSS.t167 sg13_lv_nmos ad=79.8f pd=0.8u as=0.1296p ps=1.52u w=0.42u l=0.13u
X3142 a_17578_11428# a_18021_11471# a_17318_11898# VSS.t170 sg13_lv_nmos ad=79.8f pd=0.8u as=0.1296p ps=1.52u w=0.42u l=0.13u
X3143 a_20997_4629# sg13cmos5l_inv_1_2.A VSS.t269 VSS.t268 sg13_lv_nmos ad=0.2516p pd=2.16u as=17.54618p ps=0.11546m w=0.74u l=0.13u
X3144 VSS.t1752 VDD.t2506 VSS.t1751 VSS.t1750 sg13_lv_nmos ad=0.1428p pd=1.52u as=0 ps=0 w=0.42u l=1u
X3145 VDD.t2 sg13cmos5l_dfrbpq_1_13.RESET_B a_6700_6162# VDD.t2 sg13_lv_pmos ad=2.1916p pd=14.26u as=79.8f ps=0.8u w=0.42u l=0.13u
X3146 VDD.t16 sg13cmos5l_dfrbpq_1_24.RESET_B a_3532_16434# VDD.t16 sg13_lv_pmos ad=2.07625p pd=13.51u as=79.8f ps=0.8u w=0.42u l=0.13u
X3147 VSS.t1916 VDD.t2447 VSS.t1915 VSS.t1914 sg13_lv_nmos ad=0.1428p pd=1.52u as=0 ps=0 w=0.42u l=1u
X3148 a_9646_6351# a_9761_6352# VSS.t293 VSS.t1085 sg13_lv_nmos ad=0.1428p pd=1.52u as=0.1426p ps=1.16u w=0.42u l=0.5u
X3149 a_12381_13912# sg13cmos5l_buf_1_66.X VDD.t1229 VDD.t19 sg13_lv_pmos ad=0.2856p pd=2.36u as=0.2198p ps=1.53u w=0.84u l=0.13u
X3150 a_17510_10702# a_17240_10702# VDD.t706 VDD.t0 sg13_lv_pmos ad=0.34p pd=2.68u as=0.1523p ps=1.38u w=1u l=0.5u
X3151 VDD.t2132 a_14446_9375# sg13cmos5l_dlygate4sd3_1_15.X VDD.t52 sg13_lv_pmos ad=0.2254p pd=1.53u as=0.4256p ps=3u w=1.12u l=0.13u
X3152 VSS.t1132 a_6448_19262# a_6097_19381# VSS.t1169 sg13_lv_nmos ad=79.8f pd=0.8u as=0.1428p ps=1.52u w=0.42u l=0.13u
X3153 VDD.t716 a_8015_11821# a_8682_11460# VDD.t0 sg13_lv_pmos ad=0.2128p pd=1.5u as=0.3864p ps=2.93u w=1.12u l=0.13u
X3154 sg13cmos5l_a21oi_1_9.Y sg13cmos5l_a21oi_1_9.B1 VSS.t291 VSS.t2495 sg13_lv_nmos ad=0.1406p pd=1.12u as=0.2516p ps=2.16u w=0.74u l=0.13u
X3155 VDD.t453 VSS.t291 VDD.t452 VDD.t5 sg13_lv_pmos ad=0.34p pd=2.68u as=0 ps=0 w=1u l=1u
X3156 VSS.t264 a_5541_9165# a_5643_9308# VSS.t364 sg13_lv_nmos ad=5.26052p pd=34.445u as=0.2516p ps=2.16u w=0.74u l=0.13u
X3157 sg13cmos5l_dlygate4sd3_1_28.A a_20586_7972# VDD.t2060 VDD.t8 sg13_lv_pmos ad=0.3808p pd=2.92u as=0.2128p ps=1.5u w=1.12u l=0.13u
X3158 sg13cmos5l_dfrbpq_1_27.Q a_22506_14020# VSS.t163 VSS.t1389 sg13_lv_nmos ad=0.2516p pd=2.16u as=0.1406p ps=1.12u w=0.74u l=0.13u
X3159 VDD.t1029 a_18575_8797# a_19242_8436# VDD.t8 sg13_lv_pmos ad=0.2128p pd=1.5u as=0.3864p ps=2.93u w=1.12u l=0.13u
X3160 VDD.t960 sg13cmos5l_nand4_1_5.D sg13cmos5l_a21oi_1_19.A2 VDD.t16 sg13_lv_pmos ad=0.3808p pd=2.92u as=0.2128p ps=1.5u w=1.12u l=0.13u
X3161 a_13210_12936# sg13cmos5l_nand2_1_18.A VSS.t150 VSS.t149 sg13_lv_nmos ad=0.1428p pd=1.52u as=79.8f ps=0.8u w=0.42u l=0.13u
X3162 a_20580_8440# a_20554_8404# VDD.t366 VDD.t8 sg13_lv_pmos ad=0.34p pd=2.68u as=0.36237p ps=2.605u w=1u l=0.13u
X3163 VSS.t1618 VDD.t2559 VSS.t1617 VSS.t1616 sg13_lv_nmos ad=0.1428p pd=1.52u as=0 ps=0 w=0.42u l=1u
X3164 VSS.t2128 VDD.t2390 VSS.t2130 VSS.t2129 sg13_lv_nmos ad=79.8f pd=0.8u as=0 ps=0 w=0.42u l=1u
X3165 VDD.t280 VSS.t1692 VDD.t283 VDD.t83 sg13_lv_pmos ad=0.34p pd=2.68u as=0 ps=0 w=1u l=1u
X3166 VDD.t92 VSS.t2010 VDD.t91 VDD.t5 sg13_lv_pmos ad=0.34p pd=2.68u as=0 ps=0 w=1u l=1u
X3167 VDD.t1675 sg13cmos5l_nand2_1_11.B a_8812_17044# VDD.t310 sg13_lv_pmos ad=0.4032p pd=2.96u as=0.1176p ps=1.33u w=1.12u l=0.13u
X3168 a_15081_6553# a_14724_6480# VDD.t1992 VDD.t2 sg13_lv_pmos ad=63f pd=0.72u as=0.1563p ps=1.22u w=0.42u l=0.13u
X3169 a_19120_11702# sg13cmos5l_buf_1_13.X VDD.t0 VDD.t0 sg13_lv_pmos ad=79.8f pd=0.8u as=2.07625p ps=13.51u w=0.42u l=0.13u
X3170 a_11394_4658# sg13cmos5l_a21oi_1_9.A2 a_11292_4658# VSS.t2337 sg13_lv_nmos ad=0.1406p pd=1.12u as=0.1406p ps=1.12u w=0.74u l=0.13u
X3171 VDD.t1427 a_19718_12214# a_19830_12278# VDD.t83 sg13_lv_pmos ad=0.2254p pd=1.53u as=0.34p ps=2.68u w=1u l=0.5u
X3172 a_17098_6130# sg13cmos5l_buf_8_2.A.t1 VSS.t39 VSS.t285 sg13_lv_nmos ad=0.1406p pd=1.12u as=0.1406p ps=1.12u w=0.74u l=0.13u
X3173 a_19646_14850# sg13cmos5l_nor3_1_6.Y a_19544_14850# VSS.t432 sg13_lv_nmos ad=0.1406p pd=1.12u as=0.1406p ps=1.12u w=0.74u l=0.13u
X3174 a_17604_8861# a_17835_8447# a_17290_8404# VSS.t487 sg13_lv_nmos ad=0.2373p pd=1.97u as=79.8f ps=0.8u w=0.42u l=0.13u
X3175 a_5289_19067# a_4932_19024# VDD.t1501 VDD.t231 sg13_lv_pmos ad=63f pd=0.72u as=0.1563p ps=1.22u w=0.42u l=0.13u
X3176 sg13cmos5l_o21ai_1_17.Y sg13cmos5l_or4_1_1.X a_10872_17488# VDD.t310 sg13_lv_pmos ad=0.2128p pd=1.5u as=0.2128p ps=1.5u w=1.12u l=0.15u
X3177 a_16088_13730# sg13cmos5l_nand4_1_1.C a_15986_13730# VSS.t128 sg13_lv_nmos ad=0.1406p pd=1.12u as=0.1406p ps=1.12u w=0.74u l=0.13u
X3178 a_20868_12223# a_20580_12528# a_20806_12223# VSS.t359 sg13_lv_nmos ad=0.1428p pd=1.52u as=37.8f ps=0.6u w=0.42u l=0.13u
X3179 VDD.t117 VSS.t2005 VDD.t116 VDD.t13 sg13_lv_pmos ad=0.34p pd=2.68u as=0 ps=0 w=1u l=1u
X3180 a_13015_13686# a_13575_13940# a_13486_14037# VDD.t19 sg13_lv_pmos ad=0.2048p pd=1.63u as=93.45f ps=0.865u w=0.42u l=0.13u
X3181 a_21358_5679# a_21473_5678# VDD.t936 VDD.t5 sg13_lv_pmos ad=0.34p pd=2.68u as=0.2254p ps=1.53u w=1u l=0.5u
X3182 VSS.t369 sg13cmos5l_o21ai_1_21.B1 a_4360_19808# VSS.t465 sg13_lv_nmos ad=0.14875p pd=1.16u as=0.187p ps=1.78u w=0.55u l=0.13u
X3183 VSS.t373 a_15322_16714# a_15041_16936# VSS.t1525 sg13_lv_nmos ad=79.8f pd=0.8u as=0.1428p ps=1.52u w=0.42u l=0.5u
X3184 VDD.t435 VSS.t571 VDD.t433 VDD.t8 sg13_lv_pmos ad=0.19p pd=1.38u as=0 ps=0 w=1u l=1u
X3185 VDD.t145 VSS.t1707 VDD.t144 VDD.t83 sg13_lv_pmos ad=0.34p pd=2.68u as=0 ps=0 w=1u l=1u
X3186 a_12172_10996# sg13cmos5l_a22oi_1_0.B2 sg13cmos5l_nor2_1_3.Y VDD.t0 sg13_lv_pmos ad=0.1176p pd=1.33u as=0.3808p ps=2.92u w=1.12u l=0.13u
X3187 sg13cmos5l_nand3_1_6.C sg13cmos5l_o21ai_1_5.A2 VSS.t52 VSS.t1020 sg13_lv_nmos ad=0.1406p pd=1.12u as=0.2516p ps=2.16u w=0.74u l=0.13u
X3188 sg13cmos5l_inv_1_2.A a_19995_9190# VDD.t830 VDD.t52 sg13_lv_pmos ad=0.2128p pd=1.5u as=0.2128p ps=1.5u w=1.12u l=0.13u
X3189 VDD.t1831 VSS.t1884 VDD.t1830 VDD.t8 sg13_lv_pmos ad=0.34p pd=2.68u as=0 ps=0 w=1u l=1u
X3190 VDD.t365 sg13cmos5l_buf_1_7.X a_20554_8404# VDD.t8 sg13_lv_pmos ad=0.1563p pd=1.22u as=0.147p ps=1.54u w=0.42u l=0.13u
X3191 sg13cmos5l_inv_1_1.Y sg13cmos5l_inv_1_1.A VSS.t237 VSS.t10 sg13_lv_nmos ad=0.2516p pd=2.16u as=0.2516p ps=2.16u w=0.74u l=0.13u
X3192 a_14423_14113# sg13cmos5l_nand2_1_15.Y a_15170_13722# VSS.t128 sg13_lv_nmos ad=0.1428p pd=1.52u as=60.89999f ps=0.71u w=0.42u l=0.13u
X3193 a_17961_11507# a_17604_11464# VDD.t1040 VDD.t0 sg13_lv_pmos ad=63f pd=0.72u as=0.1563p ps=1.22u w=0.42u l=0.13u
X3194 a_8218_19738# sg13cmos5l_o21ai_1_19.Y VDD.t2220 VDD.t270 sg13_lv_pmos ad=0.1428p pd=1.52u as=0.1523p ps=1.38u w=0.42u l=0.13u
X3195 a_20398_4167# a_20513_4166# VSS.t22 VSS.t304 sg13_lv_nmos ad=0.1428p pd=1.52u as=0.1426p ps=1.16u w=0.42u l=0.5u
X3196 VSS.t13 a_17098_6130# sg13cmos5l_inv_1_5.A VSS.t285 sg13_lv_nmos ad=0.1406p pd=1.12u as=0.1406p ps=1.12u w=0.74u l=0.13u
X3197 a_22522_7642# sg13cmos5l_dlygate4sd3_1_16.A VDD.t1170 VDD.t8 sg13_lv_pmos ad=0.1428p pd=1.52u as=0.1523p ps=1.38u w=0.42u l=0.13u
X3198 a_17523_12236# sg13cmos5l_a21oi_1_16.A2 VSS.t232 VSS.t1193 sg13_lv_nmos ad=0.1406p pd=1.12u as=0.2516p ps=2.16u w=0.74u l=0.13u
X3199 VDD.t722 sg13cmos5l_buf_1_10.A sg13cmos5l_inv_1_20.Y VDD.t0 sg13_lv_pmos ad=0.3808p pd=2.92u as=0.3808p ps=2.92u w=1.12u l=0.13u
X3200 VSS.t1056 a_22030_19287# sg13cmos5l_inv_1_15.A VSS.t1098 sg13_lv_nmos ad=0.1426p pd=1.16u as=0.2516p ps=2.16u w=0.74u l=0.13u
X3201 a_14121_17555# a_13764_17512# VDD.t1309 VDD.t310 sg13_lv_pmos ad=63f pd=0.72u as=0.1563p ps=1.22u w=0.42u l=0.13u
X3202 VDD.t2062 sg13cmos5l_inv_1_31.A sg13cmos5l_inv_1_31.Y VDD.t16 sg13_lv_pmos ad=0.3808p pd=2.92u as=0.3808p ps=2.92u w=1.12u l=0.13u
X3203 a_15760_19990# sg13cmos5l_buf_1_45.X.t14 VDD.t270 VDD.t270 sg13_lv_pmos ad=79.8f pd=0.8u as=2.51485p ps=16.46u w=0.42u l=0.13u
X3204 a_7482_12508# a_7416_12404# VDD.t1090 VDD.t83 sg13_lv_pmos ad=0.2975p pd=1.595u as=0.2198p ps=1.52u w=1u l=0.13u
X3205 VDD.t270 a_18095_19847# a_18352_19990# VDD.t270 sg13_lv_pmos ad=2.69447p pd=17.64u as=79.8f ps=0.8u w=0.42u l=0.13u
X3206 VSS.t1752 VDD.t2517 VSS.t1751 VSS.t1750 sg13_lv_nmos ad=0.1428p pd=1.52u as=0 ps=0 w=0.42u l=1u
X3207 sg13cmos5l_inv_1_36.Y sg13cmos5l_inv_1_36.A VSS.t153 VSS.t632 sg13_lv_nmos ad=0.2516p pd=2.16u as=0.2516p ps=2.16u w=0.74u l=0.13u
X3208 VSS.t291 VDD.t2426 VSS.t291 VSS.t1995 sg13_lv_nmos ad=0.1428p pd=1.52u as=0 ps=0 w=0.42u l=1u
X3209 a_4838_9186# sg13cmos5l_dlygate4sd3_1_42.X VDD.t2103 VDD.t52 sg13_lv_pmos ad=79.8f pd=0.8u as=0.1428p ps=1.52u w=0.42u l=0.13u
X3210 VDD.t1749 sg13cmos5l_buf_8_2.A.t2 a_19995_9190# VDD.t52 sg13_lv_pmos ad=0.2128p pd=1.5u as=0.3808p ps=2.92u w=1.12u l=0.13u
X3211 a_20554_6892# a_20997_6935# a_20937_6971# VDD.t2 sg13_lv_pmos ad=79.8f pd=0.8u as=63f ps=0.72u w=0.42u l=0.13u
X3212 VDD.t1341 sg13cmos5l_buf_1_57.A sg13cmos5l_inv_1_25.Y VDD.t16 sg13_lv_pmos ad=0.3808p pd=2.92u as=0.3808p ps=2.92u w=1.12u l=0.13u
X3213 VDD.t2 a_18671_7285# a_18928_7166# VDD.t2 sg13_lv_pmos ad=2.1916p pd=14.26u as=79.8f ps=0.8u w=0.42u l=0.13u
X3214 a_17412_6928# a_17386_6892# VSS.t31 VSS.t334 sg13_lv_nmos ad=0.2516p pd=2.16u as=0.1626p ps=1.415u w=0.74u l=0.13u
X3215 a_20503_16710# a_21063_16964# a_21084_16710# VSS.t646 sg13_lv_nmos ad=0.12665p pd=1.145u as=0.3473p ps=2.71u w=0.74u l=0.13u
X3216 VDD.t1344 sg13cmos5l_nand2b_1_0.B a_15597_12256# VDD.t83 sg13_lv_pmos ad=0.1918p pd=1.5u as=0.1596p ps=1.22u w=0.84u l=0.13u
X3217 VDD.t1340 VSS.t2170 VDD.t198 VDD.t13 sg13_lv_pmos ad=0.19p pd=1.38u as=0 ps=0 w=1u l=1u
X3218 a_20806_7349# sg13cmos5l_buf_1_7.X VSS.t26 VSS.t35 sg13_lv_nmos ad=37.8f pd=0.6u as=0.1701p ps=1.65u w=0.42u l=0.13u
X3219 VSS.t101 sg13cmos5l_nand2b_1_1.A_N a_12082_7302# VSS.t2223 sg13_lv_nmos ad=0.1406p pd=1.12u as=0.1406p ps=1.12u w=0.74u l=0.15u
X3220 VDD.t260 VSS.t542 VDD.t259 VDD.t2 sg13_lv_pmos ad=0.19p pd=1.38u as=0 ps=0 w=1u l=1u
X3221 sg13cmos5l_dfrbpq_1_19.CLK a_7498_18226# VDD.t2032 VDD.t231 sg13_lv_pmos ad=0.2128p pd=1.5u as=0.3864p ps=2.93u w=1.12u l=0.13u
X3222 VDD.t1244 a_17038_14751# sg13cmos5l_dlygate4sd3_1_81.X VDD.t19 sg13_lv_pmos ad=0.2254p pd=1.53u as=0.4256p ps=3u w=1.12u l=0.13u
X3223 VDD.t903 sg13cmos5l_dfrbpq_1_47.D a_14039_5459# VDD.t5 sg13_lv_pmos ad=0.1428p pd=1.52u as=79.8f ps=0.8u w=0.42u l=0.13u
X3224 VDD.t665 a_13210_19738# a_12929_19960# VDD.t270 sg13_lv_pmos ad=0.1523p pd=1.38u as=0.34p ps=2.68u w=1u l=0.5u
X3225 sg13cmos5l_dfrbpq_1_13.RESET_B a_5032_9948# VSS.t1058 VSS.t2261 sg13_lv_nmos ad=0.2886p pd=2.26u as=0.14875p ps=1.16u w=0.74u l=0.13u
X3226 a_6487_6126# a_7047_6380# a_7068_6126# VSS.t846 sg13_lv_nmos ad=0.12665p pd=1.145u as=0.3473p ps=2.71u w=0.74u l=0.13u
X3227 a_9322_19993# a_9765_19749# a_9705_20161# VDD.t270 sg13_lv_pmos ad=79.8f pd=0.8u as=63f ps=0.72u w=0.42u l=0.13u
X3228 a_4202_18258# a_3895_18222# a_4108_18258# VSS.t1265 sg13_lv_nmos ad=37.8f pd=0.6u as=0.1428p ps=1.52u w=0.42u l=0.13u
X3229 VSS.t52 sg13cmos5l_nand4_1_7.B sg13cmos5l_nor2_1_15.Y VSS.t415 sg13_lv_nmos ad=0.2516p pd=2.16u as=0.1406p ps=1.12u w=0.74u l=0.13u
X3230 VSS.t74 a_8015_11821# a_8682_11460# VSS.t802 sg13_lv_nmos ad=0.1406p pd=1.12u as=0.2516p ps=2.16u w=0.74u l=0.13u
X3231 sg13cmos5l_a22oi_1_0.B2 a_12426_9948# VDD.t1202 VDD.t52 sg13_lv_pmos ad=0.3808p pd=2.92u as=0.2128p ps=1.5u w=1.12u l=0.13u
X3232 VSS.t2188 VDD.t2378 VSS.t2190 VSS.t2189 sg13_lv_nmos ad=79.8f pd=0.8u as=0 ps=0 w=0.42u l=1u
X3233 a_5412_7992# a_5386_7897# VSS.t542 VSS.t541 sg13_lv_nmos ad=0.2516p pd=2.16u as=0.1626p ps=1.415u w=0.74u l=0.13u
X3234 a_6418_15230# sg13cmos5l_o21ai_1_5.A1 VSS.t585 VSS.t985 sg13_lv_nmos ad=0.2516p pd=2.16u as=0.1406p ps=1.12u w=0.74u l=0.15u
X3235 a_17253_19749# sg13cmos5l_inv_1_31.A VSS.t2302 VSS.t2301 sg13_lv_nmos ad=0.2516p pd=2.16u as=3.5562p ps=22.685u w=0.74u l=0.13u
X3236 VSS.t67 sg13cmos5l_inv_1_36.A a_9176_13726# VSS.t66 sg13_lv_nmos ad=79.8f pd=0.8u as=0.1428p ps=1.52u w=0.42u l=0.13u
X3237 sg13cmos5l_nand2_1_1.Y sg13cmos5l_nand2_1_1.A a_16954_10702# VSS.t990 sg13_lv_nmos ad=0.2516p pd=2.16u as=0.1406p ps=1.12u w=0.74u l=0.13u
X3238 VDD.t1402 VSS.t1908 VDD.t1401 VDD.t5 sg13_lv_pmos ad=0.19p pd=1.38u as=0 ps=0 w=1u l=1u
X3239 VSS.t307 a_15503_19847# a_16170_20068# VSS.t166 sg13_lv_nmos ad=0.1406p pd=1.12u as=0.2516p ps=2.16u w=0.74u l=0.13u
X3240 a_15299_10996# sg13cmos5l_a22oi_1_0.B2 a_15197_10996# VDD.t0 sg13_lv_pmos ad=0.2464p pd=1.56u as=0.2128p ps=1.5u w=1.12u l=0.13u
X3241 VSS.t67 sg13cmos5l_dfrbpq_1_24.Q a_8635_13362# VSS.t149 sg13_lv_nmos ad=0.1447p pd=1.15u as=0.1408p ps=1.08u w=0.64u l=0.13u
X3242 sg13cmos5l_dlygate4sd3_1_3.A a_22506_6924# VSS.t37 VSS.t36 sg13_lv_nmos ad=0.2516p pd=2.16u as=0.1406p ps=1.12u w=0.74u l=0.13u
X3243 VDD.t1923 sg13cmos5l_buf_1_24.A sg13cmos5l_a21oi_1_24.A1 VDD.t231 sg13_lv_pmos ad=0.3808p pd=2.92u as=0.3808p ps=2.92u w=1.12u l=0.13u
X3244 a_10954_18481# a_11397_18237# a_10694_18258# VSS.t1137 sg13_lv_nmos ad=79.8f pd=0.8u as=0.1296p ps=1.52u w=0.42u l=0.13u
X3245 VDD.t931 sg13cmos5l_mux2_1_0.S a_10833_14874# VDD.t19 sg13_lv_pmos ad=0.1596p pd=1.22u as=0.1596p ps=1.22u w=0.84u l=0.13u
X3246 VSS.t1542 a_20997_14495# a_21099_14495# VSS.t1541 sg13_lv_nmos ad=6.40482p pd=41.475u as=0.2516p ps=2.16u w=0.74u l=0.13u
X3247 a_5998_13911# a_6113_13912# VDD.t953 VDD.t19 sg13_lv_pmos ad=0.34p pd=2.68u as=0.2254p ps=1.53u w=1u l=0.5u
X3248 a_7895_6553# sg13cmos5l_dfrbpq_1_13.RESET_B VDD.t1564 VDD.t2 sg13_lv_pmos ad=79.8f pd=0.8u as=0.36237p ps=2.605u w=0.42u l=0.13u
X3249 VSS.t1860 VDD.t2474 VSS.t1862 VSS.t1861 sg13_lv_nmos ad=79.8f pd=0.8u as=0 ps=0 w=0.42u l=1u
X3250 a_18777_8559# a_17835_8447# a_18575_8797# VDD.t8 sg13_lv_pmos ad=93.45f pd=0.865u as=0.2048p ps=1.63u w=0.42u l=0.13u
X3251 sg13cmos5l_o21ai_1_21.Y sg13cmos5l_o21ai_1_21.B1 VDD.t928 VDD.t310 sg13_lv_pmos ad=0.2128p pd=1.5u as=0.3808p ps=2.92u w=1.12u l=0.15u
X3252 a_13738_15964# a_14181_16007# a_13478_16434# VSS.t1499 sg13_lv_nmos ad=79.8f pd=0.8u as=0.1296p ps=1.52u w=0.42u l=0.13u
X3253 VSS.t393 a_18574_14751# sg13cmos5l_inv_1_16.A VSS.t432 sg13_lv_nmos ad=0.1426p pd=1.16u as=0.2516p ps=2.16u w=0.74u l=0.13u
X3254 a_22107_18649# a_21215_18528# a_22005_18416# VDD.t231 sg13_lv_pmos ad=63f pd=0.72u as=79.8f ps=0.8u w=0.42u l=0.13u
X3255 VDD.t747 sg13cmos5l_a21oi_1_15.A2 a_16949_12508# VDD.t83 sg13_lv_pmos ad=0.2128p pd=1.5u as=0.3808p ps=2.92u w=1.12u l=0.13u
X3256 a_20272_19262# sg13cmos5l_dfrbpq_1_28.RESET_B.t13 VDD.t231 VDD.t231 sg13_lv_pmos ad=79.8f pd=0.8u as=1.4953p ps=9.545u w=0.42u l=0.13u
X3257 a_10162_16742# sg13cmos5l_or4_1_1.X VSS.t48 VSS.t1327 sg13_lv_nmos ad=0.2516p pd=2.16u as=0.1406p ps=1.12u w=0.74u l=0.15u
X3258 VDD.t920 a_17510_10702# a_17622_10766# VDD.t0 sg13_lv_pmos ad=0.2254p pd=1.53u as=0.34p ps=2.68u w=1u l=0.5u
X3259 VSS.t1805 VDD.t2490 VSS.t1805 VSS.t1823 sg13_lv_nmos ad=79.8f pd=0.8u as=0 ps=0 w=0.42u l=1u
X3260 a_7895_6553# a_7199_6432# a_7989_6320# VSS.t2396 sg13_lv_nmos ad=0.1296p pd=1.52u as=79.8f ps=0.8u w=0.42u l=0.13u
X3261 VDD.t1390 sg13cmos5l_nand2_1_0.B sg13cmos5l_nand2b_1_0.B VDD.t8 sg13_lv_pmos ad=0.3808p pd=2.92u as=0.2128p ps=1.5u w=1.12u l=0.13u
X3262 VDD.t712 sg13cmos5l_a21oi_1_26.A1 a_16283_17508# VDD.t310 sg13_lv_pmos ad=0.2128p pd=1.5u as=0.2128p ps=1.5u w=1.12u l=0.13u
X3263 VDD.t1275 a_21839_12287# a_22506_12508# VDD.t83 sg13_lv_pmos ad=0.2128p pd=1.5u as=0.3864p ps=2.93u w=1.12u l=0.13u
X3264 a_7886_9232# sg13cmos5l_nor3_1_2.A a_7507_9380# VSS.t2441 sg13_lv_nmos ad=81.6f pd=0.895u as=0.1216p ps=1.02u w=0.64u l=0.13u
X3265 a_8015_11821# a_7173_11471# a_7921_11821# VSS.t3 sg13_lv_nmos ad=0.12665p pd=1.145u as=0.1428p ps=1.52u w=0.42u l=0.13u
X3266 VSS.t242 sg13cmos5l_inv_1_31.A a_21215_18528# VSS.t1372 sg13_lv_nmos ad=3.77667p pd=24.67u as=0.2516p ps=2.16u w=0.74u l=0.13u
X3267 VSS.t81 sg13cmos5l_buf_1_13.A a_17366_9199# VSS.t2360 sg13_lv_nmos ad=0.1701p pd=1.65u as=37.8f ps=0.6u w=0.42u l=0.13u
X3268 VSS.t1921 VDD.t2446 VSS.t1920 VSS.t1919 sg13_lv_nmos ad=0.1428p pd=1.52u as=0 ps=0 w=0.42u l=1u
X3269 a_9077_6460# sg13cmos5l_a21oi_1_10.A1 VDD.t1012 VDD.t2 sg13_lv_pmos ad=0.2128p pd=1.5u as=0.2128p ps=1.5u w=1.12u l=0.13u
X3270 a_11756_19734# sg13cmos5l_o21ai_1_13.B1 VDD.t2180 VDD.t270 sg13_lv_pmos ad=0.2856p pd=2.36u as=0.2114p ps=1.54u w=0.84u l=0.13u
X3271 a_17429_12508# sg13cmos5l_inv_1_9.Y VDD.t1549 VDD.t83 sg13_lv_pmos ad=0.2128p pd=1.5u as=0.2128p ps=1.5u w=1.12u l=0.13u
X3272 a_15480_8752# sg13cmos5l_nor2b_1_2.Y VSS.t97 VSS.t329 sg13_lv_nmos ad=0.1045p pd=0.93u as=0.1469p ps=1.155u w=0.55u l=0.13u
X3273 VSS.t46 sg13cmos5l_nor4_1_1.D a_9300_15280# VSS.t1471 sg13_lv_nmos ad=0.2272p pd=1.99u as=78.39999f ps=0.885u w=0.64u l=0.13u
X3274 a_22041_10071# a_21099_9959# a_21839_10309# VDD.t52 sg13_lv_pmos ad=93.45f pd=0.865u as=0.2048p ps=1.63u w=0.42u l=0.13u
X3275 sg13cmos5l_a21oi_1_10.Y sg13cmos5l_a21oi_1_10.A1 a_9171_6188# VSS.t566 sg13_lv_nmos ad=0.1406p pd=1.12u as=0.1406p ps=1.12u w=0.74u l=0.13u
X3276 a_4114_17886# sg13cmos5l_o21ai_1_20.A1 VSS.t1112 VSS.t1149 sg13_lv_nmos ad=0.2516p pd=2.16u as=0.1406p ps=1.12u w=0.74u l=0.15u
X3277 VSS.t176 sg13cmos5l_dfrbpq_1_24.RESET_B a_5174_16759# VSS.t1122 sg13_lv_nmos ad=0.1701p pd=1.65u as=37.8f ps=0.6u w=0.42u l=0.13u
X3278 a_13400_10706# sg13cmos5l_buf_1_21.A a_13298_10706# VSS.t1479 sg13_lv_nmos ad=0.1406p pd=1.12u as=0.1406p ps=1.12u w=0.74u l=0.13u
X3279 VDD.t1069 a_21370_6130# a_21089_6352# VDD.t2 sg13_lv_pmos ad=0.1523p pd=1.38u as=0.34p ps=2.68u w=1u l=0.5u
X3280 VDD.t415 VSS.t2115 VDD.t414 VDD.t13 sg13_lv_pmos ad=0.19p pd=1.38u as=0 ps=0 w=1u l=1u
X3281 a_18206_14850# sg13cmos5l_nand4_1_3.B a_18104_14850# VSS.t432 sg13_lv_nmos ad=0.1406p pd=1.12u as=0.1406p ps=1.12u w=0.74u l=0.13u
X3282 a_12045_11808# sg13cmos5l_and2_1_6.A VDD.t1838 VDD.t0 sg13_lv_pmos ad=0.1596p pd=1.22u as=0.2856p ps=2.36u w=0.84u l=0.13u
X3283 VDD.t1361 sg13cmos5l_nand2_1_1.A sg13cmos5l_nand2_1_1.Y VDD.t0 sg13_lv_pmos ad=0.3808p pd=2.92u as=0.2128p ps=1.5u w=1.12u l=0.13u
X3284 a_20338_7674# sg13cmos5l_buf_1_7.X VSS.t26 VSS.t25 sg13_lv_nmos ad=37.8f pd=0.6u as=79.8f ps=0.8u w=0.42u l=0.13u
X3285 a_10906_18984# sg13cmos5l_dlygate4sd3_1_54.A VDD.t1312 VDD.t231 sg13_lv_pmos ad=0.1428p pd=1.52u as=0.1523p ps=1.38u w=0.42u l=0.13u
X3286 sg13cmos5l_dlygate4sd3_1_51.X a_4182_19044# VSS.t369 VSS.t1118 sg13_lv_nmos ad=0.2516p pd=2.16u as=0.1426p ps=1.16u w=0.74u l=0.13u
X3287 a_18194_13338# sg13cmos5l_nand4_1_18.D VSS.t164 VSS.t128 sg13_lv_nmos ad=0.1406p pd=1.12u as=0.2516p ps=2.16u w=0.74u l=0.13u
X3288 a_8734_12214# sg13cmos5l_mux2_1_1.A0 a_8637_12508# VDD.t83 sg13_lv_pmos ad=0.2225p pd=1.445u as=0.3325p ps=1.665u w=1u l=0.13u
X3289 a_15012_6175# a_14724_6480# a_14950_6175# VSS.t205 sg13_lv_nmos ad=0.1428p pd=1.52u as=37.8f ps=0.6u w=0.42u l=0.13u
X3290 sg13cmos5l_inv_1_29.Y sg13cmos5l_dfrbpq_1_19.CLK VDD.t2223 VDD.t231 sg13_lv_pmos ad=0.3808p pd=2.92u as=0.3808p ps=2.92u w=1.12u l=0.13u
X3291 a_7594_9916# a_8037_9959# a_7977_9995# VDD.t52 sg13_lv_pmos ad=79.8f pd=0.8u as=63f ps=0.72u w=0.42u l=0.13u
X3292 VDD.t1520 a_12239_18335# a_12906_18556# VDD.t231 sg13_lv_pmos ad=0.2128p pd=1.5u as=0.3864p ps=2.93u w=1.12u l=0.13u
X3293 a_9350_12210# a_10155_12332# a_9610_12433# VDD.t83 sg13_lv_pmos ad=0.1428p pd=1.52u as=79.8f ps=0.8u w=0.42u l=0.13u
X3294 VSS.t31 sg13cmos5l_a21oi_1_2.B1 sg13cmos5l_a21oi_1_3.Y VSS.t899 sg13_lv_nmos ad=0.2516p pd=2.16u as=0.1406p ps=1.12u w=0.74u l=0.13u
X3295 a_17316_8440# a_17290_8404# VSS.t81 VSS.t2493 sg13_lv_nmos ad=0.2516p pd=2.16u as=0.1626p ps=1.415u w=0.74u l=0.13u
X3296 VSS.t161 a_19342_10215# sg13cmos5l_buf_1_5.A VSS.t2604 sg13_lv_nmos ad=0.1426p pd=1.16u as=0.2516p ps=2.16u w=0.74u l=0.13u
X3297 a_18756_19024# a_18730_18988# VSS.t931 VSS.t1391 sg13_lv_nmos ad=0.2516p pd=2.16u as=0.1626p ps=1.415u w=0.74u l=0.13u
X3298 a_20868_11885# a_20580_11464# a_20806_11885# VSS.t359 sg13_lv_nmos ad=0.1428p pd=1.52u as=37.8f ps=0.6u w=0.42u l=0.13u
X3299 VSS.t13 a_17098_6130# sg13cmos5l_inv_1_5.A VSS.t528 sg13_lv_nmos ad=0.1406p pd=1.12u as=0.1406p ps=1.12u w=0.74u l=0.13u
X3300 a_18670_16263# a_18785_16262# VDD.t682 VDD.t16 sg13_lv_pmos ad=0.34p pd=2.68u as=0.2254p ps=1.53u w=1u l=0.5u
X3301 VDD.t83 a_11152_12430# a_11097_12525# VDD.t83 sg13_lv_pmos ad=2.51485p pd=16.46u as=93.45f ps=0.865u w=0.42u l=0.13u
X3302 VDD.t513 VSS.t2155 VDD.t512 VDD.t13 sg13_lv_pmos ad=0.19p pd=1.38u as=0 ps=0 w=1u l=1u
X3303 VDD.t571 VSS.t1872 VDD.t12 VDD.t2 sg13_lv_pmos ad=0.19p pd=1.38u as=0 ps=0 w=1u l=1u
X3304 a_9466_18226# sg13cmos5l_o21ai_1_15.Y VSS.t56 VSS.t115 sg13_lv_nmos ad=0.1428p pd=1.52u as=79.8f ps=0.8u w=0.42u l=0.13u
X3305 a_17243_17508# sg13cmos5l_a21oi_1_24.A2 VDD.t1610 VDD.t310 sg13_lv_pmos ad=0.3808p pd=2.92u as=0.2128p ps=1.5u w=1.12u l=0.13u
X3306 sg13cmos5l_dfrbpq_1_24.Q a_7530_12972# VDD.t1705 VDD.t83 sg13_lv_pmos ad=0.3808p pd=2.92u as=0.2128p ps=1.5u w=1.12u l=0.13u
X3307 VSS.t547 a_21839_10309# a_22506_9948# VSS.t546 sg13_lv_nmos ad=0.1406p pd=1.12u as=0.2516p ps=2.16u w=0.74u l=0.13u
X3308 a_15790_7191# a_15905_7190# VSS.t99 VSS.t2572 sg13_lv_nmos ad=0.1428p pd=1.52u as=0.1426p ps=1.16u w=0.42u l=0.5u
X3309 a_12394_18988# a_12837_19031# a_12777_19067# VDD.t231 sg13_lv_pmos ad=79.8f pd=0.8u as=63f ps=0.72u w=0.42u l=0.13u
X3310 VSS.t204 sg13cmos5l_buf_1_45.X.t5 a_13572_16434# VSS.t417 sg13_lv_nmos ad=0.1626p pd=1.415u as=60.89999f ps=0.71u w=0.42u l=0.13u
X3311 VSS.t273 sg13cmos5l_inv_1_0.A a_19048_3900# VSS.t561 sg13_lv_nmos ad=0.14875p pd=1.16u as=0.187p ps=1.78u w=0.55u l=0.13u
X3312 sg13cmos5l_dlygate4sd3_1_80.X a_13782_15302# VDD.t1071 VDD.t16 sg13_lv_pmos ad=0.4256p pd=3u as=0.2254p ps=1.53u w=1.12u l=0.13u
X3313 a_8410_14854# sg13cmos5l_dlygate4sd3_1_45.X sg13cmos5l_o21ai_1_9.B1 VSS.t125 sg13_lv_nmos ad=0.1406p pd=1.12u as=0.2516p ps=2.16u w=0.74u l=0.13u
X3314 sg13cmos5l_nand4_1_3.D a_15358_14850# a_15684_14850# VSS.t1421 sg13_lv_nmos ad=0.3404p pd=2.4u as=0.1406p ps=1.12u w=0.74u l=0.13u
X3315 VDD.t1446 sg13cmos5l_a21oi_1_4.A2 sg13cmos5l_nand3_1_8.Y VDD.t83 sg13_lv_pmos ad=0.2128p pd=1.5u as=0.3808p ps=2.92u w=1.12u l=0.13u
X3316 VDD.t0 a_19077_10677# a_19179_10820# VDD.t0 sg13_lv_pmos ad=2.1916p pd=14.26u as=0.3864p ps=2.93u w=1.12u l=0.13u
X3317 a_16356_5416# a_16330_5380# VSS.t13 VSS.t355 sg13_lv_nmos ad=0.2516p pd=2.16u as=0.1626p ps=1.415u w=0.74u l=0.13u
X3318 VDD.t527 VSS.t1756 VDD.t526 VDD.t0 sg13_lv_pmos ad=0.34p pd=2.68u as=0 ps=0 w=1u l=1u
X3319 VDD.t2262 a_15692_18984# code2 VDD.t231 sg13_lv_pmos ad=0.2114p pd=1.54u as=0.42p ps=2.99u w=1.12u l=0.13u
X3320 a_4366_18258# a_4607_18528# a_3895_18222# VSS.t1113 sg13_lv_nmos ad=0.1428p pd=1.52u as=0.12665p ps=1.145u w=0.42u l=0.13u
X3321 VDD.t2035 a_7498_18226# sg13cmos5l_dfrbpq_1_19.CLK VDD.t231 sg13_lv_pmos ad=0.2128p pd=1.5u as=0.2128p ps=1.5u w=1.12u l=0.13u
X3322 VDD.t226 VSS.t1498 VDD.t225 VDD.t16 sg13_lv_pmos ad=0.19p pd=1.38u as=0 ps=0 w=1u l=1u
X3323 a_13210_19738# sg13cmos5l_o21ai_1_25.Y VSS.t107 VSS.t106 sg13_lv_nmos ad=0.1428p pd=1.52u as=79.8f ps=0.8u w=0.42u l=0.13u
X3324 VDD.t574 VSS.t1108 VDD.t500 VDD.t310 sg13_lv_pmos ad=0.19p pd=1.38u as=0 ps=0 w=1u l=1u
X3325 VDD.t350 VSS.t1651 VDD.t334 VDD.t310 sg13_lv_pmos ad=0.19p pd=1.38u as=0 ps=0 w=1u l=1u
X3326 VSS.t99 a_15104_7849# sg13cmos5l_dlygate4sd3_1_9.A VSS.t98 sg13_lv_nmos ad=0.1406p pd=1.12u as=0.2516p ps=2.16u w=0.74u l=0.13u
X3327 a_5829_8436# sg13cmos5l_nor3_1_2.A VDD.t2191 VDD.t8 sg13_lv_pmos ad=0.2464p pd=1.56u as=0.3808p ps=2.92u w=1.12u l=0.13u
X3328 VSS.t468 sg13cmos5l_o21ai_1_20.Y a_3800_19061# VSS.t1271 sg13_lv_nmos ad=79.8f pd=0.8u as=0.1428p ps=1.52u w=0.42u l=0.13u
X3329 a_12837_19031# sg13cmos5l_dfrbpq_1_41.CLK VSS.t169 VSS.t670 sg13_lv_nmos ad=0.2516p pd=2.16u as=3.5562p ps=22.685u w=0.74u l=0.13u
X3330 a_4917_16904# a_3975_16964# a_4823_17137# VDD.t310 sg13_lv_pmos ad=79.8f pd=0.8u as=0.1428p ps=1.52u w=0.42u l=0.13u
X3331 VDD.t496 VSS.t1724 VDD.t492 VDD.t0 sg13_lv_pmos ad=0.19p pd=1.38u as=0 ps=0 w=1u l=1u
X3332 VSS.t1999 VDD.t2424 VSS.t1999 VSS.t2000 sg13_lv_nmos ad=0.1428p pd=1.52u as=0 ps=0 w=0.42u l=1u
X3333 VDD.t376 sg13cmos5l_buf_1_7.X a_17126_7362# VDD.t2 sg13_lv_pmos ad=0.36237p pd=2.605u as=79.8f ps=0.8u w=0.42u l=0.13u
X3334 a_20716_16434# a_20503_15960# VDD.t16 VDD.t16 sg13_lv_pmos ad=79.8f pd=0.8u as=2.07625p ps=13.51u w=0.42u l=0.13u
X3335 sg13cmos5l_a21oi_1_7.A2 sg13cmos5l_nand4_1_1.B VDD.t1545 VDD.t83 sg13_lv_pmos ad=0.2128p pd=1.5u as=0.2128p ps=1.5u w=1.12u l=0.13u
X3336 sg13cmos5l_inv_1_36.Y sg13cmos5l_inv_1_36.A VDD.t1068 VDD.t0 sg13_lv_pmos ad=0.3808p pd=2.92u as=0.3808p ps=2.92u w=1.12u l=0.13u
X3337 VDD.t16 a_14181_16007# a_14283_16007# VDD.t16 sg13_lv_pmos ad=2.07625p pd=13.51u as=0.3864p ps=2.93u w=1.12u l=0.13u
X3338 bp0 a_15208_12972# VSS.t245 VSS.t128 sg13_lv_nmos ad=0.2886p pd=2.26u as=0.14875p ps=1.16u w=0.74u l=0.13u
X3339 VSS.t481 sg13cmos5l_buf_1_43.X a_17224_12972# VSS.t128 sg13_lv_nmos ad=0.14875p pd=1.16u as=0.187p ps=1.78u w=0.55u l=0.13u
X3340 sg13cmos5l_o21ai_1_1.Y sg13cmos5l_nor4_1_0.Y a_14328_7992# VDD.t8 sg13_lv_pmos ad=0.2128p pd=1.5u as=0.2128p ps=1.5u w=1.12u l=0.15u
X3341 VDD.t23 VSS.t1864 VDD.t32 VDD.t8 sg13_lv_pmos ad=0.34p pd=2.68u as=0 ps=0 w=1u l=1u
X3342 sg13cmos5l_a21oi_1_4.A1 a_15592_10736# VSS.t120 VSS.t1571 sg13_lv_nmos ad=0.2886p pd=2.26u as=0.14875p ps=1.16u w=0.74u l=0.13u
X3343 a_15023_16357# a_14181_16007# a_13764_16000# VDD.t16 sg13_lv_pmos ad=0.2048p pd=1.63u as=0.34p ps=2.68u w=1u l=0.13u
X3344 a_22258_12210# sg13cmos5l_dfrbpq_1_28.RESET_B.t1 VSS.t17 VSS.t16 sg13_lv_nmos ad=37.8f pd=0.6u as=79.8f ps=0.8u w=0.42u l=0.13u
X3345 VSS.t1906 VDD.t2449 VSS.t1905 VSS.t1904 sg13_lv_nmos ad=0.1428p pd=1.52u as=0 ps=0 w=0.42u l=1u
X3346 a_14601_20161# a_14244_20088# VDD.t889 VDD.t270 sg13_lv_pmos ad=63f pd=0.72u as=0.1563p ps=1.22u w=0.42u l=0.13u
X3347 sg13cmos5l_dfrbpq_1_30.D a_21462_17532# VDD.t901 VDD.t310 sg13_lv_pmos ad=0.4256p pd=3u as=0.2254p ps=1.53u w=1.12u l=0.13u
X3348 sg13cmos5l_a21oi_1_16.A2 sg13cmos5l_nand4_1_1.A a_17342_13730# VSS.t128 sg13_lv_nmos ad=0.2516p pd=2.16u as=0.1406p ps=1.12u w=0.74u l=0.13u
X3349 a_9705_5459# a_9348_5416# VDD.t1575 VDD.t5 sg13_lv_pmos ad=63f pd=0.72u as=0.1563p ps=1.22u w=0.42u l=0.13u
X3350 VSS.t99 sg13cmos5l_buf_1_0.A sg13cmos5l_inv_1_11.Y VSS.t760 sg13_lv_nmos ad=0.2516p pd=2.16u as=0.2516p ps=2.16u w=0.74u l=0.13u
X3351 VSS.t937 a_10906_18984# a_10625_19286# VSS.t1282 sg13_lv_nmos ad=79.8f pd=0.8u as=0.1428p ps=1.52u w=0.42u l=0.5u
X3352 a_15692_18984# sg13cmos5l_o21ai_1_25.B1 VDD.t2262 VDD.t231 sg13_lv_pmos ad=0.2856p pd=2.36u as=0.2114p ps=1.54u w=0.84u l=0.13u
X3353 sg13cmos5l_dfrbpq_1_28.RESET_B a_15784_15272# VSS.t201 VSS.t1249 sg13_lv_nmos ad=0.2886p pd=2.26u as=0.14875p ps=1.16u w=0.74u l=0.13u
X3354 sg13cmos5l_a21oi_1_20.A2 sg13cmos5l_a21oi_1_17.Y a_16478_15242# VSS.t127 sg13_lv_nmos ad=0.2516p pd=2.16u as=0.1406p ps=1.12u w=0.74u l=0.13u
X3355 VSS.t153 clk a_12987_12214# VSS.t716 sg13_lv_nmos ad=0.1406p pd=1.12u as=0.1406p ps=1.12u w=0.74u l=0.13u
X3356 VSS.t2193 VDD.t2377 VSS.t563 VSS.t2194 sg13_lv_nmos ad=79.8f pd=0.8u as=0 ps=0 w=0.42u l=1u
X3357 VDD.t231 sg13cmos5l_inv_1_31.A a_21215_18528# VDD.t231 sg13_lv_pmos ad=1.4953p pd=9.545u as=0.4088p ps=2.97u w=1.12u l=0.13u
X3358 VDD.t402 VSS.t2100 VDD.t356 VDD.t13 sg13_lv_pmos ad=0.19p pd=1.38u as=0 ps=0 w=1u l=1u
X3359 a_21531_13342# sg13cmos5l_buf_8_2.A.t4 VDD.t2353 VDD.t83 sg13_lv_pmos ad=0.2128p pd=1.5u as=0.2128p ps=1.5u w=1.12u l=0.13u
X3360 a_22258_7362# sg13cmos5l_buf_1_7.X VSS.t37 VSS.t36 sg13_lv_nmos ad=37.8f pd=0.6u as=79.8f ps=0.8u w=0.42u l=0.13u
X3361 VDD.t894 sg13cmos5l_buf_1_45.X.t11 a_12134_19458# VDD.t231 sg13_lv_pmos ad=0.36237p pd=2.605u as=79.8f ps=0.8u w=0.42u l=0.13u
X3362 a_15588_18258# sg13cmos5l_dfrbpq_1_33.D a_15494_18258# VSS.t1413 sg13_lv_nmos ad=60.89999f pd=0.71u as=0.1428p ps=1.52u w=0.42u l=0.13u
X3363 VDD.t657 a_18374_18262# a_18486_18326# VDD.t231 sg13_lv_pmos ad=0.2254p pd=1.53u as=0.34p ps=2.68u w=1u l=0.5u
X3364 VDD.t684 sg13cmos5l_dfrbpq_1_28.RESET_B a_16742_15234# VDD.t16 sg13_lv_pmos ad=0.36237p pd=2.605u as=79.8f ps=0.8u w=0.42u l=0.13u
X3365 a_14724_6480# a_14698_6385# VDD.t730 VDD.t2 sg13_lv_pmos ad=0.34p pd=2.68u as=0.36237p ps=2.605u w=1u l=0.13u
X3366 a_17830_11885# sg13cmos5l_buf_1_13.X VSS.t232 VSS.t594 sg13_lv_nmos ad=37.8f pd=0.6u as=0.1701p ps=1.65u w=0.42u l=0.13u
X3367 sg13cmos5l_nand4_1_18.C a_17224_12972# VSS.t481 VSS.t128 sg13_lv_nmos ad=0.2886p pd=2.26u as=0.14875p ps=1.16u w=0.74u l=0.13u
X3368 a_13478_11460# a_13208_11501# VSS.t153 VSS.t235 sg13_lv_nmos ad=0.1428p pd=1.52u as=79.8f ps=0.8u w=0.42u l=0.5u
X3369 a_19642_6130# sg13cmos5l_a21oi_1_0.Y VSS.t11 VSS.t526 sg13_lv_nmos ad=0.1428p pd=1.52u as=79.8f ps=0.8u w=0.42u l=0.13u
X3370 VSS.t284 a_13786_7642# a_13505_7864# VSS.t283 sg13_lv_nmos ad=79.8f pd=0.8u as=0.1428p ps=1.52u w=0.42u l=0.5u
X3371 a_7113_11507# a_6756_11464# VDD.t1560 VDD.t0 sg13_lv_pmos ad=63f pd=0.72u as=0.1563p ps=1.22u w=0.42u l=0.13u
X3372 VDD.t765 sg13cmos5l_dfrbpq_1_9.Q a_20024_6166# VDD.t2 sg13_lv_pmos ad=0.1523p pd=1.38u as=0.1428p ps=1.52u w=0.42u l=0.13u
X3373 a_3790_16434# a_3532_16434# VSS.t228 VSS.t227 sg13_lv_nmos ad=0.1428p pd=1.52u as=79.8f ps=0.8u w=0.42u l=0.13u
X3374 VDD.t16 sg13cmos5l_dfrbpq_1_5.CLK a_21215_15967# VDD.t16 sg13_lv_pmos ad=2.07625p pd=13.51u as=0.4088p ps=2.97u w=1.12u l=0.13u
X3375 a_14619_14113# a_13727_13992# a_14517_13880# VDD.t19 sg13_lv_pmos ad=63f pd=0.72u as=79.8f ps=0.8u w=0.42u l=0.13u
X3376 VSS.t362 sg13cmos5l_buf_8_2.A.t3 a_6442_10666# VSS.t1026 sg13_lv_nmos ad=0.1406p pd=1.12u as=0.1406p ps=1.12u w=0.74u l=0.13u
X3377 a_10162_16742# sg13cmos5l_o21ai_1_15.B1 sg13cmos5l_o21ai_1_15.Y VSS.t1289 sg13_lv_nmos ad=0.1406p pd=1.12u as=0.2516p ps=2.16u w=0.74u l=0.15u
X3378 bp6 a_19432_3900# VDD.t1167 VDD.t13 sg13_lv_pmos ad=0.42p pd=2.99u as=0.2114p ps=1.54u w=1.12u l=0.13u
X3379 VDD.t270 a_17253_19749# a_17355_19892# VDD.t270 sg13_lv_pmos ad=2.69447p pd=17.64u as=0.3864p ps=2.93u w=1.12u l=0.13u
X3380 VSS.t107 sg13cmos5l_buf_1_45.X.t11 a_12228_19458# VSS.t424 sg13_lv_nmos ad=0.1626p pd=1.415u as=60.89999f ps=0.71u w=0.42u l=0.13u
X3381 a_10607_19847# a_9765_19749# a_10513_19847# VSS.t2278 sg13_lv_nmos ad=0.12665p pd=1.145u as=0.1428p ps=1.52u w=0.42u l=0.13u
X3382 a_18470_19458# a_19275_19031# a_18730_18988# VDD.t231 sg13_lv_pmos ad=0.1428p pd=1.52u as=79.8f ps=0.8u w=0.42u l=0.13u
X3383 VSS.t69 a_6394_17472# a_6113_17774# VSS.t1251 sg13_lv_nmos ad=79.8f pd=0.8u as=0.1428p ps=1.52u w=0.42u l=0.5u
X3384 a_22096_11702# sg13cmos5l_buf_1_7.X VDD.t0 VDD.t0 sg13_lv_pmos ad=79.8f pd=0.8u as=2.1916p ps=14.26u w=0.42u l=0.13u
X3385 a_4114_17886# sg13cmos5l_o21ai_1_20.B1 sg13cmos5l_o21ai_1_20.Y VSS.t2419 sg13_lv_nmos ad=0.1406p pd=1.12u as=0.2516p ps=2.16u w=0.74u l=0.15u
X3386 VDD.t1544 sg13cmos5l_o21ai_1_8.B1 sg13cmos5l_nand2_1_9.Y VDD.t16 sg13_lv_pmos ad=0.3808p pd=2.92u as=0.2128p ps=1.5u w=1.12u l=0.13u
X3387 sg13cmos5l_inv_1_22.Y sg13cmos5l_dfrbpq_1_13.CLK VDD.t1318 VDD.t52 sg13_lv_pmos ad=0.3808p pd=2.92u as=0.3808p ps=2.92u w=1.12u l=0.13u
X3388 bp4 a_20488_3176# VSS.t122 VSS.t326 sg13_lv_nmos ad=0.2886p pd=2.26u as=0.14875p ps=1.16u w=0.74u l=0.13u
X3389 sg13cmos5l_or2_1_1.X a_10896_8052# VDD.t1379 VDD.t8 sg13_lv_pmos ad=0.3976p pd=2.95u as=0.2226p ps=1.535u w=1.12u l=0.13u
X3390 VSS.t176 sg13cmos5l_dfrbpq_1_24.RESET_B a_5078_16421# VSS.t1141 sg13_lv_nmos ad=0.1701p pd=1.65u as=37.8f ps=0.6u w=0.42u l=0.13u
X3391 VDD.t1078 a_5036_13686# sg13cmos5l_dfrbpq_1_24.RESET_B VDD.t19 sg13_lv_pmos ad=0.2114p pd=1.54u as=0.42p ps=2.99u w=1.12u l=0.13u
X3392 VSS.t260 a_6383_9263# a_7050_9484# VSS.t2483 sg13_lv_nmos ad=0.1406p pd=1.12u as=0.2516p ps=2.16u w=0.74u l=0.13u
X3393 VDD.t224 VSS.t2120 VDD.t149 VDD.t13 sg13_lv_pmos ad=0.19p pd=1.38u as=0 ps=0 w=1u l=1u
X3394 a_14218_18226# sg13cmos5l_buf_8_2.A.t6 VDD.t1793 VDD.t231 sg13_lv_pmos ad=0.2128p pd=1.5u as=0.2128p ps=1.5u w=1.12u l=0.13u
X3395 VDD.t2365 a_12987_12214# sg13cmos5l_buf_8_2.A.t0 VDD.t83 sg13_lv_pmos ad=0.2128p pd=1.5u as=0.2128p ps=1.5u w=1.12u l=0.13u
X3396 VSS.t52 sg13cmos5l_nor4_1_2.Y sg13cmos5l_nor2_1_16.Y VSS.t415 sg13_lv_nmos ad=0.2516p pd=2.16u as=0.1406p ps=1.12u w=0.74u l=0.13u
X3397 VDD.t1407 sg13cmos5l_buf_8_2.A.t3 a_6442_10666# VDD.t0 sg13_lv_pmos ad=0.2128p pd=1.5u as=0.2128p ps=1.5u w=1.12u l=0.13u
X3398 a_11674_12936# sg13cmos5l_dfrbpq_1_18.Q VDD.t1350 VDD.t83 sg13_lv_pmos ad=0.1428p pd=1.52u as=0.1523p ps=1.38u w=0.42u l=0.13u
X3399 VSS.t1614 VDD.t2560 VSS.t1605 VSS.t1613 sg13_lv_nmos ad=0.1428p pd=1.52u as=0 ps=0 w=0.42u l=1u
X3400 VDD.t1670 sg13cmos5l_inv_1_15.Y a_16763_17508# VDD.t310 sg13_lv_pmos ad=0.2128p pd=1.5u as=0.2128p ps=1.5u w=1.12u l=0.13u
X3401 VSS.t67 sg13cmos5l_mux2_1_0.S sg13cmos5l_nand4_1_3.B VSS.t66 sg13_lv_nmos ad=0.1406p pd=1.12u as=0.1406p ps=1.12u w=0.74u l=0.13u
X3402 VSS.t150 a_13676_12936# sg13cmos5l_buf_1_45.X VSS.t149 sg13_lv_nmos ad=0.14875p pd=1.16u as=0.2886p ps=2.26u w=0.74u l=0.13u
X3403 VSS.t7 sg13cmos5l_a21oi_1_15.Y a_19448_12214# VSS.t2324 sg13_lv_nmos ad=79.8f pd=0.8u as=0.1428p ps=1.52u w=0.42u l=0.13u
X3404 a_20937_11507# a_20580_11464# VDD.t363 VDD.t0 sg13_lv_pmos ad=63f pd=0.72u as=0.1563p ps=1.22u w=0.42u l=0.13u
X3405 VDD.t811 a_16725_7832# a_15804_7638# VDD.t8 sg13_lv_pmos ad=0.36237p pd=2.605u as=0.34p ps=2.68u w=1u l=0.13u
X3406 VDD.t1987 VSS.t2160 VDD.t188 VDD.t13 sg13_lv_pmos ad=0.19p pd=1.38u as=0 ps=0 w=1u l=1u
X3407 VSS.t563 sg13cmos5l_inv_1_0.A sg13cmos5l_inv_1_0.Y VSS.t562 sg13_lv_nmos ad=0.2516p pd=2.16u as=0.2516p ps=2.16u w=0.74u l=0.13u
X3408 VDD.t1910 VSS.t1877 VDD.t568 VDD.t2 sg13_lv_pmos ad=0.19p pd=1.38u as=0 ps=0 w=1u l=1u
X3409 VSS.t1880 VDD.t2470 VSS.t1879 VSS.t1878 sg13_lv_nmos ad=0.1428p pd=1.52u as=0 ps=0 w=0.42u l=1u
X3410 a_13566_8412# sg13cmos5l_nand2_1_0.B sg13cmos5l_nor3_1_2.B VDD.t8 sg13_lv_pmos ad=0.2716p pd=1.605u as=0.2128p ps=1.5u w=1.12u l=0.13u
X3411 sg13cmos5l_nor3_1_2.Y sg13cmos5l_nor3_1_2.C a_5943_8436# VDD.t8 sg13_lv_pmos ad=0.3808p pd=2.92u as=0.2128p ps=1.5u w=1.12u l=0.13u
X3412 a_4594_17886# sg13cmos5l_buf_1_66.X VSS.t384 VSS.t835 sg13_lv_nmos ad=0.2516p pd=2.16u as=0.1406p ps=1.12u w=0.74u l=0.15u
X3413 VSS.t585 a_6256_14726# a_5905_14845# VSS.t1543 sg13_lv_nmos ad=79.8f pd=0.8u as=0.1428p ps=1.52u w=0.42u l=0.13u
X3414 VSS.t576 sg13cmos5l_buf_1_43.X a_15496_13760# VSS.t128 sg13_lv_nmos ad=0.14875p pd=1.16u as=0.187p ps=1.78u w=0.55u l=0.13u
X3415 a_13880_10706# sg13cmos5l_o21ai_1_1.B1 a_13778_10706# VSS.t1465 sg13_lv_nmos ad=0.1406p pd=1.12u as=0.1406p ps=1.12u w=0.74u l=0.13u
X3416 VSS.t1360 sg13cmos5l_nand4_1_1.C a_16578_13338# VSS.t128 sg13_lv_nmos ad=0.2886p pd=2.26u as=0.1406p ps=1.12u w=0.74u l=0.13u
X3417 VSS.t479 sg13cmos5l_a21oi_1_1.A2 a_22337_5760# VSS.t10 sg13_lv_nmos ad=0.2516p pd=2.16u as=0.1406p ps=1.12u w=0.74u l=0.13u
X3418 VDD.t1451 sg13cmos5l_nand3_1_3.Y sg13cmos5l_a21oi_1_10.A2 VDD.t8 sg13_lv_pmos ad=0.3808p pd=2.92u as=0.2128p ps=1.5u w=1.12u l=0.13u
X3419 a_5769_8065# a_5412_7992# VDD.t659 VDD.t8 sg13_lv_pmos ad=63f pd=0.72u as=0.1563p ps=1.22u w=0.42u l=0.13u
X3420 sg13cmos5l_o21ai_1_24.Y sg13cmos5l_nor2_1_16.Y a_12792_17064# VDD.t310 sg13_lv_pmos ad=0.2128p pd=1.5u as=0.2128p ps=1.5u w=1.12u l=0.15u
X3421 VSS.t2178 VDD.t2380 VSS.t2180 VSS.t2179 sg13_lv_nmos ad=79.8f pd=0.8u as=0 ps=0 w=0.42u l=1u
X3422 VSS.t97 sg13cmos5l_nand3b_1_0.C a_13910_9194# VSS.t656 sg13_lv_nmos ad=0.18575p pd=1.26u as=0.1406p ps=1.12u w=0.74u l=0.13u
X3423 VDD.t1581 sg13cmos5l_nand4_1_18.C sg13cmos5l_a21oi_1_1.A2 VDD.t19 sg13_lv_pmos ad=0.2128p pd=1.5u as=0.2128p ps=1.5u w=1.12u l=0.13u
X3424 a_20388_13722# sg13cmos5l_dlygate4sd3_1_76.X a_20294_13722# VSS.t128 sg13_lv_nmos ad=60.89999f pd=0.71u as=0.1428p ps=1.52u w=0.42u l=0.13u
X3425 VSS.t291 VDD.t2411 VSS.t291 VSS.t2039 sg13_lv_nmos ad=79.8f pd=0.8u as=0 ps=0 w=0.42u l=1u
X3426 VSS.t422 a_16942_19287# sg13cmos5l_dlygate4sd3_1_82.X VSS.t356 sg13_lv_nmos ad=0.1426p pd=1.16u as=0.2516p ps=2.16u w=0.74u l=0.13u
X3427 VDD.t1026 sg13cmos5l_dfrbpq_1_28.RESET_B.t6 a_20554_14452# VDD.t19 sg13_lv_pmos ad=0.1563p pd=1.22u as=0.147p ps=1.54u w=0.42u l=0.13u
X3428 a_10878_7180# sg13cmos5l_a21oi_1_9.A1 a_11269_7314# VSS.t687 sg13_lv_nmos ad=0.2176p pd=1.96u as=0.1216p ps=1.02u w=0.64u l=0.13u
X3429 VDD.t1044 sg13cmos5l_buf_1_13.X a_17030_8874# VDD.t8 sg13_lv_pmos ad=0.36237p pd=2.605u as=79.8f ps=0.8u w=0.42u l=0.13u
X3430 a_5499_18649# a_4607_18528# a_5397_18416# VDD.t231 sg13_lv_pmos ad=63f pd=0.72u as=79.8f ps=0.8u w=0.42u l=0.13u
X3431 VSS.t677 sg13cmos5l_buf_1_15.A.t3 a_22262_16421# VSS.t1273 sg13_lv_nmos ad=0.1701p pd=1.65u as=37.8f ps=0.6u w=0.42u l=0.13u
X3432 sg13cmos5l_a21oi_1_25.A2 sg13cmos5l_buf_1_42.A VDD.t1592 VDD.t310 sg13_lv_pmos ad=0.2128p pd=1.5u as=0.3808p ps=2.92u w=1.12u l=0.13u
X3433 a_7090_15230# sg13cmos5l_buf_1_66.X VSS.t124 VSS.t834 sg13_lv_nmos ad=0.2516p pd=2.16u as=0.1406p ps=1.12u w=0.74u l=0.15u
X3434 a_20716_16746# a_20503_16710# VDD.t310 VDD.t310 sg13_lv_pmos ad=79.8f pd=0.8u as=2.1916p ps=14.26u w=0.42u l=0.13u
X3435 VDD.t1225 VSS.t2132 VDD.t2023 VDD.t13 sg13_lv_pmos ad=0.34p pd=2.68u as=0 ps=0 w=1u l=1u
X3436 a_18948_7687# a_19179_7796# a_18634_7897# VSS.t23 sg13_lv_nmos ad=0.2373p pd=1.97u as=79.8f ps=0.8u w=0.42u l=0.13u
X3437 VDD.t206 VSS.t1852 VDD.t205 VDD.t8 sg13_lv_pmos ad=0.19p pd=1.38u as=0 ps=0 w=1u l=1u
X3438 a_7881_19067# a_7524_19024# VDD.t1503 VDD.t231 sg13_lv_pmos ad=63f pd=0.72u as=0.1563p ps=1.22u w=0.42u l=0.13u
X3439 sg13cmos5l_nand4_1_16.D a_14761_15238# VDD.t1450 VDD.t16 sg13_lv_pmos ad=0.3808p pd=2.92u as=0.3822p ps=1.84u w=1.12u l=0.13u
X3440 VSS.t163 sg13cmos5l_buf_8_2.A.t4 a_21531_13342# VSS.t2613 sg13_lv_nmos ad=0.1406p pd=1.12u as=0.1406p ps=1.12u w=0.74u l=0.13u
X3441 VSS.t76 a_22330_10666# a_22049_10888# VSS.t75 sg13_lv_nmos ad=79.8f pd=0.8u as=0.1428p ps=1.52u w=0.42u l=0.5u
X3442 VSS.t271 sg13cmos5l_dfrbpq_1_15.CLK a_7199_6432# VSS.t2395 sg13_lv_nmos ad=4.02307p pd=25.55u as=0.2516p ps=2.16u w=0.74u l=0.13u
X3443 VDD.t2 a_22096_7166# a_22041_7047# VDD.t2 sg13_lv_pmos ad=2.1916p pd=14.26u as=93.45f ps=0.865u w=0.42u l=0.13u
X3444 VDD.t1327 a_6286_16263# sg13cmos5l_o21ai_1_10.B1 VDD.t16 sg13_lv_pmos ad=0.2254p pd=1.53u as=0.4256p ps=3u w=1.12u l=0.13u
X3445 a_8879_15238# sg13cmos5l_nor4_1_1.D VSS.t46 VSS.t1470 sg13_lv_nmos ad=0.2516p pd=2.16u as=0.1898p ps=1.36u w=0.74u l=0.13u
X3446 a_18374_18262# a_18104_18262# VSS.t1433 VSS.t92 sg13_lv_nmos ad=0.1428p pd=1.52u as=79.8f ps=0.8u w=0.42u l=0.5u
X3447 a_18948_5416# a_19467_5423# a_20207_5773# VSS.t10 sg13_lv_nmos ad=0.3473p pd=2.71u as=0.12665p ps=1.145u w=0.74u l=0.13u
X3448 a_16374_16754# sg13cmos5l_buf_1_42.A sg13cmos5l_a21oi_1_26.A2 VSS.t1232 sg13_lv_nmos ad=0.1406p pd=1.12u as=0.2516p ps=2.16u w=0.74u l=0.13u
X3449 a_4821_16043# a_3879_16083# a_4682_16276# VSS.t535 sg13_lv_nmos ad=79.8f pd=0.8u as=0.2373p ps=1.97u w=0.42u l=0.13u
X3450 a_19066_15960# sg13cmos5l_dlygate4sd3_1_72.A VSS.t132 VSS.t2634 sg13_lv_nmos ad=0.1428p pd=1.52u as=79.8f ps=0.8u w=0.42u l=0.13u
X3451 a_5097_14531# a_4740_14488# VDD.t1513 VDD.t19 sg13_lv_pmos ad=63f pd=0.72u as=0.1563p ps=1.22u w=0.42u l=0.13u
X3452 VSS.t293 sg13cmos5l_nor2_1_2.A a_8719_5782# VSS.t292 sg13_lv_nmos ad=0.14505p pd=1.15u as=0.1406p ps=1.12u w=0.74u l=0.13u
X3453 VDD.t1828 a_10508_10662# sg13cmos5l_o21ai_1_5.A1 VDD.t0 sg13_lv_pmos ad=0.2114p pd=1.54u as=0.42p ps=2.99u w=1.12u l=0.13u
X3454 sg13cmos5l_nand4_1_7.B a_10833_14874# VDD.t802 VDD.t19 sg13_lv_pmos ad=0.5376p pd=3.2u as=0.2044p ps=1.53u w=1.12u l=0.13u
X3455 a_11029_14874# sg13cmos5l_mux2_1_0.S a_10927_14874# VSS.t2250 sg13_lv_nmos ad=0.1216p pd=1.02u as=0.1216p ps=1.02u w=0.64u l=0.13u
X3456 VSS.t253 a_17829_6935# a_17931_6935# VSS.t879 sg13_lv_nmos ad=4.7455p pd=30.71u as=0.2516p ps=2.16u w=0.74u l=0.13u
X3457 sg13cmos5l_nand3_1_0.A sg13cmos5l_or2_1_1.X a_12120_8416# VDD.t8 sg13_lv_pmos ad=0.2128p pd=1.5u as=0.2128p ps=1.5u w=1.12u l=0.15u
X3458 VSS.t1676 VDD.t2538 VSS.t1498 VSS.t1677 sg13_lv_nmos ad=79.8f pd=0.8u as=0 ps=0 w=0.42u l=1u
X3459 VDD.t141 VSS.t2105 VDD.t140 VDD.t13 sg13_lv_pmos ad=0.19p pd=1.38u as=0 ps=0 w=1u l=1u
X3460 VSS.t2163 VDD.t2383 VSS.t2165 VSS.t2164 sg13_lv_nmos ad=79.8f pd=0.8u as=0 ps=0 w=0.42u l=1u
X3461 a_10774_17886# sg13cmos5l_or4_1_1.X VSS.t1140 VSS.t952 sg13_lv_nmos ad=0.1406p pd=1.12u as=0.1406p ps=1.12u w=0.74u l=0.15u
X3462 VDD.t19 a_22096_13942# a_22041_14037# VDD.t19 sg13_lv_pmos ad=2.1916p pd=14.26u as=93.45f ps=0.865u w=0.42u l=0.13u
X3463 a_20554_11428# a_20997_11471# a_20294_11898# VSS.t1008 sg13_lv_nmos ad=79.8f pd=0.8u as=0.1296p ps=1.52u w=0.42u l=0.13u
X3464 a_9885_7194# sg13cmos5l_nand2b_1_1.A_N VDD.t1979 VDD.t2 sg13_lv_pmos ad=0.2856p pd=2.36u as=0.2198p ps=1.53u w=0.84u l=0.13u
X3465 VDD.t255 VSS.t60 VDD.t254 VDD.t83 sg13_lv_pmos ad=0.34p pd=2.68u as=0 ps=0 w=1u l=1u
X3466 VSS.t740 a_8879_10309# a_9546_9948# VSS.t2507 sg13_lv_nmos ad=0.1406p pd=1.12u as=0.2516p ps=2.16u w=0.74u l=0.13u
X3467 a_3628_16746# a_3415_16710# VDD.t310 VDD.t310 sg13_lv_pmos ad=79.8f pd=0.8u as=2.1916p ps=14.26u w=0.42u l=0.13u
X3468 a_10474_9916# a_10917_9959# a_10857_9995# VDD.t52 sg13_lv_pmos ad=79.8f pd=0.8u as=63f ps=0.72u w=0.42u l=0.13u
X3469 VDD.t807 a_18382_6351# sg13cmos5l_dlygate4sd3_1_29.X VDD.t2 sg13_lv_pmos ad=0.2254p pd=1.53u as=0.4256p ps=3u w=1.12u l=0.13u
X3470 sg13cmos5l_nand4_1_1.B sg13cmos5l_a21oi_1_27.A1 a_10359_14020# VDD.t19 sg13_lv_pmos ad=0.3808p pd=2.92u as=0.2128p ps=1.5u w=1.12u l=0.13u
X3471 VSS.t22 sg13cmos5l_buf_1_10.A a_21640_3900# VSS.t193 sg13_lv_nmos ad=0.14875p pd=1.16u as=0.187p ps=1.78u w=0.55u l=0.13u
X3472 a_9765_5423# sg13cmos5l_dfrbpq_1_13.CLK VSS.t271 VSS.t945 sg13_lv_nmos ad=0.2516p pd=2.16u as=3.65735p ps=23.23u w=0.74u l=0.13u
X3473 VSS.t1099 a_20506_19738# a_20225_19960# VSS.t1055 sg13_lv_nmos ad=79.8f pd=0.8u as=0.1428p ps=1.52u w=0.42u l=0.5u
X3474 a_13881_19143# a_12939_19031# a_13679_19381# VDD.t231 sg13_lv_pmos ad=93.45f pd=0.865u as=0.2048p ps=1.63u w=0.42u l=0.13u
X3475 VDD.t521 VSS.t1910 VDD.t520 VDD.t5 sg13_lv_pmos ad=0.34p pd=2.68u as=0 ps=0 w=1u l=1u
X3476 a_17710_17775# a_17825_17774# VSS.t180 VSS.t179 sg13_lv_nmos ad=0.1428p pd=1.52u as=0.1426p ps=1.16u w=0.42u l=0.5u
X3477 VDD.t306 VSS.t1663 VDD.t305 VDD.t19 sg13_lv_pmos ad=0.19p pd=1.38u as=0 ps=0 w=1u l=1u
X3478 sg13cmos5l_a21oi_1_19.A2 sg13cmos5l_buf_1_42.A VDD.t1587 VDD.t16 sg13_lv_pmos ad=0.2128p pd=1.5u as=0.3808p ps=2.92u w=1.12u l=0.13u
X3479 VSS.t867 sg13cmos5l_dfrbpq_1_28.RESET_B.t11 a_22262_18271# VSS.t140 sg13_lv_nmos ad=0.1701p pd=1.65u as=37.8f ps=0.6u w=0.42u l=0.13u
X3480 a_17098_6130# sg13cmos5l_buf_8_2.A.t1 VDD.t988 VDD.t2 sg13_lv_pmos ad=0.2128p pd=1.5u as=0.2128p ps=1.5u w=1.12u l=0.13u
X3481 VSS.t1865 VDD.t2473 VSS.t1864 VSS.t1863 sg13_lv_nmos ad=0.1428p pd=1.52u as=0 ps=0 w=0.42u l=1u
X3482 a_20554_8404# a_20997_8447# a_20294_8874# VSS.t902 sg13_lv_nmos ad=79.8f pd=0.8u as=0.1296p ps=1.52u w=0.42u l=0.13u
X3483 a_11690_17044# sg13cmos5l_o21ai_1_5.A1 VDD.t1357 VDD.t310 sg13_lv_pmos ad=0.1176p pd=1.33u as=0.4032p ps=2.96u w=1.12u l=0.13u
X3484 a_16954_10702# sg13cmos5l_nand3_1_1.Y VSS.t174 VSS.t2348 sg13_lv_nmos ad=0.1406p pd=1.12u as=0.2516p ps=2.16u w=0.74u l=0.13u
X3485 VSS.t97 a_14842_9154# a_14561_9376# VSS.t525 sg13_lv_nmos ad=79.8f pd=0.8u as=0.1428p ps=1.52u w=0.42u l=0.5u
X3486 a_14926_16935# a_15041_16936# VSS.t437 VSS.t2629 sg13_lv_nmos ad=0.1428p pd=1.52u as=0.1426p ps=1.16u w=0.42u l=0.5u
X3487 a_15000_8416# sg13cmos5l_o21ai_1_1.Y VDD.t660 VDD.t8 sg13_lv_pmos ad=0.2128p pd=1.5u as=0.3808p ps=2.92u w=1.12u l=0.15u
X3488 sg13cmos5l_o21ai_1_10.A2 sg13cmos5l_nor4_1_4.C VDD.t1903 VDD.t16 sg13_lv_pmos ad=0.2128p pd=1.5u as=0.2128p ps=1.5u w=1.12u l=0.13u
X3489 VDD.t1584 sg13cmos5l_nand4_1_18.C sg13cmos5l_a21oi_1_0.A2 VDD.t83 sg13_lv_pmos ad=0.2128p pd=1.5u as=0.2128p ps=1.5u w=1.12u l=0.13u
X3490 a_22005_18416# a_21063_18476# a_21911_18649# VDD.t231 sg13_lv_pmos ad=79.8f pd=0.8u as=0.1428p ps=1.52u w=0.42u l=0.13u
X3491 a_17109_9344# a_16167_9404# a_17015_9577# VDD.t52 sg13_lv_pmos ad=79.8f pd=0.8u as=0.1428p ps=1.52u w=0.42u l=0.13u
X3492 sg13cmos5l_dlygate4sd3_1_22.A sg13cmos5l_a21oi_1_2.B1 a_21269_9484# VDD.t52 sg13_lv_pmos ad=0.3808p pd=2.92u as=0.2128p ps=1.5u w=1.12u l=0.13u
X3493 VSS.t1981 VDD.t2414 VSS.t1987 VSS.t1986 sg13_lv_nmos ad=79.8f pd=0.8u as=0 ps=0 w=0.42u l=1u
X3494 a_21370_19738# sg13cmos5l_dfrbpq_1_39.Q VSS.t1056 VSS.t1055 sg13_lv_nmos ad=0.1428p pd=1.52u as=79.8f ps=0.8u w=0.42u l=0.13u
X3495 a_5303_18649# sg13cmos5l_dfrbpq_1_20.D a_6050_18258# VSS.t1256 sg13_lv_nmos ad=0.1428p pd=1.52u as=60.89999f ps=0.71u w=0.42u l=0.13u
X3496 VDD.t1470 a_12987_10318# sg13cmos5l_dfrbpq_1_13.CLK VDD.t52 sg13_lv_pmos ad=0.2128p pd=1.5u as=0.2128p ps=1.5u w=1.12u l=0.13u
X3497 VSS.t1632 VDD.t2552 VSS.t1108 VSS.t1640 sg13_lv_nmos ad=79.8f pd=0.8u as=0 ps=0 w=0.42u l=1u
X3498 VSS.t174 a_16838_9948# a_16950_9972# VSS.t1586 sg13_lv_nmos ad=0.1426p pd=1.16u as=0.1428p ps=1.52u w=0.42u l=0.5u
X3499 VSS.t1722 VDD.t2512 VSS.t1724 VSS.t1723 sg13_lv_nmos ad=79.8f pd=0.8u as=0 ps=0 w=0.42u l=1u
X3500 VDD.t5 sg13cmos5l_buf_1_13.A a_12844_5850# VDD.t5 sg13_lv_pmos ad=1.96072p pd=12.69u as=79.8f ps=0.8u w=0.42u l=0.13u
X3501 VDD.t986 a_17098_6130# sg13cmos5l_inv_1_5.A VDD.t2 sg13_lv_pmos ad=0.2128p pd=1.5u as=0.2128p ps=1.5u w=1.12u l=0.13u
X3502 VSS.t845 a_9136_10190# a_8785_10309# VSS.t844 sg13_lv_nmos ad=79.8f pd=0.8u as=0.1428p ps=1.52u w=0.42u l=0.13u
X3503 VDD.t149 VSS.t2117 VDD.t148 VDD.t13 sg13_lv_pmos ad=0.34p pd=2.68u as=0 ps=0 w=1u l=1u
X3504 VDD.t854 a_15023_16357# a_15690_15996# VDD.t16 sg13_lv_pmos ad=0.2128p pd=1.5u as=0.3864p ps=2.93u w=1.12u l=0.13u
X3505 VDD.t272 VSS.t1604 VDD.t271 VDD.t270 sg13_lv_pmos ad=0.34p pd=2.68u as=0 ps=0 w=1u l=1u
X3506 a_5222_17508# a_4952_17549# VDD.t861 VDD.t310 sg13_lv_pmos ad=0.34p pd=2.68u as=0.1523p ps=1.38u w=1u l=0.5u
X3507 sg13cmos5l_o21ai_1_10.Y sg13cmos5l_o21ai_1_10.A2 a_5784_15976# VDD.t16 sg13_lv_pmos ad=0.2128p pd=1.5u as=0.2128p ps=1.5u w=1.12u l=0.15u
X3508 VSS.t273 a_19534_4839# sg13cmos5l_buf_1_6.A VSS.t2557 sg13_lv_nmos ad=0.1426p pd=1.16u as=0.2516p ps=2.16u w=0.74u l=0.13u
X3509 VSS.t264 a_17733_8447# a_17835_8447# VSS.t1576 sg13_lv_nmos ad=5.26052p pd=34.445u as=0.2516p ps=2.16u w=0.74u l=0.13u
X3510 VDD.t851 a_5230_19959# sg13cmos5l_o21ai_1_21.B1 VDD.t270 sg13_lv_pmos ad=0.2254p pd=1.53u as=0.4256p ps=3u w=1.12u l=0.13u
X3511 sg13cmos5l_dfrbpq_1_34.Q a_16170_20068# VSS.t307 VSS.t166 sg13_lv_nmos ad=0.2516p pd=2.16u as=0.1406p ps=1.12u w=0.74u l=0.13u
X3512 VSS.t129 sg13cmos5l_a21oi_1_17.Y a_17608_13760# VSS.t128 sg13_lv_nmos ad=0.14875p pd=1.16u as=0.187p ps=1.78u w=0.55u l=0.13u
X3513 a_7498_18226# sg13cmos5l_buf_8_2.A.t7 VSS.t56 VSS.t1376 sg13_lv_nmos ad=0.2553p pd=2.17u as=0.1406p ps=1.12u w=0.74u l=0.13u
X3514 VSS.t159 sg13cmos5l_inv_1_24.A sg13cmos5l_inv_1_24.Y VSS.t66 sg13_lv_nmos ad=0.2516p pd=2.16u as=0.2516p ps=2.16u w=0.74u l=0.13u
X3515 sg13cmos5l_nand2_1_1.Y sg13cmos5l_nand3_1_1.Y VDD.t2107 VDD.t0 sg13_lv_pmos ad=0.2128p pd=1.5u as=0.3808p ps=2.92u w=1.12u l=0.13u
X3516 VDD.t1836 VSS.t1882 VDD.t1835 VDD.t2 sg13_lv_pmos ad=0.19p pd=1.38u as=0 ps=0 w=1u l=1u
X3517 a_16725_7832# a_15783_7892# a_16631_8065# VDD.t8 sg13_lv_pmos ad=79.8f pd=0.8u as=0.1428p ps=1.52u w=0.42u l=0.13u
X3518 a_4594_17886# sg13cmos5l_o21ai_1_21.B1 sg13cmos5l_o21ai_1_21.Y VSS.t466 sg13_lv_nmos ad=0.1406p pd=1.12u as=0.2516p ps=2.16u w=0.74u l=0.15u
X3519 sg13cmos5l_dfrbpq_1_13.CLK a_12987_10318# VDD.t1466 VDD.t52 sg13_lv_pmos ad=0.2128p pd=1.5u as=0.2128p ps=1.5u w=1.12u l=0.13u
X3520 VDD.t1040 sg13cmos5l_buf_1_13.X a_17578_11428# VDD.t0 sg13_lv_pmos ad=0.1563p pd=1.22u as=0.147p ps=1.54u w=0.42u l=0.13u
X3521 a_13294_16935# a_13409_16936# VSS.t204 VSS.t1248 sg13_lv_nmos ad=0.1428p pd=1.52u as=0.1426p ps=1.16u w=0.42u l=0.5u
X3522 VSS.t1790 VDD.t2502 VSS.t1789 VSS.t1788 sg13_lv_nmos ad=0.1428p pd=1.52u as=0 ps=0 w=0.42u l=1u
X3523 sg13cmos5l_o21ai_1_7.A2 sg13cmos5l_a21oi_1_27.B1 VSS.t1130 VSS.t2290 sg13_lv_nmos ad=0.1406p pd=1.12u as=0.2516p ps=2.16u w=0.74u l=0.13u
X3524 VDD.t231 a_20015_19381# a_20272_19262# VDD.t231 sg13_lv_pmos ad=1.54512p pd=9.865u as=79.8f ps=0.8u w=0.42u l=0.13u
X3525 a_16172_14448# sg13cmos5l_nand4_1_3.D VDD.t905 VDD.t19 sg13_lv_pmos ad=0.2856p pd=2.36u as=0.2114p ps=1.54u w=0.84u l=0.13u
X3526 VSS.t174 sg13cmos5l_dlygate4sd3_1_13.A a_17240_10702# VSS.t173 sg13_lv_nmos ad=79.8f pd=0.8u as=0.1428p ps=1.52u w=0.42u l=0.13u
X3527 VSS.t122 sg13cmos5l_buf_1_2.A a_20104_3176# VSS.t682 sg13_lv_nmos ad=0.14875p pd=1.16u as=0.187p ps=1.78u w=0.55u l=0.13u
X3528 VSS.t279 sg13cmos5l_a21oi_1_9.A1 sg13cmos5l_nor3_1_1.Y VSS.t688 sg13_lv_nmos ad=0.2618p pd=2.22u as=0.1694p ps=1.21u w=0.77u l=0.13u
X3529 VDD.t8 sg13cmos5l_buf_1_13.A a_15436_7674# VDD.t8 sg13_lv_pmos ad=1.8716p pd=12.115u as=79.8f ps=0.8u w=0.42u l=0.13u
X3530 VDD.t2135 sg13cmos5l_o21ai_1_0.A1 a_13148_4968# VDD.t5 sg13_lv_pmos ad=0.3808p pd=2.92u as=0.2128p ps=1.5u w=1.12u l=0.15u
X3531 a_16283_17508# sg13cmos5l_a21oi_1_26.A2 VDD.t712 VDD.t310 sg13_lv_pmos ad=0.3808p pd=2.92u as=0.2128p ps=1.5u w=1.12u l=0.13u
X3532 a_17028_15552# a_17002_15457# VDD.t684 VDD.t16 sg13_lv_pmos ad=0.34p pd=2.68u as=0.36237p ps=2.605u w=1u l=0.13u
X3533 a_18587_4948# sg13cmos5l_a21oi_1_2.B1 sg13cmos5l_a21oi_1_0.Y VDD.t5 sg13_lv_pmos ad=0.2128p pd=1.5u as=0.3808p ps=2.92u w=1.12u l=0.13u
X3534 VSS.t1973 VDD.t2417 VSS.t1973 VSS.t1979 sg13_lv_nmos ad=79.8f pd=0.8u as=0 ps=0 w=0.42u l=1u
X3535 a_5126_7674# sg13cmos5l_dlygate4sd3_1_43.X VDD.t2283 VDD.t8 sg13_lv_pmos ad=79.8f pd=0.8u as=0.1428p ps=1.52u w=0.42u l=0.13u
X3536 a_9879_12972# sg13cmos5l_dfrbpq_1_24.Q a_9765_12972# VDD.t83 sg13_lv_pmos ad=0.2128p pd=1.5u as=0.2464p ps=1.56u w=1.12u l=0.13u
X3537 a_20464_5654# sg13cmos5l_buf_1_7.X VDD.t5 VDD.t5 sg13_lv_pmos ad=79.8f pd=0.8u as=1.8716p ps=12.115u w=0.42u l=0.13u
X3538 VDD.t798 a_16474_18984# a_16193_19286# VDD.t231 sg13_lv_pmos ad=0.1523p pd=1.38u as=0.34p ps=2.68u w=1u l=0.5u
X3539 a_7090_15230# sg13cmos5l_o21ai_1_7.B1 sg13cmos5l_o21ai_1_7.Y VSS.t573 sg13_lv_nmos ad=0.1406p pd=1.12u as=0.2516p ps=2.16u w=0.74u l=0.15u
X3540 VSS.t271 a_16773_5423# a_16875_5423# VSS.t2511 sg13_lv_nmos ad=4.02307p pd=25.55u as=0.2516p ps=2.16u w=0.74u l=0.13u
X3541 a_20388_7362# sg13cmos5l_dfrbpq_1_8.D a_20294_7362# VSS.t2233 sg13_lv_nmos ad=60.89999f pd=0.71u as=0.1428p ps=1.52u w=0.42u l=0.13u
X3542 VSS.t863 sg13cmos5l_buf_1_15.A.t4 a_20810_16434# VSS.t862 sg13_lv_nmos ad=79.8f pd=0.8u as=37.8f ps=0.6u w=0.42u l=0.13u
X3543 a_14698_6385# a_15141_6141# a_15081_6553# VDD.t2 sg13_lv_pmos ad=79.8f pd=0.8u as=63f ps=0.72u w=0.42u l=0.13u
X3544 a_12957_7194# sg13cmos5l_o21ai_1_0.A1 VSS.t284 VSS.t2379 sg13_lv_nmos ad=0.187p pd=1.78u as=0.14505p ps=1.15u w=0.55u l=0.13u
X3545 VSS.t182 a_6835_13916# sg13cmos5l_a21o_1_2.X VSS.t66 sg13_lv_nmos ad=0.15745p pd=1.175u as=0.2351p ps=2.16u w=0.74u l=0.13u
X3546 a_16562_13730# sg13cmos5l_nand4_1_18.D VSS.t516 VSS.t128 sg13_lv_nmos ad=0.1406p pd=1.12u as=0.2516p ps=2.16u w=0.74u l=0.13u
X3547 VDD.t2318 VSS.t1744 VDD.t331 VDD.t0 sg13_lv_pmos ad=0.19p pd=1.38u as=0 ps=0 w=1u l=1u
X3548 VSS.t222 sg13cmos5l_and2_1_5.X sg13cmos5l_nor3_1_7.Y VSS.t318 sg13_lv_nmos ad=0.1463p pd=1.15u as=0.1694p ps=1.21u w=0.77u l=0.13u
X3549 a_7620_9952# a_7594_9916# VDD.t846 VDD.t52 sg13_lv_pmos ad=0.34p pd=2.68u as=0.36237p ps=2.605u w=1u l=0.13u
X3550 VSS.t1966 VDD.t2439 VSS.t1966 VSS.t1967 sg13_lv_nmos ad=79.8f pd=0.8u as=0 ps=0 w=0.42u l=1u
X3551 a_9070_18447# a_9185_18448# VDD.t1609 VDD.t231 sg13_lv_pmos ad=0.34p pd=2.68u as=0.2254p ps=1.53u w=1u l=0.5u
X3552 a_8337_13362# sg13cmos5l_and4_1_1.A VDD.t1056 VDD.t83 sg13_lv_pmos ad=0.1596p pd=1.22u as=0.2856p ps=2.36u w=0.84u l=0.13u
X3553 a_11116_17044# sg13cmos5l_nand4_1_1.B sg13cmos5l_nor2_1_10.Y VDD.t310 sg13_lv_pmos ad=0.1176p pd=1.33u as=0.3808p ps=2.92u w=1.12u l=0.13u
X3554 sg13cmos5l_dfrbpq_1_13.CLK a_12987_10318# VSS.t86 VSS.t1094 sg13_lv_nmos ad=0.1406p pd=1.12u as=0.1406p ps=1.12u w=0.74u l=0.13u
X3555 VSS.t113 a_14218_18226# sg13cmos5l_dfrbpq_1_41.CLK VSS.t1430 sg13_lv_nmos ad=0.1406p pd=1.12u as=0.1406p ps=1.12u w=0.74u l=0.13u
X3556 a_13572_16434# sg13cmos5l_dlygate4sd3_1_80.X a_13478_16434# VSS.t346 sg13_lv_nmos ad=60.89999f pd=0.71u as=0.1428p ps=1.52u w=0.42u l=0.13u
X3557 a_14052_17933# a_13764_17512# a_13990_17933# VSS.t966 sg13_lv_nmos ad=0.1428p pd=1.52u as=37.8f ps=0.6u w=0.42u l=0.13u
X3558 a_18296_13338# sg13cmos5l_nand4_1_18.C a_18194_13338# VSS.t128 sg13_lv_nmos ad=0.1406p pd=1.12u as=0.1406p ps=1.12u w=0.74u l=0.13u
X3559 VDD.t708 sg13cmos5l_dfrbpq_1_28.RESET_B.t2 a_20294_12210# VDD.t83 sg13_lv_pmos ad=0.36237p pd=2.605u as=79.8f ps=0.8u w=0.42u l=0.13u
X3560 a_4821_16043# sg13cmos5l_dfrbpq_1_24.RESET_B VDD.t1336 VDD.t16 sg13_lv_pmos ad=0.147p pd=1.54u as=0.1563p ps=1.22u w=0.42u l=0.13u
X3561 a_20121_7989# a_19179_7796# a_19919_7751# VDD.t8 sg13_lv_pmos ad=93.45f pd=0.865u as=0.2048p ps=1.63u w=0.42u l=0.13u
X3562 sg13cmos5l_nor3_1_6.Y sg13cmos5l_a21oi_1_27.A1 VSS.t196 VSS.t149 sg13_lv_nmos ad=0.2618p pd=2.22u as=0.1463p ps=1.15u w=0.77u l=0.13u
X3563 VSS.t107 a_11756_19734# code4 VSS.t2428 sg13_lv_nmos ad=0.14875p pd=1.16u as=0.2886p ps=2.26u w=0.74u l=0.13u
X3564 VSS.t740 VDD.t2494 VSS.t740 VSS.t1815 sg13_lv_nmos ad=79.8f pd=0.8u as=0 ps=0 w=0.42u l=1u
X3565 a_7620_9952# a_8139_9959# a_8879_10309# VSS.t2565 sg13_lv_nmos ad=0.3473p pd=2.71u as=0.12665p ps=1.145u w=0.74u l=0.13u
X3566 a_8671_7996# sg13cmos5l_a22oi_1_1.B2 sg13cmos5l_dlygate4sd3_1_43.A VDD.t8 sg13_lv_pmos ad=0.2744p pd=1.61u as=0.2128p ps=1.5u w=1.12u l=0.13u
X3567 VSS.t120 a_15214_10215# sg13cmos5l_o21ai_1_3.A2 VSS.t536 sg13_lv_nmos ad=0.1426p pd=1.16u as=0.2516p ps=2.16u w=0.74u l=0.13u
X3568 a_10906_18984# sg13cmos5l_dlygate4sd3_1_54.A VSS.t937 VSS.t936 sg13_lv_nmos ad=0.1428p pd=1.52u as=79.8f ps=0.8u w=0.42u l=0.13u
X3569 a_15754_18481# a_16197_18237# a_15494_18258# VSS.t1017 sg13_lv_nmos ad=79.8f pd=0.8u as=0.1296p ps=1.52u w=0.42u l=0.13u
X3570 VDD.t908 VSS.t1658 VDD.t343 VDD.t16 sg13_lv_pmos ad=0.34p pd=2.68u as=0 ps=0 w=1u l=1u
X3571 VSS.t271 sg13cmos5l_dfrbpq_1_13.CLK a_13343_5383# VSS.t942 sg13_lv_nmos ad=3.65735p pd=23.23u as=0.2516p ps=2.16u w=0.74u l=0.13u
X3572 VSS.t37 a_22126_7863# sg13cmos5l_buf_1_0.A VSS.t667 sg13_lv_nmos ad=0.1426p pd=1.16u as=0.2516p ps=2.16u w=0.74u l=0.13u
X3573 VDD.t231 sg13cmos5l_dfrbpq_1_24.RESET_B a_4108_18258# VDD.t231 sg13_lv_pmos ad=1.4953p pd=9.545u as=79.8f ps=0.8u w=0.42u l=0.13u
X3574 VDD.t314 VSS.t1642 VDD.t313 VDD.t310 sg13_lv_pmos ad=0.34p pd=2.68u as=0 ps=0 w=1u l=1u
X3575 VSS.t222 a_14842_11424# a_14561_11726# VSS.t226 sg13_lv_nmos ad=79.8f pd=0.8u as=0.1428p ps=1.52u w=0.42u l=0.5u
X3576 a_10500_9952# a_10474_9916# VSS.t740 VSS.t2527 sg13_lv_nmos ad=0.2516p pd=2.16u as=0.1626p ps=1.415u w=0.74u l=0.13u
X3577 VSS.t1722 VDD.t2523 VSS.t1724 VSS.t1723 sg13_lv_nmos ad=79.8f pd=0.8u as=0 ps=0 w=0.42u l=1u
X3578 VSS.t210 sg13cmos5l_buf_1_1.A a_21640_3176# VSS.t209 sg13_lv_nmos ad=0.14875p pd=1.16u as=0.187p ps=1.78u w=0.55u l=0.13u
X3579 a_7047_6380# a_7199_6432# VDD.t2 VDD.t2 sg13_lv_pmos ad=0.3864p pd=2.93u as=2.1916p ps=14.26u w=1.12u l=0.13u
X3580 sg13cmos5l_dlygate4sd3_1_82.A sg13cmos5l_a21oi_1_21.A1 a_17811_19368# VSS.t935 sg13_lv_nmos ad=0.1406p pd=1.12u as=0.1406p ps=1.12u w=0.74u l=0.13u
X3581 a_20810_18258# a_20503_18222# a_20716_18258# VSS.t118 sg13_lv_nmos ad=37.8f pd=0.6u as=0.1428p ps=1.52u w=0.42u l=0.13u
X3582 VDD.t1777 sg13cmos5l_nor2_1_4.Y sg13cmos5l_nand3_1_5.Y VDD.t16 sg13_lv_pmos ad=0.3808p pd=2.92u as=0.2128p ps=1.5u w=1.12u l=0.13u
X3583 VDD.t204 VSS.t190 VDD.t203 VDD.t8 sg13_lv_pmos ad=0.34p pd=2.68u as=0 ps=0 w=1u l=1u
X3584 VDD.t1508 sg13cmos5l_dfrbpq_1_24.RESET_B a_10694_18258# VDD.t231 sg13_lv_pmos ad=0.36237p pd=2.605u as=79.8f ps=0.8u w=0.42u l=0.13u
X3585 a_21370_6130# sg13cmos5l_dlygate4sd3_1_28.A VSS.t479 VSS.t258 sg13_lv_nmos ad=0.1428p pd=1.52u as=79.8f ps=0.8u w=0.42u l=0.13u
X3586 VDD.t2139 a_20398_4167# sg13cmos5l_inv_1_0.A VDD.t13 sg13_lv_pmos ad=0.2254p pd=1.53u as=0.4256p ps=3u w=1.12u l=0.13u
X3587 a_9765_19749# sg13cmos5l_dfrbpq_1_19.CLK VDD.t270 VDD.t270 sg13_lv_pmos ad=0.4088p pd=2.97u as=2.69447p ps=17.64u w=1.12u l=0.13u
X3588 a_12178_10386# sg13cmos5l_dfrbpq_1_13.RESET_B VSS.t248 VSS.t1216 sg13_lv_nmos ad=37.8f pd=0.6u as=79.8f ps=0.8u w=0.42u l=0.13u
X3589 VDD.t2110 a_22522_3864# a_22241_4166# VDD.t13 sg13_lv_pmos ad=0.1523p pd=1.38u as=0.34p ps=2.68u w=1u l=0.5u
X3590 VSS.t759 VDD.t2459 VSS.t101 VSS.t1903 sg13_lv_nmos ad=0.1428p pd=1.52u as=0 ps=0 w=0.42u l=1u
X3591 a_17730_16362# sg13cmos5l_buf_1_43.X a_17628_16362# VSS.t2585 sg13_lv_nmos ad=0.1406p pd=1.12u as=0.1406p ps=1.12u w=0.74u l=0.13u
X3592 sg13cmos5l_dfrbpq_1_13.CLK a_12987_10318# VSS.t86 VSS.t1090 sg13_lv_nmos ad=0.1406p pd=1.12u as=0.1406p ps=1.12u w=0.74u l=0.13u
X3593 a_4838_9186# a_5643_9308# a_5098_9409# VDD.t52 sg13_lv_pmos ad=0.1428p pd=1.52u as=79.8f ps=0.8u w=0.42u l=0.13u
X3594 VSS.t113 a_14218_18226# sg13cmos5l_dfrbpq_1_41.CLK VSS.t1426 sg13_lv_nmos ad=0.1406p pd=1.12u as=0.1406p ps=1.12u w=0.74u l=0.13u
X3595 a_13460_6924# a_13434_6887# sg13cmos5l_o21ai_1_0.B1 VDD.t2 sg13_lv_pmos ad=0.2128p pd=1.5u as=0.3808p ps=2.92u w=1.12u l=0.13u
X3596 a_19054_18447# a_19169_18448# VDD.t881 VDD.t231 sg13_lv_pmos ad=0.34p pd=2.68u as=0.2254p ps=1.53u w=1u l=0.5u
X3597 VDD.t982 a_17098_6130# sg13cmos5l_inv_1_5.A VDD.t2 sg13_lv_pmos ad=0.2128p pd=1.5u as=0.2128p ps=1.5u w=1.12u l=0.13u
X3598 sg13cmos5l_o21ai_1_0.B1 a_13434_6887# VSS.t284 VSS.t564 sg13_lv_nmos ad=0.1628p pd=1.18u as=0.3108p ps=2.32u w=0.74u l=0.13u
X3599 VDD.t25 VSS.t1867 VDD.t24 VDD.t2 sg13_lv_pmos ad=0.19p pd=1.38u as=0 ps=0 w=1u l=1u
X3600 a_4070_19020# a_3800_19061# VSS.t468 VSS.t1270 sg13_lv_nmos ad=0.1428p pd=1.52u as=79.8f ps=0.8u w=0.42u l=0.5u
X3601 a_16666_12214# sg13cmos5l_nand2_1_13.A sg13cmos5l_nand2_1_13.Y VSS.t904 sg13_lv_nmos ad=0.1406p pd=1.12u as=0.2516p ps=2.16u w=0.74u l=0.13u
X3602 a_6640_9406# a_6383_9263# a_6802_9186# VSS.t2482 sg13_lv_nmos ad=0.1428p pd=1.52u as=37.8f ps=0.6u w=0.42u l=0.13u
X3603 a_20207_5773# a_19365_5423# a_20113_5773# VSS.t10 sg13_lv_nmos ad=0.12665p pd=1.145u as=0.1428p ps=1.52u w=0.42u l=0.13u
X3604 VSS.t222 sg13cmos5l_and2_1_5.X sg13cmos5l_a21oi_1_17.Y VSS.t317 sg13_lv_nmos ad=0.2516p pd=2.16u as=0.1406p ps=1.12u w=0.74u l=0.13u
X3605 a_16172_14448# sg13cmos5l_nand4_1_3.D VSS.t136 VSS.t439 sg13_lv_nmos ad=0.187p pd=1.78u as=0.14875p ps=1.16u w=0.55u l=0.13u
X3606 VDD.t783 sg13cmos5l_a21o_1_1.A2 a_8576_10901# VDD.t0 sg13_lv_pmos ad=0.2856p pd=2.36u as=0.1596p ps=1.22u w=0.84u l=0.13u
X3607 VDD.t859 a_17039_18335# a_17706_18556# VDD.t231 sg13_lv_pmos ad=0.2128p pd=1.5u as=0.3864p ps=2.93u w=1.12u l=0.13u
X3608 a_15900_16754# sg13cmos5l_nand4_1_7.B a_15798_16754# VSS.t414 sg13_lv_nmos ad=0.1406p pd=1.12u as=0.1406p ps=1.12u w=0.74u l=0.13u
X3609 a_17028_15552# a_17002_15457# VSS.t136 VSS.t135 sg13_lv_nmos ad=0.2516p pd=2.16u as=0.1626p ps=1.415u w=0.74u l=0.13u
X3610 sg13cmos5l_dfrbpq_1_24.Q a_7530_12972# VSS.t67 VSS.t149 sg13_lv_nmos ad=0.2516p pd=2.16u as=0.1406p ps=1.12u w=0.74u l=0.13u
X3611 VSS.t1971 VDD.t13 VSS.t1973 VSS.t1972 sg13_lv_nmos ad=79.8f pd=0.8u as=0 ps=0 w=0.42u l=1u
X3612 a_12631_5376# a_13191_5499# a_13102_5535# VDD.t5 sg13_lv_pmos ad=0.2048p pd=1.63u as=93.45f ps=0.865u w=0.42u l=0.13u
X3613 a_10771_9380# sg13cmos5l_o21ai_1_0.A2 VSS.t571 VSS.t2592 sg13_lv_nmos ad=0.1216p pd=1.02u as=0.15745p ps=1.175u w=0.64u l=0.13u
X3614 VDD.t5 a_22096_4870# a_22041_4965# VDD.t5 sg13_lv_pmos ad=1.96072p pd=12.69u as=93.45f ps=0.865u w=0.42u l=0.13u
X3615 sg13cmos5l_dfrbpq_1_35.Q a_20682_19020# VSS.t1099 VSS.t1098 sg13_lv_nmos ad=0.2516p pd=2.16u as=0.1406p ps=1.12u w=0.74u l=0.13u
X3616 VDD.t1676 sg13cmos5l_nand2_1_11.B sg13cmos5l_o21ai_1_9.A2 VDD.t19 sg13_lv_pmos ad=0.3808p pd=2.92u as=0.2128p ps=1.5u w=1.12u l=0.13u
X3617 VSS.t60 sg13cmos5l_dfrbpq_1_13.RESET_B a_6564_11898# VSS.t1195 sg13_lv_nmos ad=0.1626p pd=1.415u as=60.89999f ps=0.71u w=0.42u l=0.13u
X3618 VDD.t2277 a_12826_9154# a_12545_9376# VDD.t52 sg13_lv_pmos ad=0.1523p pd=1.38u as=0.34p ps=2.68u w=1u l=0.5u
X3619 VDD.t156 VSS.t2122 VDD.t417 VDD.t13 sg13_lv_pmos ad=0.34p pd=2.68u as=0 ps=0 w=1u l=1u
X3620 a_22096_8678# sg13cmos5l_buf_1_7.X VDD.t8 VDD.t8 sg13_lv_pmos ad=79.8f pd=0.8u as=1.79022p ps=11.585u w=0.42u l=0.13u
X3621 VDD.t941 sg13cmos5l_a22oi_1_0.A2 a_14061_8784# VDD.t8 sg13_lv_pmos ad=0.1918p pd=1.5u as=0.1596p ps=1.22u w=0.84u l=0.13u
X3622 VDD.t1175 a_14746_9912# a_14465_10214# VDD.t52 sg13_lv_pmos ad=0.1523p pd=1.38u as=0.34p ps=2.68u w=1u l=0.5u
X3623 sg13cmos5l_a21oi_1_2.Y sg13cmos5l_a21oi_1_2.B1 a_19829_3900# VDD.t13 sg13_lv_pmos ad=0.3808p pd=2.92u as=0.2128p ps=1.5u w=1.12u l=0.13u
X3624 sg13cmos5l_nand4_1_1.C a_15496_13760# VDD.t1703 VDD.t19 sg13_lv_pmos ad=0.42p pd=2.99u as=0.2114p ps=1.54u w=1.12u l=0.13u
X3625 VDD.t974 sg13cmos5l_nand4_1_18.D sg13cmos5l_a21oi_1_15.A2 VDD.t19 sg13_lv_pmos ad=0.3808p pd=2.92u as=0.2128p ps=1.5u w=1.12u l=0.13u
X3626 a_1294_9375# a_1409_9376# VSS.t918 VSS.t88 sg13_lv_nmos ad=0.1428p pd=1.52u as=0.1426p ps=1.16u w=0.42u l=0.5u
X3627 VSS.t400 sg13cmos5l_buf_1_30.A a_1192_19020# VSS.t697 sg13_lv_nmos ad=0.14875p pd=1.16u as=0.187p ps=1.78u w=0.55u l=0.13u
X3628 VSS.t307 a_16078_19287# sg13cmos5l_dfrbpq_1_33.D VSS.t305 sg13_lv_nmos ad=0.1426p pd=1.16u as=0.2516p ps=2.16u w=0.74u l=0.13u
X3629 VSS.t357 a_17338_18984# a_17057_19286# VSS.t356 sg13_lv_nmos ad=79.8f pd=0.8u as=0.1428p ps=1.52u w=0.42u l=0.5u
X3630 VDD.t265 VSS.t1726 VDD.t264 VDD.t83 sg13_lv_pmos ad=0.34p pd=2.68u as=0 ps=0 w=1u l=1u
X3631 a_12987_10318# sg13cmos5l_buf_8_2.A VSS.t86 VSS.t873 sg13_lv_nmos ad=0.1406p pd=1.12u as=0.1406p ps=1.12u w=0.74u l=0.13u
X3632 VDD.t1163 a_20974_6351# sg13cmos5l_buf_1_8.A VDD.t2 sg13_lv_pmos ad=0.2254p pd=1.53u as=0.4256p ps=3u w=1.12u l=0.13u
X3633 a_19829_8436# sg13cmos5l_inv_1_11.Y VDD.t1578 VDD.t8 sg13_lv_pmos ad=0.2128p pd=1.5u as=0.2128p ps=1.5u w=1.12u l=0.13u
X3634 VSS.t969 sg13cmos5l_o21ai_1_28.Y a_13400_15238# VSS.t1388 sg13_lv_nmos ad=79.8f pd=0.8u as=0.1428p ps=1.52u w=0.42u l=0.13u
X3635 sg13cmos5l_nand4_1_1.B sg13cmos5l_nor3_1_4.A VSS.t196 VSS.t66 sg13_lv_nmos ad=0.1694p pd=1.21u as=0.2618p ps=2.22u w=0.77u l=0.13u
X3636 VDD.t1226 VSS.t2135 VDD.t1225 VDD.t13 sg13_lv_pmos ad=0.19p pd=1.38u as=0 ps=0 w=1u l=1u
X3637 a_18756_17512# a_19275_17519# a_20015_17869# VSS.t225 sg13_lv_nmos ad=0.3473p pd=2.71u as=0.12665p ps=1.145u w=0.74u l=0.13u
X3638 sg13cmos5l_dfrbpq_1_18.Q a_11562_12508# VSS.t111 VSS.t110 sg13_lv_nmos ad=0.2516p pd=2.16u as=0.1406p ps=1.12u w=0.74u l=0.13u
X3639 a_20997_8447# sg13cmos5l_inv_1_2.A VDD.t8 VDD.t8 sg13_lv_pmos ad=0.4088p pd=2.97u as=1.79022p ps=11.585u w=1.12u l=0.13u
X3640 a_19173_19031# sg13cmos5l_inv_1_31.A VSS.t2302 VSS.t2303 sg13_lv_nmos ad=0.2516p pd=2.16u as=3.5562p ps=22.685u w=0.74u l=0.13u
X3641 VDD.t1031 sg13cmos5l_dfrbpq_1_30.D a_21911_16043# VDD.t16 sg13_lv_pmos ad=0.1428p pd=1.52u as=79.8f ps=0.8u w=0.42u l=0.13u
X3642 VDD.t996 a_21839_10309# a_22506_9948# VDD.t52 sg13_lv_pmos ad=0.2128p pd=1.5u as=0.3864p ps=2.93u w=1.12u l=0.13u
X3643 VSS.t1651 VDD.t2549 VSS.t1649 VSS.t1641 sg13_lv_nmos ad=79.8f pd=0.8u as=0 ps=0 w=0.42u l=1u
X3644 a_12058_16750# sg13cmos5l_nand2_1_9.Y VSS.t52 VSS.t1362 sg13_lv_nmos ad=0.1406p pd=1.12u as=0.2516p ps=2.16u w=0.74u l=0.13u
X3645 VDD.t316 VSS.t1642 VDD.t315 VDD.t16 sg13_lv_pmos ad=0.34p pd=2.68u as=0 ps=0 w=1u l=1u
X3646 VSS.t2002 VDD.t2423 VSS.t2002 VSS.t2003 sg13_lv_nmos ad=79.8f pd=0.8u as=0 ps=0 w=0.42u l=1u
X3647 VDD.t1011 a_20294_6166# a_20406_6230# VDD.t2 sg13_lv_pmos ad=0.2254p pd=1.53u as=0.34p ps=2.68u w=1u l=0.5u
X3648 VSS.t182 a_7120_13214# a_6769_13333# VSS.t149 sg13_lv_nmos ad=79.8f pd=0.8u as=0.1428p ps=1.52u w=0.42u l=0.13u
X3649 a_8015_11821# a_7173_11471# a_6756_11464# VDD.t0 sg13_lv_pmos ad=0.2048p pd=1.63u as=0.34p ps=2.68u w=1u l=0.13u
X3650 a_16188_9150# a_16319_9456# a_15607_9150# VDD.t52 sg13_lv_pmos ad=0.34p pd=2.68u as=0.2048p ps=1.63u w=1u l=0.13u
X3651 VSS.t1981 VDD.t2416 VSS.t1981 VSS.t1982 sg13_lv_nmos ad=79.8f pd=0.8u as=0 ps=0 w=0.42u l=1u
X3652 VSS.t5 a_7238_17508# a_7350_17532# VSS.t4 sg13_lv_nmos ad=0.1426p pd=1.16u as=0.1428p ps=1.52u w=0.42u l=0.5u
X3653 VDD.t1835 VSS.t1879 VDD.t1989 VDD.t2 sg13_lv_pmos ad=0.34p pd=2.68u as=0 ps=0 w=1u l=1u
X3654 a_20806_8861# sg13cmos5l_buf_1_7.X VSS.t15 VSS.t24 sg13_lv_nmos ad=37.8f pd=0.6u as=0.1701p ps=1.65u w=0.42u l=0.13u
X3655 sg13cmos5l_inv_1_31.A a_19035_16750# VDD.t913 VDD.t310 sg13_lv_pmos ad=0.2128p pd=1.5u as=0.2128p ps=1.5u w=1.12u l=0.13u
X3656 a_22658_16746# sg13cmos5l_dfrbpq_1_28.RESET_B.t7 VSS.t677 VSS.t1274 sg13_lv_nmos ad=60.89999f pd=0.71u as=0.1626p ps=1.415u w=0.42u l=0.13u
X3657 VDD.t1369 sg13cmos5l_dfrbpq_1_17.Q sg13cmos5l_nor3_1_2.C VDD.t8 sg13_lv_pmos ad=0.2128p pd=1.5u as=0.2128p ps=1.5u w=1.12u l=0.13u
X3658 VDD.t1752 sg13cmos5l_inv_1_24.A a_14536_14484# VDD.t19 sg13_lv_pmos ad=0.2114p pd=1.54u as=0.2856p ps=2.36u w=0.84u l=0.13u
X3659 VDD.t1006 a_18874_9912# a_18593_10214# VDD.t52 sg13_lv_pmos ad=0.1523p pd=1.38u as=0.34p ps=2.68u w=1u l=0.5u
X3660 a_8694_14020# sg13cmos5l_and4_1_1.A VDD.t1057 VDD.t19 sg13_lv_pmos ad=0.2128p pd=1.5u as=0.3808p ps=2.92u w=1.12u l=0.13u
X3661 a_17138_13730# sg13cmos5l_nand4_1_18.D VSS.t172 VSS.t128 sg13_lv_nmos ad=0.1406p pd=1.12u as=0.2516p ps=2.16u w=0.74u l=0.13u
X3662 VDD.t924 sg13cmos5l_dfrbpq_1_24.Q sg13cmos5l_nor4_1_1.D VDD.t19 sg13_lv_pmos ad=0.3808p pd=2.92u as=0.3808p ps=2.92u w=1.12u l=0.13u
X3663 a_9574_5837# sg13cmos5l_dfrbpq_1_13.RESET_B VSS.t293 VSS.t1198 sg13_lv_nmos ad=37.8f pd=0.6u as=0.1701p ps=1.65u w=0.42u l=0.13u
X3664 sg13cmos5l_buf_8_2.A.t0 a_12987_12214# VDD.t2365 VDD.t83 sg13_lv_pmos ad=0.2128p pd=1.5u as=0.2128p ps=1.5u w=1.12u l=0.13u
X3665 VSS.t1219 VDD.t2461 VSS.t542 VSS.t1899 sg13_lv_nmos ad=0.1428p pd=1.52u as=0 ps=0 w=0.42u l=1u
X3666 a_16631_8065# sg13cmos5l_buf_1_13.A VDD.t811 VDD.t8 sg13_lv_pmos ad=79.8f pd=0.8u as=0.36237p ps=2.605u w=0.42u l=0.13u
X3667 a_19919_7751# a_19077_7653# a_18660_7992# VDD.t8 sg13_lv_pmos ad=0.2048p pd=1.63u as=0.34p ps=2.68u w=1u l=0.13u
X3668 VDD.t1182 sg13cmos5l_dfrbpq_1_15.Q a_8859_8436# VDD.t8 sg13_lv_pmos ad=0.2144p pd=1.52u as=0.19p ps=1.38u w=1u l=0.13u
X3669 sg13cmos5l_a21oi_1_4.B1 a_14646_10766# VDD.t2018 VDD.t0 sg13_lv_pmos ad=0.4256p pd=3u as=0.2254p ps=1.53u w=1.12u l=0.13u
X3670 VSS.t2045 VDD.t2408 VSS.t1997 VSS.t2046 sg13_lv_nmos ad=79.8f pd=0.8u as=0 ps=0 w=0.42u l=1u
X3671 VSS.t232 a_16954_11424# a_16673_11726# VSS.t2413 sg13_lv_nmos ad=79.8f pd=0.8u as=0.1428p ps=1.52u w=0.42u l=0.5u
X3672 a_22522_3106# sg13cmos5l_dlygate4sd3_1_0.A VSS.t210 VSS.t2499 sg13_lv_nmos ad=0.1428p pd=1.52u as=79.8f ps=0.8u w=0.42u l=0.13u
X3673 a_16763_17508# sg13cmos5l_a21oi_1_25.A2 VDD.t1670 VDD.t310 sg13_lv_pmos ad=0.3808p pd=2.92u as=0.2128p ps=1.5u w=1.12u l=0.13u
X3674 VDD.t338 VSS.t1685 VDD.t337 VDD.t19 sg13_lv_pmos ad=0.19p pd=1.38u as=0 ps=0 w=1u l=1u
X3675 a_9348_5416# a_9867_5423# a_10607_5773# VSS.t95 sg13_lv_nmos ad=0.3473p pd=2.71u as=0.12665p ps=1.145u w=0.74u l=0.13u
X3676 a_20398_13239# a_20513_13238# VSS.t396 VSS.t162 sg13_lv_nmos ad=0.1428p pd=1.52u as=0.1426p ps=1.16u w=0.42u l=0.5u
X3677 a_5570_16746# sg13cmos5l_dfrbpq_1_24.RESET_B VSS.t176 VSS.t1142 sg13_lv_nmos ad=60.89999f pd=0.71u as=0.1626p ps=1.415u w=0.42u l=0.13u
X3678 VSS.t514 a_19630_15423# sg13cmos5l_inv_1_24.A VSS.t392 sg13_lv_nmos ad=0.1426p pd=1.16u as=0.2516p ps=2.16u w=0.74u l=0.13u
X3679 VDD.t55 VSS.t2182 VDD.t199 VDD.t13 sg13_lv_pmos ad=0.34p pd=2.68u as=0 ps=0 w=1u l=1u
X3680 VSS.t260 a_7726_8703# sg13cmos5l_nor3_1_2.A VSS.t2357 sg13_lv_nmos ad=0.1426p pd=1.16u as=0.2516p ps=2.16u w=0.74u l=0.13u
X3681 VSS.t596 sg13cmos5l_buf_1_13.X a_20388_10386# VSS.t601 sg13_lv_nmos ad=0.1626p pd=1.415u as=60.89999f ps=0.71u w=0.42u l=0.13u
X3682 VSS.t284 sg13cmos5l_nand2b_1_0.B a_13039_7294# VSS.t972 sg13_lv_nmos ad=0.14505p pd=1.15u as=0.1406p ps=1.12u w=0.74u l=0.13u
X3683 VDD.t2202 sg13cmos5l_nand3_1_0.A sg13cmos5l_o21ai_1_3.Y VDD.t8 sg13_lv_pmos ad=0.3808p pd=2.92u as=0.2128p ps=1.5u w=1.12u l=0.15u
X3684 a_16090_10702# sg13cmos5l_nand2b_1_0.B VSS.t120 VSS.t970 sg13_lv_nmos ad=0.1406p pd=1.12u as=0.2516p ps=2.16u w=0.74u l=0.13u
X3685 VSS.t1790 VDD.t2492 VSS.t1789 VSS.t1788 sg13_lv_nmos ad=0.1428p pd=1.52u as=0 ps=0 w=0.42u l=1u
X3686 a_19035_16750# sg13cmos5l_buf_8_2.A.t5 VDD.t1746 VDD.t310 sg13_lv_pmos ad=0.2128p pd=1.5u as=0.2128p ps=1.5u w=1.12u l=0.13u
X3687 VDD.t87 VSS.t344 VDD.t86 VDD.t83 sg13_lv_pmos ad=0.34p pd=2.68u as=0 ps=0 w=1u l=1u
X3688 a_6670_18447# a_6785_18448# VSS.t69 VSS.t1392 sg13_lv_nmos ad=0.1428p pd=1.52u as=0.1426p ps=1.16u w=0.42u l=0.5u
X3689 a_22262_16421# a_21084_16357# a_21866_16276# VSS.t951 sg13_lv_nmos ad=37.8f pd=0.6u as=0.1428p ps=1.52u w=0.42u l=0.13u
X3690 a_4714_14452# a_5157_14495# a_4454_14922# VSS.t491 sg13_lv_nmos ad=79.8f pd=0.8u as=0.1296p ps=1.52u w=0.42u l=0.13u
X3691 VDD.t1663 a_6958_16935# sg13cmos5l_o21ai_1_11.B1 VDD.t310 sg13_lv_pmos ad=0.2254p pd=1.53u as=0.4256p ps=3u w=1.12u l=0.13u
X3692 a_21063_16964# a_21215_17016# VSS.t674 VSS.t705 sg13_lv_nmos ad=0.2516p pd=2.16u as=4.4216p ps=27.885u w=0.74u l=0.13u
X3693 a_11674_12936# sg13cmos5l_dfrbpq_1_18.Q VSS.t159 VSS.t149 sg13_lv_nmos ad=0.1428p pd=1.52u as=79.8f ps=0.8u w=0.42u l=0.13u
X3694 a_14854_12236# sg13cmos5l_a21oi_1_4.A1 sg13cmos5l_nand2b_1_1.A_N VSS.t146 sg13_lv_nmos ad=0.1406p pd=1.12u as=0.2516p ps=2.16u w=0.74u l=0.13u
X3695 sg13cmos5l_buf_1_7.X a_18952_4688# VDD.t992 VDD.t5 sg13_lv_pmos ad=0.42p pd=2.99u as=0.2114p ps=1.54u w=1.12u l=0.13u
X3696 VSS.t2168 VDD.t2382 VSS.t2167 VSS.t2166 sg13_lv_nmos ad=0.1428p pd=1.52u as=0 ps=0 w=0.42u l=1u
X3697 a_9636_5837# a_9867_5423# a_9322_5380# VSS.t94 sg13_lv_nmos ad=0.2373p pd=1.97u as=79.8f ps=0.8u w=0.42u l=0.13u
X3698 VSS.t99 a_15404_6888# sg13cmos5l_buf_1_13.A VSS.t298 sg13_lv_nmos ad=0.14875p pd=1.16u as=0.2886p ps=2.26u w=0.74u l=0.13u
X3699 VDD.t964 sg13cmos5l_nand4_1_5.D sg13cmos5l_nand4_1_12.Y VDD.t310 sg13_lv_pmos ad=0.3808p pd=2.92u as=0.2128p ps=1.5u w=1.12u l=0.13u
X3700 VSS.t545 a_18094_9375# sg13cmos5l_dfrbpq_1_11.D VSS.t724 sg13_lv_nmos ad=0.1426p pd=1.16u as=0.2516p ps=2.16u w=0.74u l=0.13u
X3701 VDD.t13 VSS.t1966 VDD.t13 VDD.t13 sg13_lv_pmos ad=0.19p pd=1.38u as=0 ps=0 w=1u l=1u
X3702 a_4906_18988# a_5349_19031# a_4646_19458# VSS.t1170 sg13_lv_nmos ad=79.8f pd=0.8u as=0.1296p ps=1.52u w=0.42u l=0.13u
X3703 VDD.t1070 a_20026_15202# a_19745_15424# VDD.t16 sg13_lv_pmos ad=0.1523p pd=1.38u as=0.34p ps=2.68u w=1u l=0.5u
X3704 a_12938_5850# a_12631_5376# a_12844_5850# VSS.t280 sg13_lv_nmos ad=37.8f pd=0.6u as=0.1428p ps=1.52u w=0.42u l=0.13u
X3705 code7 a_4360_19808# VSS.t369 VSS.t574 sg13_lv_nmos ad=0.2886p pd=2.26u as=0.14875p ps=1.16u w=0.74u l=0.13u
X3706 a_7812_19445# a_8043_19031# a_7498_18988# VSS.t1165 sg13_lv_nmos ad=0.2373p pd=1.97u as=79.8f ps=0.8u w=0.42u l=0.13u
X3707 VSS.t1727 VDD.t2511 VSS.t1729 VSS.t1728 sg13_lv_nmos ad=79.8f pd=0.8u as=0 ps=0 w=0.42u l=1u
X3708 VSS.t312 a_1294_15423# sg13cmos5l_buf_1_29.A VSS.t621 sg13_lv_nmos ad=0.1426p pd=1.16u as=0.2516p ps=2.16u w=0.74u l=0.13u
X3709 sg13cmos5l_buf_8_2.A.t0 a_12987_12214# VDD.t1138 VDD.t83 sg13_lv_pmos ad=0.2128p pd=1.5u as=0.2128p ps=1.5u w=1.12u l=0.13u
X3710 VSS.t1660 VDD.t2540 VSS.t1658 VSS.t1671 sg13_lv_nmos ad=0.1428p pd=1.52u as=0 ps=0 w=0.42u l=1u
X3711 sg13cmos5l_dlygate4sd3_1_20.A a_22506_11460# VDD.t1948 VDD.t0 sg13_lv_pmos ad=0.3808p pd=2.92u as=0.2128p ps=1.5u w=1.12u l=0.13u
X3712 VSS.t1973 VDD.t2435 VSS.t1973 VSS.t1976 sg13_lv_nmos ad=0.1428p pd=1.52u as=0 ps=0 w=0.42u l=1u
X3713 VDD.t1839 a_12812_15960# sg13cmos5l_buf_1_47.X VDD.t16 sg13_lv_pmos ad=0.2114p pd=1.54u as=0.42p ps=2.99u w=1.12u l=0.13u
X3714 a_9322_5380# a_9765_5423# a_9705_5459# VDD.t5 sg13_lv_pmos ad=79.8f pd=0.8u as=63f ps=0.72u w=0.42u l=0.13u
X3715 VSS.t48 sg13cmos5l_o21ai_1_5.A2 sg13cmos5l_nor2_1_4.Y VSS.t397 sg13_lv_nmos ad=0.2516p pd=2.16u as=0.1406p ps=1.12u w=0.74u l=0.13u
X3716 sg13cmos5l_o21ai_1_11.Y sg13cmos5l_o21ai_1_11.B1 VDD.t1664 VDD.t16 sg13_lv_pmos ad=0.2128p pd=1.5u as=0.3808p ps=2.92u w=1.12u l=0.15u
X3717 a_16563_14832# sg13cmos5l_a21oi_1_20.A2 VSS.t136 VSS.t137 sg13_lv_nmos ad=0.1406p pd=1.12u as=0.2516p ps=2.16u w=0.74u l=0.13u
X3718 a_20580_14488# a_21099_14495# a_21839_14845# VSS.t394 sg13_lv_nmos ad=0.3473p pd=2.71u as=0.12665p ps=1.145u w=0.74u l=0.13u
X3719 a_21350_17508# a_21080_17549# VDD.t1897 VDD.t310 sg13_lv_pmos ad=0.34p pd=2.68u as=0.1523p ps=1.38u w=1u l=0.5u
X3720 VDD.t1420 sg13cmos5l_inv_1_5.A sg13cmos5l_inv_1_5.Y VDD.t5 sg13_lv_pmos ad=0.3808p pd=2.92u as=0.3808p ps=2.92u w=1.12u l=0.13u
X3721 VSS.t1707 VDD.t2524 VSS.t645 VSS.t1719 sg13_lv_nmos ad=79.8f pd=0.8u as=0 ps=0 w=0.42u l=1u
X3722 sg13cmos5l_dlygate4sd3_1_13.X a_17622_10766# VSS.t161 VSS.t555 sg13_lv_nmos ad=0.2516p pd=2.16u as=0.1426p ps=1.16u w=0.74u l=0.13u
X3723 VSS.t1973 VDD.t269 VSS.t1973 VSS.t1975 sg13_lv_nmos ad=79.8f pd=0.8u as=0 ps=0 w=0.42u l=1u
X3724 VDD.t1223 a_8122_8400# a_7841_8702# VDD.t8 sg13_lv_pmos ad=0.1523p pd=1.38u as=0.34p ps=2.68u w=1u l=0.5u
X3725 VDD.t270 a_10607_19847# a_10864_19990# VDD.t270 sg13_lv_pmos ad=2.69447p pd=17.64u as=79.8f ps=0.8u w=0.42u l=0.13u
X3726 a_16476_16754# sg13cmos5l_nand4_1_6.B a_16374_16754# VSS.t1348 sg13_lv_nmos ad=0.1406p pd=1.12u as=0.1406p ps=1.12u w=0.74u l=0.13u
X3727 a_13990_16421# sg13cmos5l_buf_1_45.X.t5 VSS.t204 VSS.t418 sg13_lv_nmos ad=37.8f pd=0.6u as=0.1701p ps=1.65u w=0.42u l=0.13u
X3728 VSS.t1795 VDD.t2501 VSS.t1794 VSS.t1793 sg13_lv_nmos ad=0.1428p pd=1.52u as=0 ps=0 w=0.42u l=1u
X3729 sg13cmos5l_nand2_1_2.Y sg13cmos5l_nand2b_1_0.B VDD.t1343 VDD.t0 sg13_lv_pmos ad=0.2128p pd=1.5u as=0.3808p ps=2.92u w=1.12u l=0.13u
X3730 VDD.t926 sg13cmos5l_buf_1_3.A a_19720_3176# VDD.t13 sg13_lv_pmos ad=0.2114p pd=1.54u as=0.2856p ps=2.36u w=0.84u l=0.13u
X3731 a_22126_7863# a_22241_7864# VSS.t37 VSS.t667 sg13_lv_nmos ad=0.1428p pd=1.52u as=0.1426p ps=1.16u w=0.42u l=0.5u
X3732 a_3975_16964# a_4127_17016# VSS.t674 VSS.t1494 sg13_lv_nmos ad=0.2516p pd=2.16u as=4.4216p ps=27.885u w=0.74u l=0.13u
X3733 VSS.t1742 VDD.t2508 VSS.t1744 VSS.t1743 sg13_lv_nmos ad=79.8f pd=0.8u as=0 ps=0 w=0.42u l=1u
X3734 VDD.t363 sg13cmos5l_buf_1_7.X a_20554_11428# VDD.t0 sg13_lv_pmos ad=0.1563p pd=1.22u as=0.147p ps=1.54u w=0.42u l=0.13u
X3735 VDD.t1173 sg13cmos5l_buf_1_0.A sg13cmos5l_inv_1_11.Y VDD.t8 sg13_lv_pmos ad=0.3808p pd=2.92u as=0.3808p ps=2.92u w=1.12u l=0.13u
X3736 a_20294_8874# sg13cmos5l_dfrbpq_1_6.D VDD.t2113 VDD.t8 sg13_lv_pmos ad=79.8f pd=0.8u as=0.1428p ps=1.52u w=0.42u l=0.13u
X3737 sg13cmos5l_buf_1_42.A a_17608_13760# VDD.t680 VDD.t19 sg13_lv_pmos ad=0.42p pd=2.99u as=0.2114p ps=1.54u w=1.12u l=0.13u
X3738 a_12022_8814# sg13cmos5l_or2_1_1.X VSS.t569 VSS.t749 sg13_lv_nmos ad=0.1406p pd=1.12u as=0.1406p ps=1.12u w=0.74u l=0.15u
X3739 a_5999_14845# a_5157_14495# a_4740_14488# VDD.t19 sg13_lv_pmos ad=0.2048p pd=1.63u as=0.34p ps=2.68u w=1u l=0.13u
X3740 VSS.t239 sg13cmos5l_inv_1_24.A a_14536_14484# VSS.t2319 sg13_lv_nmos ad=0.14875p pd=1.16u as=0.187p ps=1.78u w=0.55u l=0.13u
X3741 a_22096_14726# a_21839_14845# a_22258_14922# VSS.t394 sg13_lv_nmos ad=0.1428p pd=1.52u as=37.8f ps=0.6u w=0.42u l=0.13u
X3742 VDD.t1391 VSS.t2127 VDD.t1398 VDD.t13 sg13_lv_pmos ad=0.34p pd=2.68u as=0 ps=0 w=1u l=1u
X3743 VSS.t2188 VDD.t2378 VSS.t2187 VSS.t2186 sg13_lv_nmos ad=0.1428p pd=1.52u as=0 ps=0 w=0.42u l=1u
X3744 a_14052_17933# a_14283_17519# a_13738_17476# VSS.t627 sg13_lv_nmos ad=0.2373p pd=1.97u as=79.8f ps=0.8u w=0.42u l=0.13u
X3745 a_19827_7272# sg13cmos5l_a21oi_1_5.A2 VSS.t26 VSS.t1182 sg13_lv_nmos ad=0.1406p pd=1.12u as=0.2516p ps=2.16u w=0.74u l=0.13u
X3746 VDD.t231 a_8783_19381# a_9040_19262# VDD.t231 sg13_lv_pmos ad=1.54512p pd=9.865u as=79.8f ps=0.8u w=0.42u l=0.13u
X3747 a_9292_15996# sg13cmos5l_nand2_1_11.B a_9190_15996# VDD.t16 sg13_lv_pmos ad=0.2925p pd=1.585u as=0.19p ps=1.38u w=1u l=0.13u
X3748 a_11278_13239# a_11393_13238# VSS.t159 VSS.t149 sg13_lv_nmos ad=0.1428p pd=1.52u as=0.1426p ps=1.16u w=0.42u l=0.5u
X3749 a_13478_17946# sg13cmos5l_dlygate4sd3_1_97.X VDD.t1088 VDD.t310 sg13_lv_pmos ad=79.8f pd=0.8u as=0.1428p ps=1.52u w=0.42u l=0.13u
X3750 a_15280_16238# sg13cmos5l_buf_1_45.X.t4 VDD.t16 VDD.t16 sg13_lv_pmos ad=79.8f pd=0.8u as=2.07625p ps=13.51u w=0.42u l=0.13u
X3751 a_6835_13916# sg13cmos5l_a21o_1_2.B1 VSS.t182 VSS.t66 sg13_lv_nmos ad=0.1216p pd=1.02u as=0.15745p ps=1.175u w=0.64u l=0.13u
X3752 VDD.t810 sg13cmos5l_nor4_1_1.D a_9018_15532# VDD.t16 sg13_lv_pmos ad=0.2891p pd=1.695u as=0.1428p ps=1.375u w=1.12u l=0.13u
X3753 VDD.t258 VSS.t779 VDD.t257 VDD.t8 sg13_lv_pmos ad=0.34p pd=2.68u as=0 ps=0 w=1u l=1u
X3754 sg13cmos5l_dfrbpq_1_28.D sg13cmos5l_a21oi_1_18.B1 a_17621_12972# VDD.t83 sg13_lv_pmos ad=0.3808p pd=2.92u as=0.2128p ps=1.5u w=1.12u l=0.13u
X3755 VDD.t321 VSS.t1630 VDD.t2020 VDD.t231 sg13_lv_pmos ad=0.19p pd=1.38u as=0 ps=0 w=1u l=1u
X3756 VSS.t1805 VDD.t2498 VSS.t1805 VSS.t1806 sg13_lv_nmos ad=0.1428p pd=1.52u as=0 ps=0 w=0.42u l=1u
X3757 a_5829_7653# sg13cmos5l_dfrbpq_1_15.CLK VSS.t253 VSS.t2552 sg13_lv_nmos ad=0.2516p pd=2.16u as=4.7455p ps=30.71u w=0.74u l=0.13u
X3758 a_22262_18271# a_21084_18222# a_21866_18416# VSS.t140 sg13_lv_nmos ad=37.8f pd=0.6u as=0.1428p ps=1.52u w=0.42u l=0.13u
X3759 a_5318_13410# sg13cmos5l_dfrbpq_1_24.D VDD.t1586 VDD.t83 sg13_lv_pmos ad=79.8f pd=0.8u as=0.1428p ps=1.52u w=0.42u l=0.13u
X3760 a_3900_16357# a_4031_15967# a_3319_15960# VDD.t16 sg13_lv_pmos ad=0.34p pd=2.68u as=0.2048p ps=1.63u w=1u l=0.13u
X3761 VSS.t825 a_12614_6166# a_12726_6230# VSS.t934 sg13_lv_nmos ad=0.1426p pd=1.16u as=0.1428p ps=1.52u w=0.42u l=0.5u
X3762 VSS.t585 sg13cmos5l_dfrbpq_1_24.RESET_B a_4548_14922# VSS.t1136 sg13_lv_nmos ad=0.1626p pd=1.415u as=60.89999f ps=0.71u w=0.42u l=0.13u
X3763 VDD.t340 VSS.t1685 VDD.t339 VDD.t83 sg13_lv_pmos ad=0.19p pd=1.38u as=0 ps=0 w=1u l=1u
X3764 a_10895_12287# a_10053_12189# a_9636_12528# VDD.t83 sg13_lv_pmos ad=0.2048p pd=1.63u as=0.34p ps=2.68u w=1u l=0.13u
X3765 a_14532_19783# a_14244_20088# a_14470_19783# VSS.t806 sg13_lv_nmos ad=0.1428p pd=1.52u as=37.8f ps=0.6u w=0.42u l=0.13u
X3766 VSS.t380 sg13cmos5l_nand2_1_12.Y a_12632_17549# VSS.t665 sg13_lv_nmos ad=79.8f pd=0.8u as=0.1428p ps=1.52u w=0.42u l=0.13u
X3767 sg13cmos5l_buf_1_2.A a_20406_6230# VSS.t11 VSS.t258 sg13_lv_nmos ad=0.2516p pd=2.16u as=0.1426p ps=1.16u w=0.74u l=0.13u
X3768 a_5412_9199# a_5124_9504# a_5350_9199# VSS.t88 sg13_lv_nmos ad=0.1428p pd=1.52u as=37.8f ps=0.6u w=0.42u l=0.13u
X3769 a_17385_15625# a_17028_15552# VDD.t864 VDD.t16 sg13_lv_pmos ad=63f pd=0.72u as=0.1563p ps=1.22u w=0.42u l=0.13u
X3770 a_15014_19020# a_14744_19061# VDD.t2275 VDD.t231 sg13_lv_pmos ad=0.34p pd=2.68u as=0.1523p ps=1.38u w=1u l=0.5u
X3771 a_18682_16714# sg13cmos5l_dfrbpq_1_30.Q VDD.t1019 VDD.t310 sg13_lv_pmos ad=0.1428p pd=1.52u as=0.1523p ps=1.38u w=0.42u l=0.13u
X3772 sg13cmos5l_dfrbpq_1_6.D a_19542_9254# VDD.t1937 VDD.t52 sg13_lv_pmos ad=0.4256p pd=3u as=0.2254p ps=1.53u w=1.12u l=0.13u
X3773 VDD.t259 VSS.t1884 VDD.t1832 VDD.t2 sg13_lv_pmos ad=0.34p pd=2.68u as=0 ps=0 w=1u l=1u
X3774 a_20294_12210# a_21099_12332# a_20554_12433# VDD.t83 sg13_lv_pmos ad=0.1428p pd=1.52u as=79.8f ps=0.8u w=0.42u l=0.13u
X3775 a_12597_11722# sg13cmos5l_nand2_1_0.A VDD.t1086 VDD.t0 sg13_lv_pmos ad=0.2856p pd=2.36u as=0.2198p ps=1.53u w=0.84u l=0.13u
X3776 VSS.t7 a_19120_11702# a_18769_11821# VSS.t1046 sg13_lv_nmos ad=79.8f pd=0.8u as=0.1428p ps=1.52u w=0.42u l=0.13u
X3777 VSS.t1931 VDD.t2453 VSS.t1933 VSS.t1932 sg13_lv_nmos ad=79.8f pd=0.8u as=0 ps=0 w=0.42u l=1u
X3778 VSS.t97 sg13cmos5l_o21ai_1_1.Y a_14902_8814# VSS.t96 sg13_lv_nmos ad=0.1406p pd=1.12u as=0.2516p ps=2.16u w=0.74u l=0.15u
X3779 VSS.t663 a_7310_12400# sg13cmos5l_dfrbpq_1_45.D VSS.t1226 sg13_lv_nmos ad=0.148p pd=1.14u as=0.4033p ps=2.57u w=0.74u l=0.13u
X3780 VDD.t1965 a_21754_5376# a_21473_5678# VDD.t5 sg13_lv_pmos ad=0.1523p pd=1.38u as=0.34p ps=2.68u w=1u l=0.5u
X3781 VSS.t15 sg13cmos5l_a21oi_1_2.B1 sg13cmos5l_dlygate4sd3_1_22.A VSS.t896 sg13_lv_nmos ad=0.2516p pd=2.16u as=0.1406p ps=1.12u w=0.74u l=0.13u
X3782 sg13cmos5l_dfrbpq_1_40.Q a_18762_20068# VSS.t931 VSS.t1032 sg13_lv_nmos ad=0.2516p pd=2.16u as=0.1406p ps=1.12u w=0.74u l=0.13u
X3783 a_20110_19959# a_20225_19960# VSS.t1099 VSS.t1055 sg13_lv_nmos ad=0.1428p pd=1.52u as=0.1426p ps=1.16u w=0.42u l=0.5u
X3784 a_11770_11830# sg13cmos5l_nand2_1_18.A sg13cmos5l_buf_1_21.A VSS.t151 sg13_lv_nmos ad=0.1406p pd=1.12u as=0.2516p ps=2.16u w=0.74u l=0.13u
X3785 VSS.t1727 VDD.t2522 VSS.t1729 VSS.t1728 sg13_lv_nmos ad=79.8f pd=0.8u as=0 ps=0 w=0.42u l=1u
X3786 a_21466_7642# sg13cmos5l_a21oi_1_2.Y VDD.t782 VDD.t8 sg13_lv_pmos ad=0.1428p pd=1.52u as=0.1523p ps=1.38u w=0.42u l=0.13u
X3787 a_20974_16434# a_21215_15967# a_20503_15960# VSS.t704 sg13_lv_nmos ad=0.1428p pd=1.52u as=0.12665p ps=1.145u w=0.42u l=0.13u
X3788 sg13cmos5l_dlygate4sd3_1_4.A a_20874_5412# VSS.t479 VSS.t10 sg13_lv_nmos ad=0.2516p pd=2.16u as=0.1406p ps=1.12u w=0.74u l=0.13u
X3789 VDD.t1191 a_16556_15960# sg13cmos5l_nand4_1_5.D VDD.t16 sg13_lv_pmos ad=0.2114p pd=1.54u as=0.42p ps=2.99u w=1.12u l=0.13u
X3790 VSS.t72 a_20494_15423# sg13cmos5l_dfrbpq_1_29.D VSS.t567 sg13_lv_nmos ad=0.1426p pd=1.16u as=0.2516p ps=2.16u w=0.74u l=0.13u
X3791 VDD.t19 a_22096_14726# a_22041_14607# VDD.t19 sg13_lv_pmos ad=2.1916p pd=14.26u as=93.45f ps=0.865u w=0.42u l=0.13u
X3792 VDD.t159 VSS.t1835 VDD.t158 VDD.t52 sg13_lv_pmos ad=0.19p pd=1.38u as=0 ps=0 w=1u l=1u
X3793 a_12420_19024# a_12394_18988# VDD.t894 VDD.t231 sg13_lv_pmos ad=0.34p pd=2.68u as=0.36237p ps=2.605u w=1u l=0.13u
X3794 VDD.t1593 sg13cmos5l_buf_1_42.A sg13cmos5l_nand4_1_17.Y VDD.t16 sg13_lv_pmos ad=0.3808p pd=2.92u as=0.2128p ps=1.5u w=1.12u l=0.13u
X3795 VSS.t1966 VDD.t2438 VSS.t1966 VSS.t1968 sg13_lv_nmos ad=0.1428p pd=1.52u as=0 ps=0 w=0.42u l=1u
X3796 VSS.t1997 VDD.t2407 VSS.t1997 VSS.t2048 sg13_lv_nmos ad=79.8f pd=0.8u as=0 ps=0 w=0.42u l=1u
X3797 sg13cmos5l_o21ai_1_23.B1 a_15690_15996# VDD.t854 VDD.t16 sg13_lv_pmos ad=0.3808p pd=2.92u as=0.2128p ps=1.5u w=1.12u l=0.13u
X3798 sg13cmos5l_dlygate4sd3_1_20.A a_22506_11460# VSS.t887 VSS.t16 sg13_lv_nmos ad=0.2516p pd=2.16u as=0.1406p ps=1.12u w=0.74u l=0.13u
X3799 a_7078_14044# sg13cmos5l_mux2_1_0.A1 VDD.t698 VDD.t19 sg13_lv_pmos ad=0.34p pd=2.68u as=0.19p ps=1.38u w=1u l=0.13u
X3800 a_13420_9484# a_13198_9228# VDD.t1333 VDD.t52 sg13_lv_pmos ad=0.1176p pd=1.33u as=0.2618p ps=1.63u w=1.12u l=0.13u
X3801 VSS.t204 a_13294_16935# sg13cmos5l_nand2_1_12.A VSS.t1224 sg13_lv_nmos ad=0.1426p pd=1.16u as=0.2516p ps=2.16u w=0.74u l=0.13u
X3802 VDD.t2 a_16240_6382# a_16185_6477# VDD.t2 sg13_lv_pmos ad=2.1916p pd=14.26u as=93.45f ps=0.865u w=0.42u l=0.13u
X3803 VSS.t1742 VDD.t2519 VSS.t1744 VSS.t1743 sg13_lv_nmos ad=79.8f pd=0.8u as=0 ps=0 w=0.42u l=1u
X3804 VSS.t83 sg13cmos5l_dlygate4sd3_1_22.A a_19160_9190# VSS.t543 sg13_lv_nmos ad=79.8f pd=0.8u as=0.1428p ps=1.52u w=0.42u l=0.13u
X3805 VDD.t892 sg13cmos5l_buf_1_45.X.t13 a_16810_19993# VDD.t270 sg13_lv_pmos ad=0.1563p pd=1.22u as=0.147p ps=1.54u w=0.42u l=0.13u
X3806 VDD.t1683 sg13cmos5l_nand4_1_1.A sg13cmos5l_a21oi_1_6.A2 VDD.t19 sg13_lv_pmos ad=0.3808p pd=2.92u as=0.2128p ps=1.5u w=1.12u l=0.13u
X3807 VDD.t512 VSS.t2152 VDD.t572 VDD.t13 sg13_lv_pmos ad=0.34p pd=2.68u as=0 ps=0 w=1u l=1u
X3808 VSS.t122 sg13cmos5l_buf_1_5.A a_19336_3176# VSS.t889 sg13_lv_nmos ad=0.14875p pd=1.16u as=0.187p ps=1.78u w=0.55u l=0.13u
X3809 a_16668_7290# sg13cmos5l_nand3_1_0.A sg13cmos5l_nand3_1_0.Y VSS.t2451 sg13_lv_nmos ad=0.1406p pd=1.12u as=0.2516p ps=2.16u w=0.74u l=0.13u
X3810 VSS.t99 sg13cmos5l_a21oi_1_9.A2 sg13cmos5l_o21ai_1_4.A1 VSS.t2334 sg13_lv_nmos ad=0.2516p pd=2.16u as=0.2516p ps=2.16u w=0.74u l=0.13u
X3811 VDD.t12 VSS.t1869 VDD.t11 VDD.t2 sg13_lv_pmos ad=0.34p pd=2.68u as=0 ps=0 w=1u l=1u
X3812 VDD.t8 a_6928_7894# a_6873_7989# VDD.t8 sg13_lv_pmos ad=1.8716p pd=12.115u as=93.45f ps=0.865u w=0.42u l=0.13u
X3813 a_1690_19738# comp VSS.t853 VSS.t852 sg13_lv_nmos ad=0.1428p pd=1.52u as=79.8f ps=0.8u w=0.42u l=0.13u
X3814 VSS.t1130 sg13cmos5l_nand4_1_18.B sg13cmos5l_o21ai_1_7.A2 VSS.t2282 sg13_lv_nmos ad=0.2516p pd=2.16u as=0.1406p ps=1.12u w=0.74u l=0.13u
X3815 VDD.t1296 a_20398_13239# sg13cmos5l_dlygate4sd3_1_76.X VDD.t83 sg13_lv_pmos ad=0.2254p pd=1.53u as=0.4256p ps=3u w=1.12u l=0.13u
X3816 a_17510_10702# a_17240_10702# VSS.t174 VSS.t2457 sg13_lv_nmos ad=0.1428p pd=1.52u as=79.8f ps=0.8u w=0.42u l=0.5u
X3817 VDD.t414 VSS.t2112 VDD.t416 VDD.t13 sg13_lv_pmos ad=0.34p pd=2.68u as=0 ps=0 w=1u l=1u
X3818 VSS.t2173 VDD.t2381 VSS.t2172 VSS.t2171 sg13_lv_nmos ad=0.1428p pd=1.52u as=0 ps=0 w=0.42u l=1u
X3819 VSS.t1698 VDD.t2532 VSS.t1697 VSS.t1696 sg13_lv_nmos ad=0.1428p pd=1.52u as=0 ps=0 w=0.42u l=1u
X3820 VDD.t2055 sg13cmos5l_a21oi_1_8.A2 a_8021_5412# VDD.t5 sg13_lv_pmos ad=0.2128p pd=1.5u as=0.3808p ps=2.92u w=1.12u l=0.13u
X3821 VDD.t218 VSS.t781 VDD.t192 VDD.t0 sg13_lv_pmos ad=0.19p pd=1.38u as=0 ps=0 w=1u l=1u
X3822 VDD.t1158 a_8879_10309# a_9546_9948# VDD.t52 sg13_lv_pmos ad=0.2128p pd=1.5u as=0.3864p ps=2.93u w=1.12u l=0.13u
X3823 a_14724_6480# a_15243_6284# a_15983_6239# VSS.t2232 sg13_lv_nmos ad=0.3473p pd=2.71u as=0.12665p ps=1.145u w=0.74u l=0.13u
X3824 a_22042_15202# sg13cmos5l_dfrbpq_1_27.Q VDD.t725 VDD.t16 sg13_lv_pmos ad=0.1428p pd=1.52u as=0.1523p ps=1.38u w=0.42u l=0.13u
X3825 VSS.t1963 VDD.t2440 VSS.t1964 VSS.t1961 sg13_lv_nmos ad=79.8f pd=0.8u as=0 ps=0 w=0.42u l=1u
X3826 sg13cmos5l_nand3_1_1.Y sg13cmos5l_inv_1_8.A VDD.t759 VDD.t0 sg13_lv_pmos ad=0.3808p pd=2.92u as=0.2128p ps=1.5u w=1.12u l=0.13u
X3827 a_13566_8828# sg13cmos5l_a22oi_1_0.A2 VSS.t441 VSS.t485 sg13_lv_nmos ad=96.2f pd=1u as=0.2516p ps=2.16u w=0.74u l=0.13u
X3828 sg13cmos5l_nor3_1_7.Y sg13cmos5l_nand2_1_2.Y VSS.t222 VSS.t430 sg13_lv_nmos ad=0.2618p pd=2.22u as=0.1463p ps=1.15u w=0.77u l=0.13u
X3829 VDD.t452 VSS.t291 VDD.t454 VDD.t5 sg13_lv_pmos ad=0.19p pd=1.38u as=0 ps=0 w=1u l=1u
X3830 sg13cmos5l_nor2_1_6.Y sg13cmos5l_nor3_1_6.Y a_4298_15532# VDD.t16 sg13_lv_pmos ad=0.3808p pd=2.92u as=0.1176p ps=1.33u w=1.12u l=0.13u
X3831 a_12886_15230# sg13cmos5l_o21ai_1_23.A2 VSS.t79 VSS.t389 sg13_lv_nmos ad=0.1406p pd=1.12u as=0.1406p ps=1.12u w=0.74u l=0.15u
X3832 a_20806_14909# sg13cmos5l_dfrbpq_1_28.RESET_B.t6 VSS.t72 VSS.t870 sg13_lv_nmos ad=37.8f pd=0.6u as=0.1701p ps=1.65u w=0.42u l=0.13u
X3833 VDD.t407 VSS.t1731 VDD.t411 VDD.t83 sg13_lv_pmos ad=0.34p pd=2.68u as=0 ps=0 w=1u l=1u
X3834 a_6730_11428# a_7173_11471# a_6470_11898# VSS.t0 sg13_lv_nmos ad=79.8f pd=0.8u as=0.1296p ps=1.52u w=0.42u l=0.13u
X3835 sg13cmos5l_and2_1_5.X a_15405_11808# VSS.t222 VSS.t296 sg13_lv_nmos ad=0.2516p pd=2.16u as=0.1331p ps=1.12u w=0.74u l=0.13u
X3836 VSS.t759 sg13cmos5l_nor4_1_0.C sg13cmos5l_nor4_1_0.Y VSS.t2217 sg13_lv_nmos ad=0.1406p pd=1.12u as=0.1406p ps=1.12u w=0.74u l=0.13u
X3837 a_5412_7992# a_5931_7796# a_6671_7751# VSS.t748 sg13_lv_nmos ad=0.3473p pd=2.71u as=0.12665p ps=1.145u w=0.74u l=0.13u
X3838 VDD.t369 sg13cmos5l_buf_1_7.X a_18922_5380# VDD.t5 sg13_lv_pmos ad=0.1563p pd=1.22u as=0.147p ps=1.54u w=0.42u l=0.13u
X3839 VDD.t857 a_13862_6166# a_13974_6230# VDD.t2 sg13_lv_pmos ad=0.2254p pd=1.53u as=0.34p ps=2.68u w=1u l=0.5u
X3840 VSS.t918 sg13cmos5l_buf_1_17.A a_1192_8436# VSS.t88 sg13_lv_nmos ad=0.14875p pd=1.16u as=0.187p ps=1.78u w=0.55u l=0.13u
X3841 a_5829_7653# sg13cmos5l_dfrbpq_1_15.CLK VDD.t8 VDD.t8 sg13_lv_pmos ad=0.4088p pd=2.97u as=1.8716p ps=12.115u w=1.12u l=0.13u
X3842 VSS.t1130 a_8218_19738# a_7937_19960# VSS.t2532 sg13_lv_nmos ad=79.8f pd=0.8u as=0.1428p ps=1.52u w=0.42u l=0.5u
X3843 a_20384_16921# a_20503_16710# VDD.t1454 VDD.t310 sg13_lv_pmos ad=0.3864p pd=2.93u as=0.2128p ps=1.5u w=1.12u l=0.13u
X3844 VSS.t1973 VDD.t300 VSS.t1973 VSS.t1977 sg13_lv_nmos ad=79.8f pd=0.8u as=0 ps=0 w=0.42u l=1u
X3845 a_22041_14037# a_21099_13844# a_21839_13799# VDD.t19 sg13_lv_pmos ad=93.45f pd=0.865u as=0.2048p ps=1.63u w=0.42u l=0.13u
X3846 VSS.t5 a_7498_18226# sg13cmos5l_dfrbpq_1_19.CLK VSS.t2272 sg13_lv_nmos ad=0.1406p pd=1.12u as=0.1406p ps=1.12u w=0.74u l=0.13u
X3847 a_10607_5773# a_9765_5423# a_10513_5773# VSS.t771 sg13_lv_nmos ad=0.12665p pd=1.145u as=0.1428p ps=1.52u w=0.42u l=0.13u
X3848 VSS.t1916 VDD.t2456 VSS.t1918 VSS.t1917 sg13_lv_nmos ad=79.8f pd=0.8u as=0 ps=0 w=0.42u l=1u
X3849 VSS.t1099 a_20272_19262# a_19921_19381# VSS.t1098 sg13_lv_nmos ad=79.8f pd=0.8u as=0.1428p ps=1.52u w=0.42u l=0.13u
X3850 VSS.t230 VDD.t2541 VSS.t1658 VSS.t1670 sg13_lv_nmos ad=79.8f pd=0.8u as=0 ps=0 w=0.42u l=1u
X3851 VDD.t356 VSS.t2097 VDD.t355 VDD.t13 sg13_lv_pmos ad=0.34p pd=2.68u as=0 ps=0 w=1u l=1u
X3852 a_21911_18649# sg13cmos5l_a21oi_1_14.Y a_22658_18258# VSS.t140 sg13_lv_nmos ad=0.1428p pd=1.52u as=60.89999f ps=0.71u w=0.42u l=0.13u
X3853 a_20398_13239# a_20513_13238# VDD.t1296 VDD.t83 sg13_lv_pmos ad=0.34p pd=2.68u as=0.2254p ps=1.53u w=1u l=0.5u
X3854 VDD.t635 VSS.t1746 VDD.t1385 VDD.t83 sg13_lv_pmos ad=0.34p pd=2.68u as=0 ps=0 w=1u l=1u
X3855 a_7173_11471# sg13cmos5l_dfrbpq_1_15.CLK VDD.t0 VDD.t0 sg13_lv_pmos ad=0.4088p pd=2.97u as=2.1916p ps=14.26u w=1.12u l=0.13u
X3856 a_4366_18573# a_4108_18258# VDD.t231 VDD.t231 sg13_lv_pmos ad=93.45f pd=0.865u as=1.54512p ps=9.865u w=0.42u l=0.13u
X3857 a_12812_15960# sg13cmos5l_nand3_1_2.Y VSS.t52 VSS.t1556 sg13_lv_nmos ad=0.187p pd=1.78u as=0.14875p ps=1.16u w=0.55u l=0.13u
X3858 sg13cmos5l_nand3_1_4.Y sg13cmos5l_dfrbpq_1_15.Q VDD.t1184 VDD.t8 sg13_lv_pmos ad=0.3808p pd=2.92u as=0.2128p ps=1.5u w=1.12u l=0.13u
X3859 VSS.t81 sg13cmos5l_buf_1_13.X a_17124_8874# VSS.t597 sg13_lv_nmos ad=0.1626p pd=1.415u as=60.89999f ps=0.71u w=0.42u l=0.13u
X3860 a_9466_18226# sg13cmos5l_o21ai_1_15.Y VDD.t670 VDD.t231 sg13_lv_pmos ad=0.1428p pd=1.52u as=0.1523p ps=1.38u w=0.42u l=0.13u
X3861 VSS.t1646 VDD.t2547 VSS.t1645 VSS.t227 sg13_lv_nmos ad=0.1428p pd=1.52u as=0 ps=0 w=0.42u l=1u
X3862 a_9610_12433# a_10053_12189# a_9350_12210# VSS.t155 sg13_lv_nmos ad=79.8f pd=0.8u as=0.1296p ps=1.52u w=0.42u l=0.13u
X3863 a_15488_9361# a_15607_9150# VDD.t1264 VDD.t52 sg13_lv_pmos ad=0.3864p pd=2.93u as=0.2128p ps=1.5u w=1.12u l=0.13u
X3864 sg13cmos5l_dlygate4sd3_1_55.X a_11670_19044# VDD.t1653 VDD.t231 sg13_lv_pmos ad=0.4256p pd=3u as=0.2254p ps=1.53u w=1.12u l=0.13u
X3865 a_20272_19262# a_20015_19381# a_20434_19458# VSS.t1098 sg13_lv_nmos ad=0.1428p pd=1.52u as=37.8f ps=0.6u w=0.42u l=0.13u
X3866 a_6564_11898# sg13cmos5l_dfrbpq_1_45.D a_6470_11898# VSS.t664 sg13_lv_nmos ad=60.89999f pd=0.71u as=0.1428p ps=1.52u w=0.42u l=0.13u
X3867 VDD.t1534 a_21838_19959# sg13cmos5l_buf_1_25.A VDD.t270 sg13_lv_pmos ad=0.2254p pd=1.53u as=0.4256p ps=3u w=1.12u l=0.13u
X3868 a_3296_16921# a_3415_16710# VDD.t874 VDD.t310 sg13_lv_pmos ad=0.3864p pd=2.93u as=0.2128p ps=1.5u w=1.12u l=0.13u
X3869 VDD.t1373 a_11278_13239# sg13cmos5l_buf_1_22.A VDD.t83 sg13_lv_pmos ad=0.2254p pd=1.53u as=0.4256p ps=3u w=1.12u l=0.13u
X3870 VDD.t1437 sg13cmos5l_dlygate4sd3_1_33.X a_5416_9948# VDD.t52 sg13_lv_pmos ad=0.2114p pd=1.54u as=0.2856p ps=2.36u w=0.84u l=0.13u
X3871 a_18286_16935# a_18401_16936# VDD.t1783 VDD.t310 sg13_lv_pmos ad=0.34p pd=2.68u as=0.2254p ps=1.53u w=1u l=0.5u
X3872 a_20974_16746# a_21215_17016# a_20503_16710# VSS.t704 sg13_lv_nmos ad=0.1428p pd=1.52u as=0.12665p ps=1.145u w=0.42u l=0.13u
X3873 VDD.t1001 sg13cmos5l_nor3_1_2.B a_9500_8416# VDD.t8 sg13_lv_pmos ad=0.3808p pd=2.92u as=0.2128p ps=1.5u w=1.12u l=0.15u
X3874 VSS.t1498 sg13cmos5l_nor3_1_6.Y sg13cmos5l_nor2_1_6.Y VSS.t1497 sg13_lv_nmos ad=0.2516p pd=2.16u as=0.1406p ps=1.12u w=0.74u l=0.13u
X3875 VSS.t1966 VDD.t13 VSS.t1966 VSS.t1969 sg13_lv_nmos ad=79.8f pd=0.8u as=0 ps=0 w=0.42u l=1u
X3876 a_9260_11424# sg13cmos5l_buf_1_65.A VDD.t1904 VDD.t0 sg13_lv_pmos ad=0.2856p pd=2.36u as=0.2114p ps=1.54u w=0.84u l=0.13u
X3877 VDD.t154 VSS.t2137 VDD.t219 VDD.t13 sg13_lv_pmos ad=0.34p pd=2.68u as=0 ps=0 w=1u l=1u
X3878 VSS.t1665 VDD.t2543 VSS.t1498 VSS.t1666 sg13_lv_nmos ad=79.8f pd=0.8u as=0 ps=0 w=0.42u l=1u
X3879 VSS.t1936 VDD.t2452 VSS.t1938 VSS.t1937 sg13_lv_nmos ad=79.8f pd=0.8u as=0 ps=0 w=0.42u l=1u
X3880 VSS.t13 sg13cmos5l_buf_1_7.X a_16164_5850# VSS.t20 sg13_lv_nmos ad=0.1626p pd=1.415u as=60.89999f ps=0.71u w=0.42u l=0.13u
X3881 a_20503_18222# a_21063_18476# a_21084_18222# VSS.t118 sg13_lv_nmos ad=0.12665p pd=1.145u as=0.3473p ps=2.71u w=0.74u l=0.13u
X3882 VSS.t1835 VDD.t2480 VSS.t1836 VSS.t88 sg13_lv_nmos ad=79.8f pd=0.8u as=0 ps=0 w=0.42u l=1u
X3883 VSS.t1795 VDD.t2491 VSS.t1794 VSS.t1793 sg13_lv_nmos ad=0.1428p pd=1.52u as=0 ps=0 w=0.42u l=1u
X3884 VDD.t5 a_20997_4629# a_21099_4772# VDD.t5 sg13_lv_pmos ad=1.96072p pd=12.69u as=0.3864p ps=2.93u w=1.12u l=0.13u
X3885 VSS.t22 a_21839_4727# a_22506_4948# VSS.t42 sg13_lv_nmos ad=0.1406p pd=1.12u as=0.2516p ps=2.16u w=0.74u l=0.13u
X3886 VSS.t1981 VDD.t2415 VSS.t1981 VSS.t1983 sg13_lv_nmos ad=0.1428p pd=1.52u as=0 ps=0 w=0.42u l=1u
X3887 VSS.t5 sg13cmos5l_nand3b_1_3.C a_6968_17549# VSS.t1268 sg13_lv_nmos ad=79.8f pd=0.8u as=0.1428p ps=1.52u w=0.42u l=0.13u
X3888 VDD.t789 sg13cmos5l_buf_1_9.A a_21256_3900# VDD.t13 sg13_lv_pmos ad=0.2114p pd=1.54u as=0.2856p ps=2.36u w=0.84u l=0.13u
X3889 VSS.t279 a_11278_6351# sg13cmos5l_a21oi_1_9.B1 VSS.t742 sg13_lv_nmos ad=0.1426p pd=1.16u as=0.2516p ps=2.16u w=0.74u l=0.13u
X3890 a_7738_7294# sg13cmos5l_nand2_1_3.Y VSS.t812 VSS.t811 sg13_lv_nmos ad=0.1406p pd=1.12u as=0.2516p ps=2.16u w=0.74u l=0.13u
X3891 a_21839_8797# a_20997_8447# a_20580_8440# VDD.t8 sg13_lv_pmos ad=0.2048p pd=1.63u as=0.34p ps=2.68u w=1u l=0.13u
X3892 VSS.t48 sg13cmos5l_o21ai_1_10.A2 a_10162_16742# VSS.t1186 sg13_lv_nmos ad=0.1406p pd=1.12u as=0.1406p ps=1.12u w=0.74u l=0.15u
X3893 VDD.t445 VSS.t1215 VDD.t163 VDD.t52 sg13_lv_pmos ad=0.19p pd=1.38u as=0 ps=0 w=1u l=1u
X3894 VSS.t1643 VDD.t2551 VSS.t1642 VSS.t1641 sg13_lv_nmos ad=0.1428p pd=1.52u as=0 ps=0 w=0.42u l=1u
X3895 a_10508_10662# sg13cmos5l_buf_1_21.A VSS.t740 VSS.t1478 sg13_lv_nmos ad=0.187p pd=1.78u as=0.14875p ps=1.16u w=0.55u l=0.13u
X3896 a_4740_14488# a_4714_14452# VDD.t1496 VDD.t19 sg13_lv_pmos ad=0.34p pd=2.68u as=0.36237p ps=2.605u w=1u l=0.13u
X3897 VDD.t486 VSS.t1705 VDD.t293 VDD.t19 sg13_lv_pmos ad=0.19p pd=1.38u as=0 ps=0 w=1u l=1u
X3898 VSS.t120 sg13cmos5l_nor2b_1_0.B_N sg13cmos5l_nor3_1_0.Y VSS.t959 sg13_lv_nmos ad=0.2618p pd=2.22u as=0.1694p ps=1.21u w=0.77u l=0.13u
X3899 a_3886_16746# a_4127_17016# a_3415_16710# VSS.t1493 sg13_lv_nmos ad=0.1428p pd=1.52u as=0.12665p ps=1.145u w=0.42u l=0.13u
X3900 a_7162_6888# sg13cmos5l_dlygate4sd3_1_43.A VDD.t1239 VDD.t2 sg13_lv_pmos ad=0.1428p pd=1.52u as=0.1523p ps=1.38u w=0.42u l=0.13u
X3901 VDD.t343 VSS.t1660 VDD.t342 VDD.t16 sg13_lv_pmos ad=0.19p pd=1.38u as=0 ps=0 w=1u l=1u
X3902 VDD.t208 VSS.t1813 VDD.t207 VDD.t0 sg13_lv_pmos ad=0.19p pd=1.38u as=0 ps=0 w=1u l=1u
X3903 a_11278_13239# a_11393_13238# VDD.t1373 VDD.t83 sg13_lv_pmos ad=0.34p pd=2.68u as=0.2254p ps=1.53u w=1u l=0.5u
X3904 VSS.t284 sg13cmos5l_a21oi_1_9.A1 a_13590_7282# VSS.t689 sg13_lv_nmos ad=0.15245p pd=1.17u as=88.8f ps=0.98u w=0.74u l=0.13u
X3905 a_4932_19024# a_4906_18988# VDD.t1498 VDD.t231 sg13_lv_pmos ad=0.34p pd=2.68u as=0.36237p ps=2.605u w=1u l=0.13u
X3906 VDD.t896 sg13cmos5l_buf_1_45.X.t9 a_15494_18258# VDD.t231 sg13_lv_pmos ad=0.36237p pd=2.605u as=79.8f ps=0.8u w=0.42u l=0.13u
X3907 VSS.t86 sg13cmos5l_buf_8_2.A a_12987_10318# VSS.t874 sg13_lv_nmos ad=0.1406p pd=1.12u as=0.1406p ps=1.12u w=0.74u l=0.13u
X3908 VSS.t190 a_8206_9375# sg13cmos5l_dlygate4sd3_1_38.X VSS.t1084 sg13_lv_nmos ad=0.1426p pd=1.16u as=0.2516p ps=2.16u w=0.74u l=0.13u
X3909 a_21358_5679# a_21473_5678# VSS.t479 VSS.t10 sg13_lv_nmos ad=0.1428p pd=1.52u as=0.1426p ps=1.16u w=0.42u l=0.5u
X3910 VSS.t779 a_9274_6888# a_8993_7190# VSS.t2460 sg13_lv_nmos ad=79.8f pd=0.8u as=0.1428p ps=1.52u w=0.42u l=0.5u
X3911 VDD.t16 a_18287_15311# a_18544_15454# VDD.t16 sg13_lv_pmos ad=2.07625p pd=13.51u as=79.8f ps=0.8u w=0.42u l=0.13u
X3912 VSS.t153 a_12987_12214# sg13cmos5l_buf_8_2.A VSS.t2628 sg13_lv_nmos ad=0.2516p pd=2.16u as=0.1406p ps=1.12u w=0.74u l=0.13u
X3913 a_14350_10215# a_14465_10214# VSS.t86 VSS.t2408 sg13_lv_nmos ad=0.1428p pd=1.52u as=0.1426p ps=1.16u w=0.42u l=0.5u
X3914 a_20294_10386# sg13cmos5l_dfrbpq_1_7.D VDD.t2335 VDD.t52 sg13_lv_pmos ad=79.8f pd=0.8u as=0.1428p ps=1.52u w=0.42u l=0.13u
X3915 VDD.t188 VSS.t2157 VDD.t187 VDD.t13 sg13_lv_pmos ad=0.34p pd=2.68u as=0 ps=0 w=1u l=1u
X3916 a_20997_6935# sg13cmos5l_inv_1_2.A VSS.t253 VSS.t262 sg13_lv_nmos ad=0.2516p pd=2.16u as=4.21822p ps=27.295u w=0.74u l=0.13u
X3917 VDD.t2 a_17829_6935# a_17931_6935# VDD.t2 sg13_lv_pmos ad=2.1916p pd=14.26u as=0.3864p ps=2.93u w=1.12u l=0.13u
X3918 VDD.t568 VSS.t1874 VDD.t567 VDD.t2 sg13_lv_pmos ad=0.34p pd=2.68u as=0 ps=0 w=1u l=1u
X3919 a_13670_15238# a_13400_15238# VSS.t969 VSS.t2318 sg13_lv_nmos ad=0.1428p pd=1.52u as=79.8f ps=0.8u w=0.42u l=0.5u
X3920 a_19642_6130# sg13cmos5l_a21oi_1_0.Y VDD.t980 VDD.t2 sg13_lv_pmos ad=0.1428p pd=1.52u as=0.1523p ps=1.38u w=0.42u l=0.13u
X3921 sg13cmos5l_dfrbpq_1_5.CLK a_21531_13342# VDD.t1602 VDD.t83 sg13_lv_pmos ad=0.2128p pd=1.5u as=0.2128p ps=1.5u w=1.12u l=0.13u
X3922 VSS.t50 sg13cmos5l_dfrbpq_1_13.RESET_B a_9444_12210# VSS.t1201 sg13_lv_nmos ad=0.1626p pd=1.415u as=60.89999f ps=0.71u w=0.42u l=0.13u
X3923 a_11100_16362# sg13cmos5l_buf_1_65.A sg13cmos5l_o21ai_1_10.A2 VSS.t1550 sg13_lv_nmos ad=0.1406p pd=1.12u as=0.2516p ps=2.16u w=0.74u l=0.13u
X3924 VDD.t735 a_21839_13799# a_22506_14020# VDD.t19 sg13_lv_pmos ad=0.2128p pd=1.5u as=0.3864p ps=2.93u w=1.12u l=0.13u
X3925 a_5578_12940# a_6021_12983# a_5961_13019# VDD.t83 sg13_lv_pmos ad=79.8f pd=0.8u as=63f ps=0.72u w=0.42u l=0.13u
X3926 a_18770_13338# sg13cmos5l_nand4_1_3.D VSS.t438 VSS.t128 sg13_lv_nmos ad=0.1406p pd=1.12u as=0.2516p ps=2.16u w=0.74u l=0.13u
X3927 VDD.t787 sg13cmos5l_nor2_1_2.A sg13cmos5l_a21oi_1_8.A1 VDD.t5 sg13_lv_pmos ad=0.2198p pd=1.53u as=0.2128p ps=1.5u w=1.12u l=0.13u
X3928 a_16556_15960# sg13cmos5l_nand4_1_16.D VSS.t134 VSS.t787 sg13_lv_nmos ad=0.187p pd=1.78u as=0.14875p ps=1.16u w=0.55u l=0.13u
X3929 valid a_12040_15272# VSS.t199 VSS.t198 sg13_lv_nmos ad=0.2886p pd=2.26u as=0.14875p ps=1.16u w=0.74u l=0.13u
X3930 sg13cmos5l_nand2_1_1.A a_19530_11460# VDD.t358 VDD.t0 sg13_lv_pmos ad=0.3808p pd=2.92u as=0.2128p ps=1.5u w=1.12u l=0.13u
X3931 VSS.t2178 VDD.t2380 VSS.t2177 VSS.t2176 sg13_lv_nmos ad=0.1428p pd=1.52u as=0 ps=0 w=0.42u l=1u
X3932 VDD.t231 sg13cmos5l_dfrbpq_1_28.RESET_B.t12 a_20716_18258# VDD.t231 sg13_lv_pmos ad=1.4953p pd=9.545u as=79.8f ps=0.8u w=0.42u l=0.13u
X3933 VDD.t1483 sg13cmos5l_dfrbpq_1_37.D a_21911_17137# VDD.t310 sg13_lv_pmos ad=0.1428p pd=1.52u as=79.8f ps=0.8u w=0.42u l=0.13u
X3934 a_7354_16714# sg13cmos5l_dlygate4sd3_1_62.A VSS.t375 VSS.t1475 sg13_lv_nmos ad=0.1428p pd=1.52u as=79.8f ps=0.8u w=0.42u l=0.13u
X3935 VDD.t377 sg13cmos5l_buf_1_7.X a_20554_6892# VDD.t2 sg13_lv_pmos ad=0.1563p pd=1.22u as=0.147p ps=1.54u w=0.42u l=0.13u
X3936 a_5654_18271# a_4476_18222# a_5258_18416# VSS.t1110 sg13_lv_nmos ad=37.8f pd=0.6u as=0.1428p ps=1.52u w=0.42u l=0.13u
X3937 a_9734_17508# a_9464_17549# VSS.t56 VSS.t65 sg13_lv_nmos ad=0.1428p pd=1.52u as=79.8f ps=0.8u w=0.42u l=0.5u
X3938 VDD.t1347 sg13cmos5l_nand2b_1_0.B sg13cmos5l_nand2_1_6.A VDD.t2 sg13_lv_pmos ad=0.2198p pd=1.53u as=0.2128p ps=1.5u w=1.12u l=0.13u
X3939 VSS.t1056 a_22234_19738# a_21953_19960# VSS.t1055 sg13_lv_nmos ad=79.8f pd=0.8u as=0.1428p ps=1.52u w=0.42u l=0.5u
X3940 VSS.t196 sg13cmos5l_buf_1_65.A sg13cmos5l_nand4_1_15.B VSS.t66 sg13_lv_nmos ad=0.1406p pd=1.12u as=0.1406p ps=1.12u w=0.74u l=0.13u
X3941 VSS.t362 a_6442_10666# sg13cmos5l_dfrbpq_1_15.CLK VSS.t2403 sg13_lv_nmos ad=0.1406p pd=1.12u as=0.1406p ps=1.12u w=0.74u l=0.13u
X3942 a_13764_17512# a_13738_17476# VDD.t1308 VDD.t310 sg13_lv_pmos ad=0.34p pd=2.68u as=0.36237p ps=2.605u w=1u l=0.13u
X3943 VDD.t406 VSS.t1729 VDD.t267 VDD.t0 sg13_lv_pmos ad=0.19p pd=1.38u as=0 ps=0 w=1u l=1u
X3944 VSS.t11 a_19642_6130# a_19361_6352# VSS.t2310 sg13_lv_nmos ad=79.8f pd=0.8u as=0.1428p ps=1.52u w=0.42u l=0.5u
X3945 VDD.t662 sg13cmos5l_and4_1_0.D a_12430_6980# VDD.t2 sg13_lv_pmos ad=0.2618p pd=1.63u as=0.2856p ps=2.36u w=0.84u l=0.13u
X3946 a_12708_19445# a_12420_19024# a_12646_19445# VSS.t1162 sg13_lv_nmos ad=0.1428p pd=1.52u as=37.8f ps=0.6u w=0.42u l=0.13u
X3947 VSS.t2302 a_19173_19031# a_19275_19031# VSS.t2620 sg13_lv_nmos ad=3.91182p pd=24.955u as=0.2516p ps=2.16u w=0.74u l=0.13u
X3948 VSS.t1834 VDD.t2485 VSS.t1835 VSS.t88 sg13_lv_nmos ad=79.8f pd=0.8u as=0 ps=0 w=0.42u l=1u
X3949 VSS.t1173 a_22426_18984# a_22145_19286# VSS.t1098 sg13_lv_nmos ad=79.8f pd=0.8u as=0.1428p ps=1.52u w=0.42u l=0.5u
X3950 VDD.t1546 sg13cmos5l_nand4_1_1.B sg13cmos5l_a21oi_1_24.A2 VDD.t310 sg13_lv_pmos ad=0.2128p pd=1.5u as=0.2128p ps=1.5u w=1.12u l=0.13u
X3951 a_8796_14020# sg13cmos5l_mux2_1_0.S a_8694_14020# VDD.t19 sg13_lv_pmos ad=0.2128p pd=1.5u as=0.2128p ps=1.5u w=1.12u l=0.13u
X3952 a_10543_11830# a_10461_11730# sg13cmos5l_a21oi_1_27.A1 VSS.t578 sg13_lv_nmos ad=0.1406p pd=1.12u as=0.333p ps=2.38u w=0.74u l=0.13u
X3953 VDD.t13 VSS.t1966 VDD.t13 VDD.t13 sg13_lv_pmos ad=0.34p pd=2.68u as=0 ps=0 w=1u l=1u
X3954 VDD.t779 a_12512_5699# sg13cmos5l_dfrbpq_1_47.Q VDD.t5 sg13_lv_pmos ad=0.2128p pd=1.5u as=0.3808p ps=2.92u w=1.12u l=0.13u
X3955 sg13cmos5l_dfrbpq_1_5.Q a_20586_10996# VDD.t1273 VDD.t0 sg13_lv_pmos ad=0.3808p pd=2.92u as=0.2128p ps=1.5u w=1.12u l=0.13u
X3956 VSS.t182 sg13cmos5l_o21ai_1_9.A2 a_5554_13718# VSS.t1326 sg13_lv_nmos ad=0.1406p pd=1.12u as=0.1406p ps=1.12u w=0.74u l=0.15u
X3957 sg13cmos5l_a21oi_1_1.A2 sg13cmos5l_nand4_1_18.A a_19550_13730# VSS.t128 sg13_lv_nmos ad=0.2516p pd=2.16u as=0.1406p ps=1.12u w=0.74u l=0.13u
X3958 VSS.t1058 VDD.t2497 VSS.t1058 VSS.t1808 sg13_lv_nmos ad=0.1428p pd=1.52u as=0 ps=0 w=0.42u l=1u
X3959 sg13cmos5l_dlygate4sd3_1_33.X a_3894_9972# VDD.t1217 VDD.t52 sg13_lv_pmos ad=0.4256p pd=3u as=0.2254p ps=1.53u w=1.12u l=0.13u
X3960 sg13cmos5l_dfrbpq_1_47.D a_13974_6230# VSS.t206 VSS.t377 sg13_lv_nmos ad=0.2516p pd=2.16u as=0.1426p ps=1.16u w=0.74u l=0.13u
X3961 VSS.t1693 VDD.t2533 VSS.t1695 VSS.t1694 sg13_lv_nmos ad=79.8f pd=0.8u as=0 ps=0 w=0.42u l=1u
X3962 sg13cmos5l_a21oi_1_15.A2 sg13cmos5l_nand4_1_1.A VDD.t1680 VDD.t19 sg13_lv_pmos ad=0.2128p pd=1.5u as=0.3808p ps=2.92u w=1.12u l=0.13u
X3963 VDD.t1535 sg13cmos5l_buf_1_15.A.t6 a_9062_19770# VDD.t270 sg13_lv_pmos ad=0.36237p pd=2.605u as=79.8f ps=0.8u w=0.42u l=0.13u
X3964 VSS.t1140 sg13cmos5l_dfrbpq_1_24.RESET_B a_10788_18258# VSS.t1137 sg13_lv_nmos ad=0.1626p pd=1.415u as=60.89999f ps=0.71u w=0.42u l=0.13u
X3965 a_20294_6166# a_20024_6166# VSS.t11 VSS.t258 sg13_lv_nmos ad=0.1428p pd=1.52u as=79.8f ps=0.8u w=0.42u l=0.5u
X3966 VDD.t1080 sg13cmos5l_nor3_1_4.A a_10787_12972# VDD.t83 sg13_lv_pmos ad=0.3808p pd=2.92u as=0.2464p ps=1.56u w=1.12u l=0.13u
X3967 VSS.t1921 VDD.t2455 VSS.t1923 VSS.t1922 sg13_lv_nmos ad=79.8f pd=0.8u as=0 ps=0 w=0.42u l=1u
X3968 VDD.t2096 sg13cmos5l_a21oi_1_9.A2 sg13cmos5l_o21ai_1_4.A1 VDD.t2 sg13_lv_pmos ad=0.3808p pd=2.92u as=0.3808p ps=2.92u w=1.12u l=0.13u
X3969 sg13cmos5l_dfrbpq_1_25.Q a_6858_19020# VDD.t1657 VDD.t231 sg13_lv_pmos ad=0.3808p pd=2.92u as=0.2128p ps=1.5u w=1.12u l=0.13u
X3970 VSS.t1155 a_8783_19381# a_9450_19020# VSS.t1276 sg13_lv_nmos ad=0.1406p pd=1.12u as=0.2516p ps=2.16u w=0.74u l=0.13u
X3971 sg13cmos5l_dfrbpq_1_41.CLK a_14218_18226# VDD.t1789 VDD.t231 sg13_lv_pmos ad=0.2128p pd=1.5u as=0.2128p ps=1.5u w=1.12u l=0.13u
X3972 VDD.t1211 sg13cmos5l_dfrbpq_1_23.D a_4823_17137# VDD.t310 sg13_lv_pmos ad=0.1428p pd=1.52u as=79.8f ps=0.8u w=0.42u l=0.13u
X3973 a_9260_11424# sg13cmos5l_buf_1_65.A VSS.t74 VSS.t1553 sg13_lv_nmos ad=0.187p pd=1.78u as=0.14875p ps=1.16u w=0.55u l=0.13u
X3974 VSS.t199 sg13cmos5l_mux2_1_0.S sg13cmos5l_nand4_1_6.B VSS.t2252 sg13_lv_nmos ad=0.1406p pd=1.12u as=0.1406p ps=1.12u w=0.74u l=0.13u
X3975 VDD.t1638 sg13cmos5l_a21oi_1_15.Y a_19448_12214# VDD.t83 sg13_lv_pmos ad=0.1523p pd=1.38u as=0.1428p ps=1.52u w=0.42u l=0.13u
X3976 a_20868_10373# a_21099_9959# a_20554_9916# VSS.t2571 sg13_lv_nmos ad=0.2373p pd=1.97u as=79.8f ps=0.8u w=0.42u l=0.13u
X3977 a_22126_4167# a_22241_4166# VSS.t22 VSS.t193 sg13_lv_nmos ad=0.1428p pd=1.52u as=0.1426p ps=1.16u w=0.42u l=0.5u
X3978 VDD.t1239 a_7162_6888# a_6881_7190# VDD.t2 sg13_lv_pmos ad=0.1523p pd=1.38u as=0.34p ps=2.68u w=1u l=0.5u
X3979 VSS.t69 a_6670_18447# sg13cmos5l_dfrbpq_1_20.D VSS.t1393 sg13_lv_nmos ad=0.1426p pd=1.16u as=0.2516p ps=2.16u w=0.74u l=0.13u
X3980 a_19718_12214# a_19448_12214# VDD.t1638 VDD.t83 sg13_lv_pmos ad=0.34p pd=2.68u as=0.1523p ps=1.38u w=1u l=0.5u
X3981 VDD.t2157 a_6442_10666# sg13cmos5l_dfrbpq_1_15.CLK VDD.t0 sg13_lv_pmos ad=0.2128p pd=1.5u as=0.2128p ps=1.5u w=1.12u l=0.13u
X3982 sg13cmos5l_or2_1_1.X a_10896_8052# VSS.t759 VSS.t2580 sg13_lv_nmos ad=0.2516p pd=2.16u as=0.1469p ps=1.155u w=0.74u l=0.13u
X3983 sg13cmos5l_o21ai_1_3.Y sg13cmos5l_nand3_1_0.A a_14902_8814# VSS.t2449 sg13_lv_nmos ad=0.2516p pd=2.16u as=0.1406p ps=1.12u w=0.74u l=0.15u
X3984 VSS.t89 VDD.t2483 VSS.t1828 VSS.t88 sg13_lv_nmos ad=79.8f pd=0.8u as=0 ps=0 w=0.42u l=1u
X3985 VDD.t1143 sg13cmos5l_nor3_1_0.Y sg13cmos5l_nand2_1_13.Y VDD.t83 sg13_lv_pmos ad=0.3808p pd=2.92u as=0.2128p ps=1.5u w=1.12u l=0.13u
X3986 VDD.t1897 sg13cmos5l_dlygate4sd3_1_98.A a_21080_17549# VDD.t310 sg13_lv_pmos ad=0.1523p pd=1.38u as=0.1428p ps=1.52u w=0.42u l=0.13u
X3987 sg13cmos5l_nand3_1_2.Y sg13cmos5l_nand3_1_2.A VDD.t1710 VDD.t0 sg13_lv_pmos ad=0.3808p pd=2.92u as=0.2128p ps=1.5u w=1.12u l=0.13u
X3988 VSS.t17 a_22096_11702# a_21745_11821# VSS.t16 sg13_lv_nmos ad=79.8f pd=0.8u as=0.1428p ps=1.52u w=0.42u l=0.13u
X3989 VSS.t362 a_6442_10666# sg13cmos5l_dfrbpq_1_15.CLK VSS.t2399 sg13_lv_nmos ad=0.1406p pd=1.12u as=0.1406p ps=1.12u w=0.74u l=0.13u
X3990 VDD.t523 VSS.t1940 VDD.t522 VDD.t2 sg13_lv_pmos ad=0.34p pd=2.68u as=0 ps=0 w=1u l=1u
X3991 sg13cmos5l_a21oi_1_21.A1 sg13cmos5l_buf_1_63.A VSS.t107 VSS.t2306 sg13_lv_nmos ad=0.2516p pd=2.16u as=0.2516p ps=2.16u w=0.74u l=0.13u
X3992 VDD.t801 a_3200_16283# sg13cmos5l_dlygate4sd3_1_50.A VDD.t16 sg13_lv_pmos ad=0.2128p pd=1.5u as=0.3808p ps=2.92u w=1.12u l=0.13u
X3993 VDD.t488 VSS.t1705 VDD.t295 VDD.t83 sg13_lv_pmos ad=0.19p pd=1.38u as=0 ps=0 w=1u l=1u
X3994 a_18948_10711# a_18660_11016# a_18886_10711# VSS.t589 sg13_lv_nmos ad=0.1428p pd=1.52u as=37.8f ps=0.6u w=0.42u l=0.13u
X3995 a_19923_18284# sg13cmos5l_nand4_1_17.Y VSS.t117 VSS.t118 sg13_lv_nmos ad=0.1406p pd=1.12u as=0.2516p ps=2.16u w=0.74u l=0.13u
X3996 sg13cmos5l_dlygate4sd3_1_77.A a_18954_15532# VDD.t955 VDD.t16 sg13_lv_pmos ad=0.3808p pd=2.92u as=0.2128p ps=1.5u w=1.12u l=0.13u
X3997 VSS.t500 a_18970_14448# a_18689_14750# VSS.t432 sg13_lv_nmos ad=79.8f pd=0.8u as=0.1428p ps=1.52u w=0.42u l=0.5u
X3998 VSS.t1698 VDD.t2526 VSS.t1697 VSS.t1696 sg13_lv_nmos ad=0.1428p pd=1.52u as=0 ps=0 w=0.42u l=1u
X3999 VSS.t949 a_19534_13239# sg13cmos5l_inv_1_12.A VSS.t128 sg13_lv_nmos ad=0.1426p pd=1.16u as=0.2516p ps=2.16u w=0.74u l=0.13u
X4000 VSS.t222 sg13cmos5l_a21oi_1_4.A2 a_14854_12236# VSS.t1073 sg13_lv_nmos ad=0.2516p pd=2.16u as=0.1406p ps=1.12u w=0.74u l=0.13u
X4001 a_4454_14922# sg13cmos5l_a21o_1_2.X VDD.t856 VDD.t19 sg13_lv_pmos ad=79.8f pd=0.8u as=0.1428p ps=1.52u w=0.42u l=0.13u
X4002 VDD.t652 sg13cmos5l_a21oi_1_3.Y a_16184_8477# VDD.t8 sg13_lv_pmos ad=0.1523p pd=1.38u as=0.1428p ps=1.52u w=0.42u l=0.13u
X4003 VDD.t693 sg13cmos5l_o21ai_1_5.A2 a_16085_12508# VDD.t83 sg13_lv_pmos ad=0.2128p pd=1.5u as=0.3808p ps=2.92u w=1.12u l=0.13u
X4004 VSS.t1757 VDD.t2505 VSS.t1756 VSS.t1778 sg13_lv_nmos ad=0.1428p pd=1.52u as=0 ps=0 w=0.42u l=1u
X4005 a_16167_9404# a_16319_9456# VDD.t52 VDD.t52 sg13_lv_pmos ad=0.3864p pd=2.93u as=1.8716p ps=12.115u w=1.12u l=0.13u
X4006 a_5220_19445# a_5451_19031# a_4906_18988# VSS.t1170 sg13_lv_nmos ad=0.2373p pd=1.97u as=79.8f ps=0.8u w=0.42u l=0.13u
X4007 a_20272_17750# sg13cmos5l_dfrbpq_1_28.RESET_B.t9 VDD.t310 VDD.t310 sg13_lv_pmos ad=79.8f pd=0.8u as=2.07625p ps=13.51u w=0.42u l=0.13u
X4008 VSS.t344 VDD.t2514 VSS.t498 VSS.t1761 sg13_lv_nmos ad=0.1428p pd=1.52u as=0 ps=0 w=0.42u l=1u
X4009 a_20580_14488# a_20554_14452# VSS.t72 VSS.t630 sg13_lv_nmos ad=0.2516p pd=2.16u as=0.1626p ps=1.415u w=0.74u l=0.13u
X4010 a_20176_10918# sg13cmos5l_buf_1_13.X VDD.t0 VDD.t0 sg13_lv_pmos ad=79.8f pd=0.8u as=2.07625p ps=13.51u w=0.42u l=0.13u
X4011 VDD.t31 VSS.t2142 VDD.t30 VDD.t13 sg13_lv_pmos ad=0.34p pd=2.68u as=0 ps=0 w=1u l=1u
X4012 VDD.t176 VSS.t1859 VDD.t175 VDD.t2 sg13_lv_pmos ad=0.34p pd=2.68u as=0 ps=0 w=1u l=1u
X4013 sg13cmos5l_dlygate4sd3_1_69.A sg13cmos5l_nor2_1_12.Y a_12216_17488# VDD.t310 sg13_lv_pmos ad=0.2128p pd=1.5u as=0.2128p ps=1.5u w=1.12u l=0.15u
X4014 a_18994_8874# sg13cmos5l_buf_1_13.X VSS.t83 VSS.t604 sg13_lv_nmos ad=37.8f pd=0.6u as=79.8f ps=0.8u w=0.42u l=0.13u
X4015 sg13cmos5l_o21ai_1_0.A1 a_14061_8784# VSS.t97 VSS.t733 sg13_lv_nmos ad=0.2516p pd=2.16u as=0.1331p ps=1.12u w=0.74u l=0.13u
X4016 VSS.t674 sg13cmos5l_inv_1_31.A a_21215_17016# VSS.t1564 sg13_lv_nmos ad=4.4216p pd=27.885u as=0.2516p ps=2.16u w=0.74u l=0.13u
X4017 VDD.t0 a_8272_11702# a_8217_11583# VDD.t0 sg13_lv_pmos ad=2.1916p pd=14.26u as=93.45f ps=0.865u w=0.42u l=0.13u
X4018 VDD.t592 VSS.t362 VDD.t543 VDD.t52 sg13_lv_pmos ad=0.19p pd=1.38u as=0 ps=0 w=1u l=1u
X4019 a_13786_7642# sg13cmos5l_dlygate4sd3_1_9.A VSS.t284 VSS.t2605 sg13_lv_nmos ad=0.1428p pd=1.52u as=79.8f ps=0.8u w=0.42u l=0.13u
X4020 sg13cmos5l_dfrbpq_1_41.CLK a_14218_18226# VDD.t1786 VDD.t231 sg13_lv_pmos ad=0.2128p pd=1.5u as=0.3864p ps=2.93u w=1.12u l=0.13u
X4021 VSS.t159 a_12896_13897# sg13cmos5l_nand2_1_18.A VSS.t66 sg13_lv_nmos ad=0.1406p pd=1.12u as=0.2516p ps=2.16u w=0.74u l=0.13u
X4022 a_8431_13362# sg13cmos5l_and4_1_1.A a_8337_13362# VSS.t149 sg13_lv_nmos ad=0.1216p pd=1.02u as=0.2176p ps=1.96u w=0.64u l=0.13u
X4023 a_18468_7674# sg13cmos5l_dlygate4sd3_1_29.X a_18374_7674# VSS.t698 sg13_lv_nmos ad=60.89999f pd=0.71u as=0.1428p ps=1.52u w=0.42u l=0.13u
X4024 a_22258_14922# sg13cmos5l_dfrbpq_1_28.RESET_B.t5 VSS.t72 VSS.t394 sg13_lv_nmos ad=37.8f pd=0.6u as=79.8f ps=0.8u w=0.42u l=0.13u
X4025 VSS.t293 a_7989_6320# a_7068_6126# VSS.t2195 sg13_lv_nmos ad=0.1626p pd=1.415u as=0.2516p ps=2.16u w=0.74u l=0.13u
X4026 sg13cmos5l_nand2_1_1.A a_19530_11460# VSS.t7 VSS.t6 sg13_lv_nmos ad=0.2516p pd=2.16u as=0.1406p ps=1.12u w=0.74u l=0.13u
X4027 a_20207_5773# a_19365_5423# a_18948_5416# VDD.t5 sg13_lv_pmos ad=0.2048p pd=1.63u as=0.34p ps=2.68u w=1u l=0.13u
X4028 VDD.t309 VSS.t1617 VDD.t308 VDD.t231 sg13_lv_pmos ad=0.34p pd=2.68u as=0 ps=0 w=1u l=1u
X4029 VDD.t80 VSS.t1780 VDD.t79 VDD.t0 sg13_lv_pmos ad=0.34p pd=2.68u as=0 ps=0 w=1u l=1u
X4030 VSS.t1981 VDD.t2414 VSS.t1981 VSS.t1985 sg13_lv_nmos ad=0.1428p pd=1.52u as=0 ps=0 w=0.42u l=1u
X4031 sg13cmos5l_dfrbpq_1_37.D a_21462_19044# VDD.t1531 VDD.t231 sg13_lv_pmos ad=0.4256p pd=3u as=0.2254p ps=1.53u w=1.12u l=0.13u
X4032 VDD.t753 sg13cmos5l_inv_1_1.A a_14152_14484# VDD.t19 sg13_lv_pmos ad=0.2114p pd=1.54u as=0.2856p ps=2.36u w=0.84u l=0.13u
X4033 VDD.t2153 a_6442_10666# sg13cmos5l_dfrbpq_1_15.CLK VDD.t0 sg13_lv_pmos ad=0.2128p pd=1.5u as=0.2128p ps=1.5u w=1.12u l=0.13u
X4034 VDD.t797 a_20794_3864# a_20513_4166# VDD.t13 sg13_lv_pmos ad=0.1523p pd=1.38u as=0.34p ps=2.68u w=1u l=0.5u
X4035 VSS.t1941 VDD.t2442 VSS.t256 VSS.t1958 sg13_lv_nmos ad=79.8f pd=0.8u as=0 ps=0 w=0.42u l=1u
X4036 bp9 a_19048_3900# VDD.t1009 VDD.t13 sg13_lv_pmos ad=0.42p pd=2.99u as=0.2114p ps=1.54u w=1.12u l=0.13u
X4037 sg13cmos5l_dfrbpq_1_13.Q a_11274_5412# VSS.t279 VSS.t2570 sg13_lv_nmos ad=0.2516p pd=2.16u as=0.1406p ps=1.12u w=0.74u l=0.13u
X4038 VDD.t231 a_6191_19381# a_6448_19262# VDD.t231 sg13_lv_pmos ad=1.54512p pd=9.865u as=79.8f ps=0.8u w=0.42u l=0.13u
X4039 a_21063_16964# a_21215_17016# VDD.t310 VDD.t310 sg13_lv_pmos ad=0.3864p pd=2.93u as=2.1916p ps=14.26u w=1.12u l=0.13u
X4040 sg13cmos5l_nor4_1_4.C sg13cmos5l_nor2b_1_1.A VDD.t385 VDD.t16 sg13_lv_pmos ad=0.3808p pd=2.92u as=0.3808p ps=2.92u w=1.12u l=0.13u
X4041 a_9274_6888# sg13cmos5l_dfrbpq_1_15.Q VDD.t1185 VDD.t2 sg13_lv_pmos ad=0.1428p pd=1.52u as=0.1523p ps=1.38u w=0.42u l=0.13u
X4042 VDD.t1165 sg13cmos5l_or2_1_1.X a_12414_7996# VDD.t8 sg13_lv_pmos ad=0.3808p pd=2.92u as=0.2716p ps=1.605u w=1.12u l=0.13u
X4043 a_12837_19031# sg13cmos5l_dfrbpq_1_41.CLK VDD.t231 VDD.t231 sg13_lv_pmos ad=0.4088p pd=2.97u as=1.4953p ps=9.545u w=1.12u l=0.13u
X4044 sg13cmos5l_dlygate4sd3_1_50.X a_4950_15302# VDD.t1140 VDD.t16 sg13_lv_pmos ad=0.4256p pd=3u as=0.2254p ps=1.53u w=1.12u l=0.13u
X4045 VDD.t1355 sg13cmos5l_o21ai_1_5.A1 a_6524_15552# VDD.t16 sg13_lv_pmos ad=0.3808p pd=2.92u as=0.2128p ps=1.5u w=1.12u l=0.15u
X4046 a_14548_12236# sg13cmos5l_inv_1_36.Y VSS.t153 VSS.t1450 sg13_lv_nmos ad=0.1406p pd=1.12u as=0.1406p ps=1.12u w=0.74u l=0.13u
X4047 VSS.t161 a_18478_10215# sg13cmos5l_dlygate4sd3_1_18.X VSS.t2410 sg13_lv_nmos ad=0.1426p pd=1.16u as=0.2516p ps=2.16u w=0.74u l=0.13u
X4048 VDD.t2 a_18928_7166# a_18873_7047# VDD.t2 sg13_lv_pmos ad=2.1916p pd=14.26u as=93.45f ps=0.865u w=0.42u l=0.13u
X4049 VDD.t388 sg13cmos5l_nand3b_1_1.C sg13cmos5l_o21ai_1_20.A1 VDD.t310 sg13_lv_pmos ad=0.3808p pd=2.92u as=0.2128p ps=1.5u w=1.12u l=0.13u
X4050 a_18756_17512# a_18730_17476# VSS.t91 VSS.t90 sg13_lv_nmos ad=0.2516p pd=2.16u as=0.1626p ps=1.415u w=0.74u l=0.13u
X4051 VDD.t1176 a_14542_7191# sg13cmos5l_dlygate4sd3_1_7.X VDD.t2 sg13_lv_pmos ad=0.2254p pd=1.53u as=0.4256p ps=3u w=1.12u l=0.13u
X4052 a_13936_19262# sg13cmos5l_buf_1_45.X.t10 VDD.t231 VDD.t231 sg13_lv_pmos ad=79.8f pd=0.8u as=1.4953p ps=9.545u w=0.42u l=0.13u
X4053 VSS.t674 sg13cmos5l_dfrbpq_1_19.CLK a_4127_17016# VSS.t2476 sg13_lv_nmos ad=3.97945p pd=25.095u as=0.2516p ps=2.16u w=0.74u l=0.13u
X4054 a_18195_13748# sg13cmos5l_a21oi_1_23.A2 VSS.t164 VSS.t128 sg13_lv_nmos ad=0.1406p pd=1.12u as=0.2516p ps=2.16u w=0.74u l=0.13u
X4055 VDD.t374 sg13cmos5l_buf_1_7.X a_18634_7897# VDD.t8 sg13_lv_pmos ad=0.1563p pd=1.22u as=0.147p ps=1.54u w=0.42u l=0.13u
X4056 VSS.t48 sg13cmos5l_nand2_1_11.B sg13cmos5l_o21ai_1_8.B1 VSS.t1320 sg13_lv_nmos ad=0.2516p pd=2.16u as=0.1406p ps=1.12u w=0.74u l=0.13u
X4057 a_5686_16374# sg13cmos5l_o21ai_1_10.A2 VSS.t176 VSS.t1187 sg13_lv_nmos ad=0.1406p pd=1.12u as=0.1406p ps=1.12u w=0.74u l=0.15u
X4058 VDD.t1067 sg13cmos5l_inv_1_36.A a_9176_13726# VDD.t19 sg13_lv_pmos ad=0.1523p pd=1.38u as=0.1428p ps=1.52u w=0.42u l=0.13u
X4059 a_6394_17472# sg13cmos5l_o21ai_1_11.Y VDD.t1607 VDD.t310 sg13_lv_pmos ad=0.1428p pd=1.52u as=0.1523p ps=1.38u w=0.42u l=0.13u
X4060 a_12228_19458# sg13cmos5l_dlygate4sd3_1_55.X a_12134_19458# VSS.t1158 sg13_lv_nmos ad=60.89999f pd=0.71u as=0.1428p ps=1.52u w=0.42u l=0.13u
X4061 a_9446_13726# a_9176_13726# VDD.t1067 VDD.t19 sg13_lv_pmos ad=0.34p pd=2.68u as=0.1523p ps=1.38u w=1u l=0.5u
X4062 sg13cmos5l_nand2_1_0.B sg13cmos5l_inv_1_18.A VSS.t248 VSS.t611 sg13_lv_nmos ad=0.1406p pd=1.12u as=0.2516p ps=2.16u w=0.74u l=0.13u
X4063 VSS.t279 sg13cmos5l_dfrbpq_1_47.Q a_12344_6166# VSS.t988 sg13_lv_nmos ad=79.8f pd=0.8u as=0.1428p ps=1.52u w=0.42u l=0.13u
X4064 a_19829_18556# sg13cmos5l_inv_1_1.Y VDD.t1769 VDD.t231 sg13_lv_pmos ad=0.2128p pd=1.5u as=0.2128p ps=1.5u w=1.12u l=0.13u
X4065 a_6756_11464# a_6730_11428# VDD.t391 VDD.t0 sg13_lv_pmos ad=0.34p pd=2.68u as=0.36237p ps=2.605u w=1u l=0.13u
X4066 sg13cmos5l_nand4_1_18.B a_8337_13362# VDD.t923 VDD.t83 sg13_lv_pmos ad=0.5376p pd=3.2u as=0.2044p ps=1.53u w=1.12u l=0.13u
X4067 a_6982_11885# sg13cmos5l_dfrbpq_1_13.RESET_B VSS.t1211 VSS.t1210 sg13_lv_nmos ad=37.8f pd=0.6u as=0.1701p ps=1.65u w=0.42u l=0.13u
X4068 VSS.t1099 a_20110_19959# sg13cmos5l_buf_1_63.A VSS.t1055 sg13_lv_nmos ad=0.1426p pd=1.16u as=0.2516p ps=2.16u w=0.74u l=0.13u
X4069 VSS.t70 a_5222_17508# a_5334_17532# VSS.t68 sg13_lv_nmos ad=0.1426p pd=1.16u as=0.1428p ps=1.52u w=0.42u l=0.5u
X4070 sg13cmos5l_a21oi_1_20.A2 sg13cmos5l_nand4_1_8.B VDD.t1781 VDD.t16 sg13_lv_pmos ad=0.2128p pd=1.5u as=0.2128p ps=1.5u w=1.12u l=0.13u
X4071 VSS.t1660 VDD.t2540 VSS.t1660 VSS.t1672 sg13_lv_nmos ad=79.8f pd=0.8u as=0 ps=0 w=0.42u l=1u
X4072 VSS.t159 sg13cmos5l_mux2_1_0.S sg13cmos5l_nor4_1_2.Y VSS.t66 sg13_lv_nmos ad=0.1406p pd=1.12u as=0.1406p ps=1.12u w=0.74u l=0.13u
X4073 VSS.t120 a_14746_9912# a_14465_10214# VSS.t1597 sg13_lv_nmos ad=79.8f pd=0.8u as=0.1428p ps=1.52u w=0.42u l=0.5u
X4074 VDD.t1779 a_19642_19738# a_19361_19960# VDD.t270 sg13_lv_pmos ad=0.1523p pd=1.38u as=0.34p ps=2.68u w=1u l=0.5u
X4075 a_6368_6337# a_6487_6126# VSS.t256 VSS.t255 sg13_lv_nmos ad=0.2516p pd=2.16u as=0.1406p ps=1.12u w=0.74u l=0.13u
X4076 a_6394_7294# sg13cmos5l_nor2_1_2.B VSS.t1902 VSS.t2486 sg13_lv_nmos ad=0.1406p pd=1.12u as=0.2516p ps=2.16u w=0.74u l=0.13u
X4077 VDD.t530 VSS.t1751 VDD.t576 VDD.t83 sg13_lv_pmos ad=0.34p pd=2.68u as=0 ps=0 w=1u l=1u
X4078 a_11278_6351# a_11393_6352# VSS.t279 VSS.t2382 sg13_lv_nmos ad=0.1428p pd=1.52u as=0.1426p ps=1.16u w=0.42u l=0.5u
X4079 a_3975_16964# a_4127_17016# VDD.t310 VDD.t310 sg13_lv_pmos ad=0.3864p pd=2.93u as=2.1916p ps=14.26u w=1.12u l=0.13u
X4080 VDD.t1815 sg13cmos5l_o21ai_1_10.B1 sg13cmos5l_o21ai_1_10.Y VDD.t16 sg13_lv_pmos ad=0.3808p pd=2.92u as=0.2128p ps=1.5u w=1.12u l=0.15u
X4081 VSS.t1837 VDD.t2484 VSS.t1215 VSS.t88 sg13_lv_nmos ad=79.8f pd=0.8u as=0 ps=0 w=0.42u l=1u
X4082 a_6021_12983# sg13cmos5l_dfrbpq_1_15.CLK VSS.t948 VSS.t2551 sg13_lv_nmos ad=0.2516p pd=2.16u as=6.29922p ps=42.355u w=0.74u l=0.13u
X4083 a_10811_4948# sg13cmos5l_a21oi_1_9.A2 VDD.t1113 VDD.t5 sg13_lv_pmos ad=0.3808p pd=2.92u as=0.2128p ps=1.5u w=1.12u l=0.13u
X4084 a_8671_7996# sg13cmos5l_inv_1_19.Y VDD.t1267 VDD.t8 sg13_lv_pmos ad=0.2716p pd=1.605u as=0.3808p ps=2.92u w=1.12u l=0.13u
X4085 VDD.t1400 VSS.t1908 VDD.t1399 VDD.t2 sg13_lv_pmos ad=0.19p pd=1.38u as=0 ps=0 w=1u l=1u
X4086 a_18671_7285# a_17829_6935# a_18577_7285# VSS.t18 sg13_lv_nmos ad=0.12665p pd=1.145u as=0.1428p ps=1.52u w=0.42u l=0.13u
X4087 a_13114_14854# sg13cmos5l_o21ai_1_5.A2 VSS.t79 VSS.t2615 sg13_lv_nmos ad=0.1406p pd=1.12u as=0.2516p ps=2.16u w=0.74u l=0.13u
X4088 sg13cmos5l_nand4_1_16.D a_14761_15238# VSS.t201 VSS.t1074 sg13_lv_nmos ad=0.2516p pd=2.16u as=0.13395p ps=1.12u w=0.74u l=0.13u
X4089 a_10124_11424# sg13cmos5l_o21ai_1_5.A1 VDD.t386 VDD.t0 sg13_lv_pmos ad=0.2856p pd=2.36u as=0.2114p ps=1.54u w=0.84u l=0.13u
X4090 a_4740_14488# a_5259_14495# a_5999_14845# VSS.t2546 sg13_lv_nmos ad=0.3473p pd=2.71u as=0.12665p ps=1.145u w=0.74u l=0.13u
X4091 sg13cmos5l_o21ai_1_14.A1 a_8830_17874# a_9156_17874# VSS.t62 sg13_lv_nmos ad=0.3404p pd=2.4u as=0.1406p ps=1.12u w=0.74u l=0.13u
X4092 VSS.t1926 VDD.t2454 VSS.t1928 VSS.t1927 sg13_lv_nmos ad=79.8f pd=0.8u as=0 ps=0 w=0.42u l=1u
X4093 a_8513_15260# sg13cmos5l_nor4_1_1.D sg13cmos5l_a21oi_1_12.Y VSS.t1468 sg13_lv_nmos ad=0.1406p pd=1.12u as=0.1406p ps=1.12u w=0.74u l=0.13u
X4094 a_18287_15311# a_17445_15213# a_18193_15311# VSS.t392 sg13_lv_nmos ad=0.12665p pd=1.145u as=0.1428p ps=1.52u w=0.42u l=0.13u
X4095 a_15610_9912# sg13cmos5l_dlygate4sd3_1_14.A VSS.t120 VSS.t119 sg13_lv_nmos ad=0.1428p pd=1.52u as=79.8f ps=0.8u w=0.42u l=0.13u
X4096 a_20997_9959# sg13cmos5l_inv_1_2.A VDD.t52 VDD.t52 sg13_lv_pmos ad=0.4088p pd=2.97u as=1.8716p ps=12.115u w=1.12u l=0.13u
X4097 VSS.t124 sg13cmos5l_o21ai_1_7.A2 a_7090_15230# VSS.t2514 sg13_lv_nmos ad=0.1406p pd=1.12u as=0.1406p ps=1.12u w=0.74u l=0.15u
X4098 a_8911_12508# sg13cmos5l_mux2_1_1.A1 a_8734_12214# VDD.t83 sg13_lv_pmos ad=0.2975p pd=1.595u as=0.2225p ps=1.445u w=1u l=0.13u
X4099 VDD.t1114 sg13cmos5l_a21oi_1_9.A1 a_12131_5412# VDD.t5 sg13_lv_pmos ad=0.3808p pd=2.92u as=0.2464p ps=1.56u w=1.12u l=0.13u
X4100 a_14446_12508# sg13cmos5l_nor3_1_0.Y a_14548_12508# VDD.t83 sg13_lv_pmos ad=0.3808p pd=2.92u as=0.2128p ps=1.5u w=1.12u l=0.13u
X4101 a_16954_11424# sg13cmos5l_nand2_1_13.Y VDD.t1701 VDD.t0 sg13_lv_pmos ad=0.1428p pd=1.52u as=0.1523p ps=1.38u w=0.42u l=0.13u
X4102 VDD.t2 a_15141_6141# a_15243_6284# VDD.t2 sg13_lv_pmos ad=2.1916p pd=14.26u as=0.3864p ps=2.93u w=1.12u l=0.13u
X4103 a_7334_10386# sg13cmos5l_dfrbpq_1_14.D VDD.t1934 VDD.t52 sg13_lv_pmos ad=79.8f pd=0.8u as=0.1428p ps=1.52u w=0.42u l=0.13u
X4104 VSS.t1973 VDD.t2417 VSS.t1973 VSS.t1978 sg13_lv_nmos ad=0.1428p pd=1.52u as=0 ps=0 w=0.42u l=1u
X4105 VDD.t8 a_18832_8678# a_18777_8559# VDD.t8 sg13_lv_pmos ad=1.8716p pd=12.115u as=93.45f ps=0.865u w=0.42u l=0.13u
X4106 VSS.t239 sg13cmos5l_inv_1_1.A a_14152_14484# VSS.t238 sg13_lv_nmos ad=0.14875p pd=1.16u as=0.187p ps=1.78u w=0.55u l=0.13u
X4107 a_19919_10775# a_19077_10677# a_18660_11016# VDD.t0 sg13_lv_pmos ad=0.2048p pd=1.63u as=0.34p ps=2.68u w=1u l=0.13u
X4108 a_3500_19734# sg13cmos5l_dlygate4sd3_1_50.X VDD.t929 VDD.t270 sg13_lv_pmos ad=0.2856p pd=2.36u as=0.2114p ps=1.54u w=0.84u l=0.13u
X4109 a_9266_7682# sg13cmos5l_nor2_1_2.B VSS.t779 VSS.t2484 sg13_lv_nmos ad=0.1406p pd=1.12u as=0.2886p ps=2.26u w=0.74u l=0.13u
X4110 VSS.t117 sg13cmos5l_buf_1_16.A sg13cmos5l_dlygate4sd3_1_98.A VSS.t118 sg13_lv_nmos ad=0.2516p pd=2.16u as=0.1406p ps=1.12u w=0.74u l=0.13u
X4111 a_20217_19143# a_19275_19031# a_20015_19381# VDD.t231 sg13_lv_pmos ad=93.45f pd=0.865u as=0.2048p ps=1.63u w=0.42u l=0.13u
X4112 a_11770_17472# sg13cmos5l_dlygate4sd3_1_69.A VSS.t382 VSS.t381 sg13_lv_nmos ad=0.1428p pd=1.52u as=79.8f ps=0.8u w=0.42u l=0.13u
X4113 a_15706_13342# sg13cmos5l_nand2_1_1.Y VSS.t576 VSS.t128 sg13_lv_nmos ad=0.1406p pd=1.12u as=0.2516p ps=2.16u w=0.74u l=0.13u
X4114 VDD.t15 VSS.t2147 VDD.t14 VDD.t13 sg13_lv_pmos ad=0.34p pd=2.68u as=0 ps=0 w=1u l=1u
X4115 VDD.t425 VSS.t1622 VDD.t424 VDD.t310 sg13_lv_pmos ad=0.34p pd=2.68u as=0 ps=0 w=1u l=1u
X4116 a_11670_14484# sg13cmos5l_nor3_1_4.A VDD.t1079 VDD.t19 sg13_lv_pmos ad=0.2128p pd=1.5u as=0.3808p ps=2.92u w=1.12u l=0.13u
X4117 sg13cmos5l_a21oi_1_2.A2 sg13cmos5l_nand4_1_18.A a_18206_12218# VSS.t1352 sg13_lv_nmos ad=0.2516p pd=2.16u as=0.1406p ps=1.12u w=0.74u l=0.13u
X4118 VSS.t1911 VDD.t2457 VSS.t1913 VSS.t1912 sg13_lv_nmos ad=79.8f pd=0.8u as=0 ps=0 w=0.42u l=1u
X4119 VSS.t931 sg13cmos5l_dfrbpq_1_28.RESET_B.t14 a_18564_19458# VSS.t2246 sg13_lv_nmos ad=0.1626p pd=1.415u as=60.89999f ps=0.71u w=0.42u l=0.13u
X4120 sg13cmos5l_nand4_1_17.Y sg13cmos5l_nand4_1_5.D VDD.t966 VDD.t16 sg13_lv_pmos ad=0.2128p pd=1.5u as=0.3808p ps=2.92u w=1.12u l=0.13u
X4121 VSS.t124 sg13cmos5l_a21oi_1_12.Y sg13cmos5l_a21o_1_2.B1 VSS.t1337 sg13_lv_nmos ad=0.1463p pd=1.15u as=0.2618p ps=2.22u w=0.77u l=0.13u
X4122 VSS.t26 a_21070_7863# sg13cmos5l_dfrbpq_1_8.D VSS.t480 sg13_lv_nmos ad=0.1426p pd=1.16u as=0.2516p ps=2.16u w=0.74u l=0.13u
X4123 a_18470_17946# a_19275_17519# a_18730_17476# VDD.t310 sg13_lv_pmos ad=0.1428p pd=1.52u as=79.8f ps=0.8u w=0.42u l=0.13u
X4124 VDD.t5 a_17872_5654# a_17817_5535# VDD.t5 sg13_lv_pmos ad=1.96072p pd=12.69u as=93.45f ps=0.865u w=0.42u l=0.13u
X4125 a_6671_7751# a_5829_7653# a_5412_7992# VDD.t8 sg13_lv_pmos ad=0.2048p pd=1.63u as=0.34p ps=2.68u w=1u l=0.13u
X4126 VSS.t369 a_5626_19738# a_5345_19960# VSS.t2464 sg13_lv_nmos ad=79.8f pd=0.8u as=0.1428p ps=1.52u w=0.42u l=0.5u
X4127 VSS.t1693 VDD.t2527 VSS.t1695 VSS.t1694 sg13_lv_nmos ad=79.8f pd=0.8u as=0 ps=0 w=0.42u l=1u
X4128 VDD.t1172 sg13cmos5l_dfrbpq_1_45.Q a_7912_12972# VDD.t83 sg13_lv_pmos ad=0.2114p pd=1.54u as=0.2856p ps=2.36u w=0.84u l=0.13u
X4129 a_6640_9406# sg13cmos5l_dfrbpq_1_13.RESET_B VDD.t52 VDD.t52 sg13_lv_pmos ad=79.8f pd=0.8u as=1.79022p ps=11.585u w=0.42u l=0.13u
X4130 VSS.t1971 VDD.t13 VSS.t1966 VSS.t1970 sg13_lv_nmos ad=0.1428p pd=1.52u as=0 ps=0 w=0.42u l=1u
X4131 VSS.t117 a_20384_18433# sg13cmos5l_dlygate4sd3_1_72.A VSS.t118 sg13_lv_nmos ad=0.1406p pd=1.12u as=0.2516p ps=2.16u w=0.74u l=0.13u
X4132 VSS.t493 a_5157_14495# a_5259_14495# VSS.t492 sg13_lv_nmos ad=6.40482p pd=41.475u as=0.2516p ps=2.16u w=0.74u l=0.13u
X4133 VSS.t825 VDD.t2450 VSS.t825 VSS.t1942 sg13_lv_nmos ad=0.1428p pd=1.52u as=0 ps=0 w=0.42u l=1u
X4134 VDD.t10 VSS.t1872 VDD.t569 VDD.t8 sg13_lv_pmos ad=0.19p pd=1.38u as=0 ps=0 w=1u l=1u
X4135 a_20110_19959# a_20225_19960# VDD.t1800 VDD.t270 sg13_lv_pmos ad=0.34p pd=2.68u as=0.2254p ps=1.53u w=1u l=0.5u
X4136 sg13cmos5l_mux2_1_1.A0 sg13cmos5l_a21oi_1_27.A1 a_9651_11808# VSS.t908 sg13_lv_nmos ad=0.1406p pd=1.12u as=0.1406p ps=1.12u w=0.74u l=0.13u
X4137 VDD.t543 VSS.t1058 VDD.t542 VDD.t52 sg13_lv_pmos ad=0.34p pd=2.68u as=0 ps=0 w=1u l=1u
X4138 a_7908_10373# a_8139_9959# a_7594_9916# VSS.t814 sg13_lv_nmos ad=0.2373p pd=1.97u as=79.8f ps=0.8u w=0.42u l=0.13u
X4139 sg13cmos5l_a21oi_1_2.Y sg13cmos5l_inv_1_7.Y a_19923_4248# VSS.t678 sg13_lv_nmos ad=0.1406p pd=1.12u as=0.1406p ps=1.12u w=0.74u l=0.13u
X4140 a_11026_5850# sg13cmos5l_dfrbpq_1_13.RESET_B VSS.t279 VSS.t1221 sg13_lv_nmos ad=37.8f pd=0.6u as=79.8f ps=0.8u w=0.42u l=0.13u
X4141 a_18575_8797# a_17733_8447# a_18481_8797# VSS.t1577 sg13_lv_nmos ad=0.12665p pd=1.145u as=0.1428p ps=1.52u w=0.42u l=0.13u
X4142 sg13cmos5l_dfrbpq_1_28.Q a_22506_12508# VSS.t887 VSS.t16 sg13_lv_nmos ad=0.2516p pd=2.16u as=0.1406p ps=1.12u w=0.74u l=0.13u
X4143 VSS.t72 a_21646_15423# sg13cmos5l_buf_1_1.A VSS.t495 sg13_lv_nmos ad=0.1426p pd=1.16u as=0.2516p ps=2.16u w=0.74u l=0.13u
X4144 a_8411_15532# sg13cmos5l_a21oi_1_12.A2 VDD.t809 VDD.t16 sg13_lv_pmos ad=0.3808p pd=2.92u as=0.2128p ps=1.5u w=1.12u l=0.13u
X4145 VSS.t46 VDD.t2536 VSS.t653 VSS.t1680 sg13_lv_nmos ad=79.8f pd=0.8u as=0 ps=0 w=0.42u l=1u
X4146 VDD.t1482 sg13cmos5l_inv_1_15.A a_12616_14484# VDD.t19 sg13_lv_pmos ad=0.2114p pd=1.54u as=0.2856p ps=2.36u w=0.84u l=0.13u
X4147 sg13cmos5l_inv_1_33.Y sg13cmos5l_dfrbpq_1_5.CLK VDD.t1919 VDD.t270 sg13_lv_pmos ad=0.3808p pd=2.92u as=0.3808p ps=2.92u w=1.12u l=0.13u
X4148 VDD.t1077 a_16172_15960# sg13cmos5l_a21oi_1_18.B1 VDD.t16 sg13_lv_pmos ad=0.2114p pd=1.54u as=0.42p ps=2.99u w=1.12u l=0.13u
X4149 VSS.t1658 VDD.t2545 VSS.t1658 VSS.t1657 sg13_lv_nmos ad=0.1428p pd=1.52u as=0 ps=0 w=0.42u l=1u
X4150 a_11576_7972# sg13cmos5l_nor4_1_0.C a_11474_7972# VDD.t8 sg13_lv_pmos ad=0.2128p pd=1.5u as=0.2128p ps=1.5u w=1.12u l=0.13u
X4151 VSS.t15 sg13cmos5l_buf_1_7.X a_20388_8874# VSS.t29 sg13_lv_nmos ad=0.1626p pd=1.415u as=60.89999f ps=0.71u w=0.42u l=0.13u
X4152 sg13cmos5l_o21ai_1_23.A2 sg13cmos5l_o21ai_1_5.A1 VSS.t239 VSS.t981 sg13_lv_nmos ad=0.1406p pd=1.12u as=0.2516p ps=2.16u w=0.74u l=0.13u
X4153 sg13cmos5l_a21oi_1_8.A2 sg13cmos5l_nand2_1_3.Y VDD.t1213 VDD.t2 sg13_lv_pmos ad=0.2128p pd=1.5u as=0.3808p ps=2.92u w=1.12u l=0.13u
X4154 a_6490_19738# sg13cmos5l_dfrbpq_1_25.Q VSS.t1132 VSS.t2420 sg13_lv_nmos ad=0.1428p pd=1.52u as=79.8f ps=0.8u w=0.42u l=0.13u
X4155 VSS.t132 a_18682_16714# a_18401_16936# VSS.t961 sg13_lv_nmos ad=79.8f pd=0.8u as=0.1428p ps=1.52u w=0.42u l=0.5u
X4156 a_17002_15457# a_17445_15213# a_16742_15234# VSS.t135 sg13_lv_nmos ad=79.8f pd=0.8u as=0.1296p ps=1.52u w=0.42u l=0.13u
X4157 VDD.t2044 a_8006_7678# a_8118_7742# VDD.t8 sg13_lv_pmos ad=0.2254p pd=1.53u as=0.34p ps=2.68u w=1u l=0.5u
X4158 a_17318_11898# sg13cmos5l_dlygate4sd3_1_13.X VDD.t2285 VDD.t0 sg13_lv_pmos ad=79.8f pd=0.8u as=0.1428p ps=1.52u w=0.42u l=0.13u
X4159 a_13042_4646# sg13cmos5l_o21ai_1_0.B1 sg13cmos5l_o21ai_1_0.Y VSS.t2488 sg13_lv_nmos ad=0.1406p pd=1.12u as=0.2516p ps=2.16u w=0.74u l=0.15u
X4160 VSS.t206 a_14133_5459# a_13212_5773# VSS.t2349 sg13_lv_nmos ad=0.1626p pd=1.415u as=0.2516p ps=2.16u w=0.74u l=0.13u
X4161 a_10124_11424# sg13cmos5l_o21ai_1_5.A1 VSS.t50 VSS.t979 sg13_lv_nmos ad=0.187p pd=1.78u as=0.14875p ps=1.16u w=0.55u l=0.13u
X4162 VDD.t675 sg13cmos5l_buf_1_2.A a_20104_3176# VDD.t13 sg13_lv_pmos ad=0.2114p pd=1.54u as=0.2856p ps=2.36u w=0.84u l=0.13u
X4163 a_21370_6130# sg13cmos5l_dlygate4sd3_1_28.A VDD.t1069 VDD.t2 sg13_lv_pmos ad=0.1428p pd=1.52u as=0.1523p ps=1.38u w=0.42u l=0.13u
X4164 a_12814_13239# a_12929_13238# VSS.t159 VSS.t149 sg13_lv_nmos ad=0.1428p pd=1.52u as=0.1426p ps=1.16u w=0.42u l=0.5u
X4165 a_9096_15996# sg13cmos5l_o21ai_1_5.A2 VSS.t48 VSS.t864 sg13_lv_nmos ad=0.1045p pd=0.93u as=0.16755p ps=1.165u w=0.55u l=0.13u
X4166 VDD.t2081 sg13cmos5l_inv_1_24.A sg13cmos5l_inv_1_24.Y VDD.t19 sg13_lv_pmos ad=0.3808p pd=2.92u as=0.3808p ps=2.92u w=1.12u l=0.13u
X4167 VDD.t0 a_7173_11471# a_7275_11471# VDD.t0 sg13_lv_pmos ad=2.1916p pd=14.26u as=0.3864p ps=2.93u w=1.12u l=0.13u
X4168 a_9394_8814# sg13cmos5l_nor3_1_2.B VSS.t190 VSS.t553 sg13_lv_nmos ad=0.2516p pd=2.16u as=0.1406p ps=1.12u w=0.74u l=0.15u
X4169 sg13cmos5l_nand3_1_2.A a_14253_13320# VSS.t245 VSS.t1394 sg13_lv_nmos ad=0.2516p pd=2.16u as=0.1331p ps=1.12u w=0.74u l=0.13u
X4170 a_6682_15960# sg13cmos5l_o21ai_1_12.Y VDD.t877 VDD.t16 sg13_lv_pmos ad=0.1428p pd=1.52u as=0.1523p ps=1.38u w=0.42u l=0.13u
X4171 VDD.t441 VSS.t1204 VDD.t153 VDD.t5 sg13_lv_pmos ad=0.19p pd=1.38u as=0 ps=0 w=1u l=1u
X4172 a_17710_17775# a_17825_17774# VDD.t710 VDD.t310 sg13_lv_pmos ad=0.34p pd=2.68u as=0.2254p ps=1.53u w=1u l=0.5u
X4173 a_17316_15247# a_17028_15552# a_17254_15247# VSS.t135 sg13_lv_nmos ad=0.1428p pd=1.52u as=37.8f ps=0.6u w=0.42u l=0.13u
X4174 a_9885_7194# sg13cmos5l_nand2b_1_1.A_N VSS.t779 VSS.t2225 sg13_lv_nmos ad=0.187p pd=1.78u as=0.14505p ps=1.15u w=0.55u l=0.13u
X4175 a_7158_8802# sg13cmos5l_dfrbpq_1_15.Q sg13cmos5l_nor3_1_2.C VSS.t775 sg13_lv_nmos ad=0.1406p pd=1.12u as=0.2516p ps=2.16u w=0.74u l=0.13u
X4176 VSS.t86 sg13cmos5l_nand2_1_0.B a_14264_10702# VSS.t1023 sg13_lv_nmos ad=79.8f pd=0.8u as=0.1428p ps=1.52u w=0.42u l=0.13u
X4177 a_14039_5459# a_13343_5383# a_14133_5459# VSS.t277 sg13_lv_nmos ad=0.1296p pd=1.52u as=79.8f ps=0.8u w=0.42u l=0.13u
X4178 VDD.t719 a_19930_4618# a_19649_4840# VDD.t5 sg13_lv_pmos ad=0.1523p pd=1.38u as=0.34p ps=2.68u w=1u l=0.5u
X4179 a_17378_7674# sg13cmos5l_buf_1_13.A VSS.t31 VSS.t2365 sg13_lv_nmos ad=60.89999f pd=0.71u as=0.1626p ps=1.415u w=0.42u l=0.13u
X4180 a_19017_8065# a_18660_7992# VDD.t374 VDD.t8 sg13_lv_pmos ad=63f pd=0.72u as=0.1563p ps=1.22u w=0.42u l=0.13u
X4181 a_5784_15976# sg13cmos5l_o21ai_1_9.A2 VDD.t1688 VDD.t16 sg13_lv_pmos ad=0.2128p pd=1.5u as=0.3808p ps=2.92u w=1.12u l=0.15u
X4182 a_6286_8703# a_6401_8702# VDD.t766 VDD.t8 sg13_lv_pmos ad=0.34p pd=2.68u as=0.2254p ps=1.53u w=1u l=0.5u
X4183 a_22041_14607# a_21099_14495# a_21839_14845# VDD.t19 sg13_lv_pmos ad=93.45f pd=0.865u as=0.2048p ps=1.63u w=0.42u l=0.13u
X4184 VDD.t702 sg13cmos5l_inv_1_16.A a_21160_12972# VDD.t83 sg13_lv_pmos ad=0.2114p pd=1.54u as=0.2856p ps=2.36u w=0.84u l=0.13u
X4185 VSS.t479 a_21370_6130# a_21089_6352# VSS.t258 sg13_lv_nmos ad=79.8f pd=0.8u as=0.1428p ps=1.52u w=0.42u l=0.5u
X4186 a_3776_18433# a_3895_18222# VSS.t1108 VSS.t1264 sg13_lv_nmos ad=0.2516p pd=2.16u as=0.1406p ps=1.12u w=0.74u l=0.13u
X4187 a_17051_15996# sg13cmos5l_a21oi_1_19.A2 VDD.t683 VDD.t16 sg13_lv_pmos ad=0.3808p pd=2.92u as=0.2128p ps=1.5u w=1.12u l=0.13u
X4188 a_9444_12210# sg13cmos5l_mux2_1_1.X a_9350_12210# VSS.t1559 sg13_lv_nmos ad=60.89999f pd=0.71u as=0.1428p ps=1.52u w=0.42u l=0.13u
X4189 VDD.t656 a_1690_9154# a_1409_9376# VDD.t52 sg13_lv_pmos ad=0.1523p pd=1.38u as=0.34p ps=2.68u w=1u l=0.5u
X4190 a_9765_5423# sg13cmos5l_dfrbpq_1_13.CLK VDD.t5 VDD.t5 sg13_lv_pmos ad=0.4088p pd=2.97u as=1.8716p ps=12.115u w=1.12u l=0.13u
X4191 sg13cmos5l_nand2b_1_5.Y a_8955_9228# a_9157_9190# VSS.t2211 sg13_lv_nmos ad=0.333p pd=2.38u as=0.1406p ps=1.12u w=0.74u l=0.13u
X4192 VSS.t97 a_15480_8752# sg13cmos5l_dfrbpq_1_2.D VSS.t2397 sg13_lv_nmos ad=0.1469p pd=1.155u as=0.2516p ps=2.16u w=0.74u l=0.13u
X4193 a_15280_17750# sg13cmos5l_buf_1_45.X.t6 VDD.t310 VDD.t310 sg13_lv_pmos ad=79.8f pd=0.8u as=2.1916p ps=14.26u w=0.42u l=0.13u
X4194 a_15760_19990# a_15503_19847# a_15922_19770# VSS.t166 sg13_lv_nmos ad=0.1428p pd=1.52u as=37.8f ps=0.6u w=0.42u l=0.13u
X4195 a_18662_5850# sg13cmos5l_dfrbpq_1_1.D VDD.t1844 VDD.t5 sg13_lv_pmos ad=79.8f pd=0.8u as=0.1428p ps=1.52u w=0.42u l=0.13u
X4196 a_14133_5459# a_13191_5499# a_14039_5459# VDD.t5 sg13_lv_pmos ad=79.8f pd=0.8u as=0.1428p ps=1.52u w=0.42u l=0.13u
X4197 VDD.t509 VSS.t468 VDD.t508 VDD.t270 sg13_lv_pmos ad=0.34p pd=2.68u as=0 ps=0 w=1u l=1u
X4198 a_14121_16043# a_13764_16000# VDD.t888 VDD.t16 sg13_lv_pmos ad=63f pd=0.72u as=0.1563p ps=1.22u w=0.42u l=0.13u
X4199 a_5036_13686# sg13cmos5l_buf_1_15.A VDD.t1078 VDD.t19 sg13_lv_pmos ad=0.2856p pd=2.36u as=0.2114p ps=1.54u w=0.84u l=0.13u
X4200 VDD.t237 VSS.t1830 VDD.t245 VDD.t52 sg13_lv_pmos ad=0.34p pd=2.68u as=0 ps=0 w=1u l=1u
X4201 VSS.t779 a_8878_7191# sg13cmos5l_nor2_1_2.A VSS.t2536 sg13_lv_nmos ad=0.1426p pd=1.16u as=0.2516p ps=2.16u w=0.74u l=0.13u
X4202 VSS.t2045 VDD.t2408 VSS.t291 VSS.t2044 sg13_lv_nmos ad=0.1428p pd=1.52u as=0 ps=0 w=0.42u l=1u
X4203 bp1 a_21640_3900# VDD.t721 VDD.t13 sg13_lv_pmos ad=0.42p pd=2.99u as=0.2114p ps=1.54u w=1.12u l=0.13u
X4204 sg13cmos5l_a21oi_1_9.A1 a_12726_6230# VDD.t1271 VDD.t2 sg13_lv_pmos ad=0.4256p pd=3u as=0.2254p ps=1.53u w=1.12u l=0.13u
X4205 a_18832_8678# a_18575_8797# a_18994_8874# VSS.t841 sg13_lv_nmos ad=0.1428p pd=1.52u as=37.8f ps=0.6u w=0.42u l=0.13u
X4206 VDD.t678 sg13cmos5l_a21oi_1_3.A2 a_17621_7972# VDD.t8 sg13_lv_pmos ad=0.2128p pd=1.5u as=0.3808p ps=2.92u w=1.12u l=0.13u
X4207 VDD.t1531 a_21350_19020# a_21462_19044# VDD.t231 sg13_lv_pmos ad=0.2254p pd=1.53u as=0.34p ps=2.68u w=1u l=0.5u
X4208 VDD.t1195 a_22005_16043# a_21084_16357# VDD.t16 sg13_lv_pmos ad=0.36237p pd=2.605u as=0.34p ps=2.68u w=1u l=0.13u
X4209 VSS.t1781 VDD.t2504 VSS.t1780 VSS.t1779 sg13_lv_nmos ad=0.1428p pd=1.52u as=0 ps=0 w=0.42u l=1u
X4210 VDD.t1949 a_7726_10887# sg13cmos5l_dfrbpq_1_14.D VDD.t0 sg13_lv_pmos ad=0.2254p pd=1.53u as=0.4256p ps=3u w=1.12u l=0.13u
X4211 VSS.t132 a_18670_16263# sg13cmos5l_buf_1_57.A VSS.t131 sg13_lv_nmos ad=0.1426p pd=1.16u as=0.2516p ps=2.16u w=0.74u l=0.13u
X4212 sg13cmos5l_o21ai_1_1.B1 sg13cmos5l_inv_1_36.Y VDD.t1805 VDD.t83 sg13_lv_pmos ad=0.2128p pd=1.5u as=0.3808p ps=2.92u w=1.12u l=0.13u
X4213 sg13cmos5l_inv_1_8.A sg13cmos5l_nand2_1_0.A VDD.t1130 VDD.t52 sg13_lv_pmos ad=0.2128p pd=1.5u as=0.2128p ps=1.5u w=1.12u l=0.13u
X4214 VDD.t2030 VSS.t1933 VDD.t946 VDD.t5 sg13_lv_pmos ad=0.19p pd=1.38u as=0 ps=0 w=1u l=1u
X4215 sg13cmos5l_nor3_1_4.A sg13cmos5l_and4_1_1.A VSS.t159 VSS.t66 sg13_lv_nmos ad=0.2516p pd=2.16u as=0.2516p ps=2.16u w=0.74u l=0.13u
X4216 VDD.t83 a_22096_12430# a_22041_12525# VDD.t83 sg13_lv_pmos ad=2.51485p pd=16.46u as=93.45f ps=0.865u w=0.42u l=0.13u
X4217 VDD.t732 sg13cmos5l_buf_1_1.A a_21640_3176# VDD.t13 sg13_lv_pmos ad=0.2114p pd=1.54u as=0.2856p ps=2.36u w=0.84u l=0.13u
X4218 VDD.t1374 a_16454_8436# a_16566_8460# VDD.t8 sg13_lv_pmos ad=0.2254p pd=1.53u as=0.34p ps=2.68u w=1u l=0.5u
X4219 sg13cmos5l_mux2_1_1.A0 sg13cmos5l_a21oi_1_27.B1 a_9557_11460# VDD.t0 sg13_lv_pmos ad=0.3808p pd=2.92u as=0.2128p ps=1.5u w=1.12u l=0.13u
X4220 a_22330_10666# sg13cmos5l_a21oi_1_6.Y VDD.t871 VDD.t0 sg13_lv_pmos ad=0.1428p pd=1.52u as=0.1523p ps=1.38u w=0.42u l=0.13u
X4221 VDD.t1604 a_21531_13342# sg13cmos5l_dfrbpq_1_5.CLK VDD.t83 sg13_lv_pmos ad=0.3864p pd=2.93u as=0.2128p ps=1.5u w=1.12u l=0.13u
X4222 a_22235_5412# sg13cmos5l_a21oi_1_1.A2 VDD.t1002 VDD.t5 sg13_lv_pmos ad=0.3808p pd=2.92u as=0.2128p ps=1.5u w=1.12u l=0.13u
X4223 a_6094_16935# a_6209_16936# VSS.t407 VSS.t1344 sg13_lv_nmos ad=0.1428p pd=1.52u as=0.1426p ps=1.16u w=0.42u l=0.5u
X4224 a_19738_9912# sg13cmos5l_dfrbpq_1_11.Q VSS.t1083 VSS.t1082 sg13_lv_nmos ad=0.1428p pd=1.52u as=79.8f ps=0.8u w=0.42u l=0.13u
X4225 sg13cmos5l_inv_1_19.Y sg13cmos5l_nand2b_1_4.B VSS.t779 VSS.t1051 sg13_lv_nmos ad=0.2516p pd=2.16u as=0.2516p ps=2.16u w=0.74u l=0.13u
X4226 VDD.t1214 sg13cmos5l_nand2_1_3.Y a_8671_7996# VDD.t8 sg13_lv_pmos ad=0.3808p pd=2.92u as=0.2744p ps=1.61u w=1.12u l=0.13u
X4227 sg13cmos5l_inv_1_2.A a_19995_9190# VSS.t15 VSS.t351 sg13_lv_nmos ad=0.1406p pd=1.12u as=0.1406p ps=1.12u w=0.74u l=0.13u
X4228 VSS.t1683 VDD.t2535 VSS.t1682 VSS.t1681 sg13_lv_nmos ad=0.1428p pd=1.52u as=0 ps=0 w=0.42u l=1u
X4229 VSS.t22 sg13cmos5l_buf_1_7.X a_20388_4650# VSS.t21 sg13_lv_nmos ad=0.1626p pd=1.415u as=60.89999f ps=0.71u w=0.42u l=0.13u
X4230 a_12646_19445# sg13cmos5l_buf_1_45.X.t11 VSS.t107 VSS.t425 sg13_lv_nmos ad=37.8f pd=0.6u as=0.1701p ps=1.65u w=0.42u l=0.13u
X4231 a_7498_18226# sg13cmos5l_buf_8_2.A.t7 VDD.t1740 VDD.t231 sg13_lv_pmos ad=0.2128p pd=1.5u as=0.2128p ps=1.5u w=1.12u l=0.13u
X4232 VSS.t79 sg13cmos5l_inv_1_15.A a_12616_14484# VSS.t1106 sg13_lv_nmos ad=0.14875p pd=1.16u as=0.187p ps=1.78u w=0.55u l=0.13u
X4233 a_20015_17869# a_19173_17519# a_19921_17869# VSS.t225 sg13_lv_nmos ad=0.12665p pd=1.145u as=0.1428p ps=1.52u w=0.42u l=0.13u
X4234 a_5892_13397# a_6123_12983# a_5578_12940# VSS.t158 sg13_lv_nmos ad=0.2373p pd=1.97u as=79.8f ps=0.8u w=0.42u l=0.13u
X4235 a_17386_6892# a_17829_6935# a_17769_6971# VDD.t2 sg13_lv_pmos ad=79.8f pd=0.8u as=63f ps=0.72u w=0.42u l=0.13u
X4236 sg13cmos5l_dfrbpq_1_48.Q a_12906_18556# VDD.t1520 VDD.t231 sg13_lv_pmos ad=0.3808p pd=2.92u as=0.2128p ps=1.5u w=1.12u l=0.13u
X4237 VDD.t855 a_7354_16714# a_7073_16936# VDD.t310 sg13_lv_pmos ad=0.1523p pd=1.38u as=0.34p ps=2.68u w=1u l=0.5u
X4238 a_12406_15230# sg13cmos5l_nand2_1_15.B VSS.t79 VSS.t1396 sg13_lv_nmos ad=0.1406p pd=1.12u as=0.1406p ps=1.12u w=0.74u l=0.15u
X4239 a_20026_15202# sg13cmos5l_dlygate4sd3_1_74.A VDD.t1070 VDD.t16 sg13_lv_pmos ad=0.1428p pd=1.52u as=0.1523p ps=1.38u w=0.42u l=0.13u
X4240 VDD.t8 a_17733_8447# a_17835_8447# VDD.t8 sg13_lv_pmos ad=1.8716p pd=12.115u as=0.3864p ps=2.93u w=1.12u l=0.13u
X4241 a_10530_17874# sg13cmos5l_nor2b_1_1.A a_10428_17874# VSS.t44 sg13_lv_nmos ad=0.1406p pd=1.12u as=0.1406p ps=1.12u w=0.74u l=0.13u
X4242 a_18302_16362# sg13cmos5l_nand4_1_18.B a_18200_16362# VSS.t2283 sg13_lv_nmos ad=0.1406p pd=1.12u as=0.1406p ps=1.12u w=0.74u l=0.13u
X4243 VSS.t120 sg13cmos5l_buf_1_14.A a_15592_10736# VSS.t223 sg13_lv_nmos ad=0.14875p pd=1.16u as=0.187p ps=1.78u w=0.55u l=0.13u
X4244 a_17638_7349# sg13cmos5l_buf_1_7.X VSS.t31 VSS.t33 sg13_lv_nmos ad=37.8f pd=0.6u as=0.1701p ps=1.65u w=0.42u l=0.13u
X4245 VDD.t1170 a_22522_7642# a_22241_7864# VDD.t8 sg13_lv_pmos ad=0.1523p pd=1.38u as=0.34p ps=2.68u w=1u l=0.5u
X4246 a_22107_17137# a_21215_17016# a_22005_16904# VDD.t310 sg13_lv_pmos ad=63f pd=0.72u as=79.8f ps=0.8u w=0.42u l=0.13u
X4247 sg13cmos5l_a21oi_1_12.A2 sg13cmos5l_nor2b_1_1.A VSS.t46 VSS.t45 sg13_lv_nmos ad=0.1406p pd=1.12u as=0.2516p ps=2.16u w=0.74u l=0.13u
X4248 VDD.t1186 sg13cmos5l_buf_1_17.X a_3512_9989# VDD.t52 sg13_lv_pmos ad=0.1523p pd=1.38u as=0.1428p ps=1.52u w=0.42u l=0.13u
X4249 VSS.t1605 VDD.t2564 VSS.t1604 VSS.t1603 sg13_lv_nmos ad=0.1428p pd=1.52u as=0 ps=0 w=0.42u l=1u
X4250 VDD.t231 a_12496_18478# a_12441_18573# VDD.t231 sg13_lv_pmos ad=1.54512p pd=9.865u as=93.45f ps=0.865u w=0.42u l=0.13u
X4251 VDD.t1236 sg13cmos5l_buf_1_66.X a_7196_15552# VDD.t16 sg13_lv_pmos ad=0.3808p pd=2.92u as=0.2128p ps=1.5u w=1.12u l=0.15u
X4252 a_15405_11808# sg13cmos5l_inv_1_36.Y VDD.t1804 VDD.t0 sg13_lv_pmos ad=0.1596p pd=1.22u as=0.2856p ps=2.36u w=0.84u l=0.13u
X4253 VDD.t869 sg13cmos5l_dfrbpq_1_28.RESET_B.t4 a_20294_13722# VDD.t19 sg13_lv_pmos ad=0.36237p pd=2.605u as=79.8f ps=0.8u w=0.42u l=0.13u
X4254 sg13cmos5l_dfrbpq_1_18.Q a_11562_12508# VDD.t667 VDD.t83 sg13_lv_pmos ad=0.3808p pd=2.92u as=0.2128p ps=1.5u w=1.12u l=0.13u
X4255 VSS.t1973 VDD.t269 VSS.t1973 VSS.t1974 sg13_lv_nmos ad=0.1428p pd=1.52u as=0 ps=0 w=0.42u l=1u
X4256 a_11759_10309# a_10917_9959# a_11665_10309# VSS.t607 sg13_lv_nmos ad=0.12665p pd=1.145u as=0.1428p ps=1.52u w=0.42u l=0.13u
X4257 VDD.t566 VSS.t1877 VDD.t1908 VDD.t8 sg13_lv_pmos ad=0.19p pd=1.38u as=0 ps=0 w=1u l=1u
X4258 VSS.t134 sg13cmos5l_nand4_1_5.D a_17346_16754# VSS.t509 sg13_lv_nmos ad=0.2516p pd=2.16u as=0.1406p ps=1.12u w=0.74u l=0.13u
X4259 a_20506_19738# sg13cmos5l_dfrbpq_1_40.Q VSS.t1099 VSS.t1055 sg13_lv_nmos ad=0.1428p pd=1.52u as=79.8f ps=0.8u w=0.42u l=0.13u
X4260 VSS.t1132 a_6191_19381# a_6858_19020# VSS.t1301 sg13_lv_nmos ad=0.1406p pd=1.12u as=0.2516p ps=2.16u w=0.74u l=0.13u
X4261 VDD.t594 VSS.t362 VDD.t593 VDD.t52 sg13_lv_pmos ad=0.34p pd=2.68u as=0 ps=0 w=1u l=1u
X4262 sg13cmos5l_dfrbpq_1_9.Q a_19338_6924# VSS.t19 VSS.t2374 sg13_lv_nmos ad=0.2516p pd=2.16u as=0.1406p ps=1.12u w=0.74u l=0.13u
X4263 a_8942_7656# sg13cmos5l_inv_1_19.Y sg13cmos5l_dlygate4sd3_1_43.A VSS.t881 sg13_lv_nmos ad=96.2f pd=1u as=0.2664p ps=1.46u w=0.74u l=0.13u
X4264 a_17604_8861# a_17316_8440# a_17542_8861# VSS.t603 sg13_lv_nmos ad=0.1428p pd=1.52u as=37.8f ps=0.6u w=0.42u l=0.13u
X4265 sg13cmos5l_dlygate4sd3_1_65.A a_9450_19020# VSS.t1155 VSS.t1164 sg13_lv_nmos ad=0.2516p pd=2.16u as=0.1406p ps=1.12u w=0.74u l=0.13u
X4266 VDD.t1600 a_21531_13342# sg13cmos5l_dfrbpq_1_5.CLK VDD.t83 sg13_lv_pmos ad=0.2128p pd=1.5u as=0.2128p ps=1.5u w=1.12u l=0.13u
X4267 a_10607_5773# a_9765_5423# a_9348_5416# VDD.t5 sg13_lv_pmos ad=0.2048p pd=1.63u as=0.34p ps=2.68u w=1u l=0.13u
X4268 a_7090_7674# sg13cmos5l_dfrbpq_1_13.RESET_B VSS.t702 VSS.t1217 sg13_lv_nmos ad=37.8f pd=0.6u as=79.8f ps=0.8u w=0.42u l=0.13u
X4269 VSS.t15 a_22126_9375# sg13cmos5l_buf_1_10.A VSS.t341 sg13_lv_nmos ad=0.1426p pd=1.16u as=0.2516p ps=2.16u w=0.74u l=0.13u
X4270 a_22522_3106# sg13cmos5l_dlygate4sd3_1_0.A VDD.t1200 VDD.t13 sg13_lv_pmos ad=0.1428p pd=1.52u as=0.1523p ps=1.38u w=0.42u l=0.13u
X4271 VDD.t5 a_16773_5423# a_16875_5423# VDD.t5 sg13_lv_pmos ad=1.96072p pd=12.69u as=0.3864p ps=2.93u w=1.12u l=0.13u
X4272 VDD.t83 a_6863_13333# a_7120_13214# VDD.t83 sg13_lv_pmos ad=2.51485p pd=16.46u as=79.8f ps=0.8u w=0.42u l=0.13u
X4273 a_8037_9959# sg13cmos5l_dfrbpq_1_15.CLK VDD.t52 VDD.t52 sg13_lv_pmos ad=0.4088p pd=2.97u as=1.79022p ps=11.585u w=1.12u l=0.13u
X4274 VSS.t1885 VDD.t2469 VSS.t1884 VSS.t1883 sg13_lv_nmos ad=0.1428p pd=1.52u as=0 ps=0 w=0.42u l=1u
X4275 VDD.t1821 sg13cmos5l_nor4_1_1.D a_8844_15424# VDD.t16 sg13_lv_pmos ad=0.4536p pd=2.76u as=0.1596p ps=1.22u w=0.84u l=0.13u
X4276 VSS.t435 a_21350_17508# a_21462_17532# VSS.t225 sg13_lv_nmos ad=0.1426p pd=1.16u as=0.1428p ps=1.52u w=0.42u l=0.5u
X4277 VDD.t1872 sg13cmos5l_nand2_1_12.A sg13cmos5l_nand2_1_12.Y VDD.t310 sg13_lv_pmos ad=0.3808p pd=2.92u as=0.2128p ps=1.5u w=1.12u l=0.13u
X4278 VSS.t56 sg13cmos5l_buf_1_24.A sg13cmos5l_a21oi_1_24.A1 VSS.t1569 sg13_lv_nmos ad=0.2516p pd=2.16u as=0.2516p ps=2.16u w=0.74u l=0.13u
X4279 sg13cmos5l_nor2_1_15.Y sg13cmos5l_nand4_1_7.B a_12458_15996# VDD.t16 sg13_lv_pmos ad=0.3808p pd=2.92u as=0.1176p ps=1.33u w=1.12u l=0.13u
X4280 VDD.t361 sg13cmos5l_buf_1_7.X a_18374_7674# VDD.t8 sg13_lv_pmos ad=0.36237p pd=2.605u as=79.8f ps=0.8u w=0.42u l=0.13u
X4281 VSS.t113 a_15023_17869# a_15690_17508# VSS.t1454 sg13_lv_nmos ad=0.1406p pd=1.12u as=0.2516p ps=2.16u w=0.74u l=0.13u
X4282 VSS.t150 sg13cmos5l_buf_1_45.X.t2 a_13322_13722# VSS.t66 sg13_lv_nmos ad=79.8f pd=0.8u as=37.8f ps=0.6u w=0.42u l=0.13u
X4283 VDD.t703 sg13cmos5l_a21oi_1_23.A2 a_18101_14020# VDD.t19 sg13_lv_pmos ad=0.2128p pd=1.5u as=0.3808p ps=2.92u w=1.12u l=0.13u
X4284 a_20868_10373# a_20580_9952# a_20806_10373# VSS.t753 sg13_lv_nmos ad=0.1428p pd=1.52u as=37.8f ps=0.6u w=0.42u l=0.13u
X4285 a_20294_10386# a_21099_9959# a_20554_9916# VDD.t52 sg13_lv_pmos ad=0.1428p pd=1.52u as=79.8f ps=0.8u w=0.42u l=0.13u
X4286 a_12430_9375# a_12545_9376# VSS.t569 VSS.t568 sg13_lv_nmos ad=0.1428p pd=1.52u as=0.1426p ps=1.16u w=0.42u l=0.5u
X4287 a_21070_7863# a_21185_7864# VSS.t26 VSS.t731 sg13_lv_nmos ad=0.1428p pd=1.52u as=0.1426p ps=1.16u w=0.42u l=0.5u
X4288 VDD.t310 a_20015_17869# a_20272_17750# VDD.t310 sg13_lv_pmos ad=2.1916p pd=14.26u as=79.8f ps=0.8u w=0.42u l=0.13u
X4289 VDD.t629 VSS.t1669 VDD.t628 VDD.t19 sg13_lv_pmos ad=0.34p pd=2.68u as=0 ps=0 w=1u l=1u
X4290 a_19346_13730# sg13cmos5l_nand4_1_18.D VSS.t521 VSS.t128 sg13_lv_nmos ad=0.1406p pd=1.12u as=0.2516p ps=2.16u w=0.74u l=0.13u
X4291 sg13cmos5l_a21oi_1_19.Y sg13cmos5l_buf_1_16.A VSS.t134 VSS.t1405 sg13_lv_nmos ad=0.1406p pd=1.12u as=0.2516p ps=2.16u w=0.74u l=0.13u
X4292 VSS.t248 sg13cmos5l_nor2b_1_0.B_N sg13cmos5l_nor2_1_3.Y VSS.t957 sg13_lv_nmos ad=0.2516p pd=2.16u as=0.1406p ps=1.12u w=0.74u l=0.13u
X4293 VDD.t5 sg13cmos5l_dfrbpq_1_13.CLK a_13343_5383# VDD.t5 sg13_lv_pmos ad=1.8716p pd=12.115u as=0.4088p ps=2.97u w=1.12u l=0.13u
X4294 VDD.t584 VSS.t1918 VDD.t583 VDD.t5 sg13_lv_pmos ad=0.19p pd=1.38u as=0 ps=0 w=1u l=1u
X4295 a_12118_17886# sg13cmos5l_nor2_1_12.Y VSS.t380 VSS.t379 sg13_lv_nmos ad=0.1406p pd=1.12u as=0.1406p ps=1.12u w=0.74u l=0.15u
X4296 a_20580_12528# a_20554_12433# VDD.t708 VDD.t83 sg13_lv_pmos ad=0.34p pd=2.68u as=0.36237p ps=2.605u w=1u l=0.13u
X4297 a_18662_5850# a_19467_5423# a_18922_5380# VDD.t5 sg13_lv_pmos ad=0.1428p pd=1.52u as=79.8f ps=0.8u w=0.42u l=0.13u
X4298 VSS.t1870 VDD.t2472 VSS.t1872 VSS.t1871 sg13_lv_nmos ad=79.8f pd=0.8u as=0 ps=0 w=0.42u l=1u
X4299 VDD.t1690 sg13cmos5l_or4_1_1.X a_10268_17064# VDD.t310 sg13_lv_pmos ad=0.3808p pd=2.92u as=0.2128p ps=1.5u w=1.12u l=0.15u
X4300 VDD.t1542 a_13690_16714# a_13409_16936# VDD.t310 sg13_lv_pmos ad=0.1523p pd=1.38u as=0.34p ps=2.68u w=1u l=0.5u
X4301 a_16172_15960# sg13cmos5l_buf_1_16.A VSS.t373 VSS.t1404 sg13_lv_nmos ad=0.187p pd=1.78u as=0.14875p ps=1.16u w=0.55u l=0.13u
X4302 VSS.t182 a_5998_13911# sg13cmos5l_dfrbpq_1_24.D VSS.t499 sg13_lv_nmos ad=0.1426p pd=1.16u as=0.2516p ps=2.16u w=0.74u l=0.13u
X4303 VDD.t1110 a_12814_13239# sg13cmos5l_and2_1_6.A VDD.t83 sg13_lv_pmos ad=0.2254p pd=1.53u as=0.4256p ps=3u w=1.12u l=0.13u
X4304 VDD.t638 VSS.t1749 VDD.t637 VDD.t0 sg13_lv_pmos ad=0.19p pd=1.38u as=0 ps=0 w=1u l=1u
X4305 a_5397_18416# a_4455_18476# a_5258_18416# VSS.t1110 sg13_lv_nmos ad=79.8f pd=0.8u as=0.2373p ps=1.97u w=0.42u l=0.13u
X4306 VDD.t1160 a_9934_9375# sg13cmos5l_nand4_1_0.C VDD.t52 sg13_lv_pmos ad=0.2254p pd=1.53u as=0.4256p ps=3u w=1.12u l=0.13u
X4307 VDD.t1787 a_14218_18226# sg13cmos5l_dfrbpq_1_41.CLK VDD.t231 sg13_lv_pmos ad=0.2128p pd=1.5u as=0.2128p ps=1.5u w=1.12u l=0.13u
X4308 VSS.t585 a_4838_15238# a_4950_15302# VSS.t718 sg13_lv_nmos ad=0.1426p pd=1.16u as=0.1428p ps=1.52u w=0.42u l=0.5u
X4309 sg13cmos5l_a21oi_1_16.A2 sg13cmos5l_nand4_1_7.B VDD.t884 VDD.t19 sg13_lv_pmos ad=0.2128p pd=1.5u as=0.2128p ps=1.5u w=1.12u l=0.13u
X4310 VSS.t1832 VDD.t2481 VSS.t1830 VSS.t88 sg13_lv_nmos ad=0.1428p pd=1.52u as=0 ps=0 w=0.42u l=1u
X4311 VSS.t113 sg13cmos5l_buf_1_45.X.t9 a_15588_18258# VSS.t428 sg13_lv_nmos ad=0.1626p pd=1.415u as=60.89999f ps=0.71u w=0.42u l=0.13u
X4312 VDD.t2082 a_18970_14448# a_18689_14750# VDD.t19 sg13_lv_pmos ad=0.1523p pd=1.38u as=0.34p ps=2.68u w=1u l=0.5u
X4313 sg13cmos5l_nand2_1_15.Y sg13cmos5l_nand2_1_15.B VDD.t1762 VDD.t83 sg13_lv_pmos ad=0.2128p pd=1.5u as=0.3808p ps=2.92u w=1.12u l=0.13u
X4314 a_17518_10215# a_17633_10214# VSS.t174 VSS.t2456 sg13_lv_nmos ad=0.1428p pd=1.52u as=0.1426p ps=1.16u w=0.42u l=0.5u
X4315 VSS.t384 sg13cmos5l_dfrbpq_1_23.Q a_4952_17549# VSS.t383 sg13_lv_nmos ad=79.8f pd=0.8u as=0.1428p ps=1.52u w=0.42u l=0.13u
X4316 sg13cmos5l_inv_1_29.Y sg13cmos5l_dfrbpq_1_19.CLK VSS.t69 VSS.t2478 sg13_lv_nmos ad=0.2516p pd=2.16u as=0.2516p ps=2.16u w=0.74u l=0.13u
X4317 VDD.t655 sg13cmos5l_a21oi_1_5.A2 a_19733_6924# VDD.t2 sg13_lv_pmos ad=0.2128p pd=1.5u as=0.3808p ps=2.92u w=1.12u l=0.13u
X4318 VSS.t1623 VDD.t2554 VSS.t1622 VSS.t1621 sg13_lv_nmos ad=0.1428p pd=1.52u as=0 ps=0 w=0.42u l=1u
X4319 VSS.t437 a_14926_16935# sg13cmos5l_buf_1_59.A VSS.t436 sg13_lv_nmos ad=0.1426p pd=1.16u as=0.2516p ps=2.16u w=0.74u l=0.13u
X4320 a_12614_6166# a_12344_6166# VDD.t1360 VDD.t2 sg13_lv_pmos ad=0.34p pd=2.68u as=0.1523p ps=1.38u w=1u l=0.5u
X4321 sg13cmos5l_nand2_1_3.Y sg13cmos5l_nor2_1_2.B VDD.t2235 VDD.t2 sg13_lv_pmos ad=0.2128p pd=1.5u as=0.3808p ps=2.92u w=1.12u l=0.13u
X4322 sg13cmos5l_inv_1_2.A a_19995_9190# VSS.t15 VSS.t347 sg13_lv_nmos ad=0.1406p pd=1.12u as=0.1406p ps=1.12u w=0.74u l=0.13u
X4323 VDD.t398 VSS.t1690 VDD.t622 VDD.t19 sg13_lv_pmos ad=0.19p pd=1.38u as=0 ps=0 w=1u l=1u
X4324 a_6958_6477# a_6700_6162# VDD.t2 VDD.t2 sg13_lv_pmos ad=93.45f pd=0.865u as=2.1916p ps=14.26u w=0.42u l=0.13u
X4325 a_10980_18576# a_10954_18481# VDD.t1508 VDD.t231 sg13_lv_pmos ad=0.34p pd=2.68u as=0.36237p ps=2.605u w=1u l=0.13u
X4326 VDD.t519 VSS.t1910 VDD.t518 VDD.t2 sg13_lv_pmos ad=0.34p pd=2.68u as=0 ps=0 w=1u l=1u
X4327 VSS.t779 sg13cmos5l_a21oi_1_9.B1 a_9967_7294# VSS.t2496 sg13_lv_nmos ad=0.14505p pd=1.15u as=0.1406p ps=1.12u w=0.74u l=0.13u
X4328 VDD.t323 VSS.t1627 VDD.t322 VDD.t310 sg13_lv_pmos ad=0.34p pd=2.68u as=0 ps=0 w=1u l=1u
X4329 VDD.t345 VSS.t1660 VDD.t302 VDD.t16 sg13_lv_pmos ad=0.34p pd=2.68u as=0 ps=0 w=1u l=1u
X4330 VDD.t1329 sg13cmos5l_nor2b_1_0.B_N a_12172_10996# VDD.t0 sg13_lv_pmos ad=0.4032p pd=2.96u as=0.1176p ps=1.33u w=1.12u l=0.13u
X4331 VDD.t1311 sg13cmos5l_nand4_1_12.Y a_17717_19020# VDD.t231 sg13_lv_pmos ad=0.2128p pd=1.5u as=0.3808p ps=2.92u w=1.12u l=0.13u
X4332 a_18756_19024# a_19275_19031# a_20015_19381# VSS.t1098 sg13_lv_nmos ad=0.3473p pd=2.71u as=0.12665p ps=1.145u w=0.74u l=0.13u
X4333 a_7482_12214# a_7416_12404# VSS.t663 VSS.t662 sg13_lv_nmos ad=0.3367p pd=1.65u as=0.148p ps=1.14u w=0.74u l=0.13u
X4334 VSS.t1966 VDD.t13 VSS.t1966 VSS.t1965 sg13_lv_nmos ad=0.1428p pd=1.52u as=0 ps=0 w=0.42u l=1u
X4335 a_10913_4676# sg13cmos5l_a21oi_1_9.A1 sg13cmos5l_a21oi_1_9.Y VSS.t692 sg13_lv_nmos ad=0.1406p pd=1.12u as=0.1406p ps=1.12u w=0.74u l=0.13u
X4336 sg13cmos5l_dlygate4sd3_1_76.A sg13cmos5l_inv_1_13.Y a_18195_13748# VSS.t128 sg13_lv_nmos ad=0.1406p pd=1.12u as=0.1406p ps=1.12u w=0.74u l=0.13u
X4337 VSS.t781 sg13cmos5l_buf_1_17.X a_3512_9989# VSS.t2274 sg13_lv_nmos ad=79.8f pd=0.8u as=0.1428p ps=1.52u w=0.42u l=0.13u
X4338 VSS.t1931 VDD.t2453 VSS.t1930 VSS.t1929 sg13_lv_nmos ad=0.1428p pd=1.52u as=0 ps=0 w=0.42u l=1u
X4339 a_8143_7294# a_8061_7194# sg13cmos5l_nand2b_1_4.Y VSS.t746 sg13_lv_nmos ad=0.1406p pd=1.12u as=0.333p ps=2.38u w=0.74u l=0.13u
X4340 sg13cmos5l_dfrbpq_1_11.Q a_19242_8436# VDD.t1029 VDD.t8 sg13_lv_pmos ad=0.3808p pd=2.92u as=0.2128p ps=1.5u w=1.12u l=0.13u
X4341 code0 a_14920_14484# VDD.t816 VDD.t19 sg13_lv_pmos ad=0.42p pd=2.99u as=0.2114p ps=1.54u w=1.12u l=0.13u
X4342 a_17578_11428# a_18021_11471# a_17961_11507# VDD.t0 sg13_lv_pmos ad=79.8f pd=0.8u as=63f ps=0.72u w=0.42u l=0.13u
X4343 VSS.t15 sg13cmos5l_buf_8_2.A.t2 a_19995_9190# VSS.t1383 sg13_lv_nmos ad=0.1406p pd=1.12u as=0.2553p ps=2.17u w=0.74u l=0.13u
X4344 VDD.t310 sg13cmos5l_inv_1_31.A a_21215_17016# VDD.t310 sg13_lv_pmos ad=2.07625p pd=13.51u as=0.4088p ps=2.97u w=1.12u l=0.13u
X4345 VSS.t1785 VDD.t2503 VSS.t1787 VSS.t1786 sg13_lv_nmos ad=79.8f pd=0.8u as=0 ps=0 w=0.42u l=1u
X4346 a_10857_9995# a_10500_9952# VDD.t1568 VDD.t52 sg13_lv_pmos ad=63f pd=0.72u as=0.1563p ps=1.22u w=0.42u l=0.13u
X4347 a_18730_18988# a_19173_19031# a_18470_19458# VSS.t2619 sg13_lv_nmos ad=79.8f pd=0.8u as=0.1296p ps=1.52u w=0.42u l=0.13u
X4348 a_20810_16746# a_20503_16710# a_20716_16746# VSS.t338 sg13_lv_nmos ad=37.8f pd=0.6u as=0.1428p ps=1.52u w=0.42u l=0.13u
X4349 a_12814_13239# a_12929_13238# VDD.t1110 VDD.t83 sg13_lv_pmos ad=0.34p pd=2.68u as=0.2254p ps=1.53u w=1u l=0.5u
X4350 a_13886_6924# sg13cmos5l_a21oi_1_9.A2 a_13434_6887# VDD.t2 sg13_lv_pmos ad=0.1225p pd=1.245u as=0.34p ps=2.68u w=1u l=0.13u
X4351 sg13cmos5l_dfrbpq_1_19.CLK a_7498_18226# VSS.t5 VSS.t2265 sg13_lv_nmos ad=0.1406p pd=1.12u as=0.2516p ps=2.16u w=0.74u l=0.13u
X4352 bp5 a_20872_3176# VSS.t122 VSS.t340 sg13_lv_nmos ad=0.2886p pd=2.26u as=0.14875p ps=1.16u w=0.74u l=0.13u
X4353 a_17124_19783# a_17355_19892# a_16810_19993# VSS.t166 sg13_lv_nmos ad=0.2373p pd=1.97u as=79.8f ps=0.8u w=0.42u l=0.13u
X4354 VSS.t1963 VDD.t2440 VSS.t1962 VSS.t1961 sg13_lv_nmos ad=0.1428p pd=1.52u as=0 ps=0 w=0.42u l=1u
X4355 VDD.t357 a_7238_17508# a_7350_17532# VDD.t310 sg13_lv_pmos ad=0.2254p pd=1.53u as=0.34p ps=2.68u w=1u l=0.5u
X4356 sg13cmos5l_o21ai_1_7.Y sg13cmos5l_o21ai_1_7.B1 VDD.t1017 VDD.t16 sg13_lv_pmos ad=0.2128p pd=1.5u as=0.3808p ps=2.92u w=1.12u l=0.15u
X4357 a_20554_14452# a_20997_14495# a_20937_14531# VDD.t19 sg13_lv_pmos ad=79.8f pd=0.8u as=63f ps=0.72u w=0.42u l=0.13u
X4358 sg13cmos5l_dfrbpq_1_5.CLK a_21531_13342# VSS.t163 VSS.t1244 sg13_lv_nmos ad=0.1406p pd=1.12u as=0.1406p ps=1.12u w=0.74u l=0.13u
X4359 VSS.t1830 VDD.t2486 VSS.t1830 VSS.t88 sg13_lv_nmos ad=0.1428p pd=1.52u as=0 ps=0 w=0.42u l=1u
X4360 a_19642_19738# sg13cmos5l_a21oi_1_25.Y VDD.t1779 VDD.t270 sg13_lv_pmos ad=0.1428p pd=1.52u as=0.1523p ps=1.38u w=0.42u l=0.13u
X4361 a_9202_19458# sg13cmos5l_dfrbpq_1_24.RESET_B VSS.t1130 VSS.t1129 sg13_lv_nmos ad=37.8f pd=0.6u as=79.8f ps=0.8u w=0.42u l=0.13u
X4362 sg13cmos5l_o21ai_1_21.A2 sg13cmos5l_nand4_1_8.B a_10634_17044# VDD.t310 sg13_lv_pmos ad=0.3808p pd=2.92u as=0.1176p ps=1.33u w=1.12u l=0.13u
X4363 a_17015_9577# sg13cmos5l_dfrbpq_1_3.D a_17762_9186# VSS.t2596 sg13_lv_nmos ad=0.1428p pd=1.52u as=60.89999f ps=0.71u w=0.42u l=0.13u
X4364 a_19173_19031# sg13cmos5l_inv_1_31.A VDD.t231 VDD.t231 sg13_lv_pmos ad=0.4088p pd=2.97u as=1.4953p ps=9.545u w=1.12u l=0.13u
X4365 sg13cmos5l_nand2_1_15.B sg13cmos5l_a21oi_1_4.A1 a_13114_14854# VSS.t143 sg13_lv_nmos ad=0.2516p pd=2.16u as=0.1406p ps=1.12u w=0.74u l=0.13u
X4366 VDD.t940 a_10042_6130# a_9761_6352# VDD.t2 sg13_lv_pmos ad=0.1523p pd=1.38u as=0.34p ps=2.68u w=1u l=0.5u
X4367 VDD.t963 sg13cmos5l_nand4_1_5.D sg13cmos5l_a21oi_1_26.A2 VDD.t310 sg13_lv_pmos ad=0.3808p pd=2.92u as=0.2128p ps=1.5u w=1.12u l=0.13u
X4368 a_22096_10190# sg13cmos5l_buf_1_13.X VDD.t52 VDD.t52 sg13_lv_pmos ad=79.8f pd=0.8u as=1.8716p ps=12.115u w=0.42u l=0.13u
X4369 VDD.t720 a_22126_4167# sg13cmos5l_inv_1_7.A VDD.t13 sg13_lv_pmos ad=0.2254p pd=1.53u as=0.4256p ps=3u w=1.12u l=0.13u
X4370 VDD.t1834 VSS.t1882 VDD.t1833 VDD.t8 sg13_lv_pmos ad=0.19p pd=1.38u as=0 ps=0 w=1u l=1u
X4371 a_13679_19381# a_12837_19031# a_12420_19024# VDD.t231 sg13_lv_pmos ad=0.2048p pd=1.63u as=0.34p ps=2.68u w=1u l=0.13u
X4372 a_20294_11898# sg13cmos5l_dlygate4sd3_1_71.X VDD.t709 VDD.t0 sg13_lv_pmos ad=79.8f pd=0.8u as=0.1428p ps=1.52u w=0.42u l=0.13u
X4373 VSS.t1916 VDD.t2456 VSS.t1915 VSS.t1914 sg13_lv_nmos ad=0.1428p pd=1.52u as=0 ps=0 w=0.42u l=1u
X4374 VDD.t310 sg13cmos5l_dfrbpq_1_19.CLK a_4127_17016# VDD.t310 sg13_lv_pmos ad=2.1916p pd=14.26u as=0.4088p ps=2.97u w=1.12u l=0.13u
X4375 a_3722_16746# a_3415_16710# a_3628_16746# VSS.t642 sg13_lv_nmos ad=37.8f pd=0.6u as=0.1428p ps=1.52u w=0.42u l=0.13u
X4376 sg13cmos5l_nor2_1_12.Y sg13cmos5l_o21ai_1_5.A1 VSS.t52 VSS.t980 sg13_lv_nmos ad=0.1406p pd=1.12u as=0.2516p ps=2.16u w=0.74u l=0.13u
X4377 VSS.t585 sg13cmos5l_dlygate4sd3_1_50.A a_4568_15238# VSS.t2235 sg13_lv_nmos ad=79.8f pd=0.8u as=0.1428p ps=1.52u w=0.42u l=0.13u
X4378 VDD.t831 a_19995_9190# sg13cmos5l_inv_1_2.A VDD.t52 sg13_lv_pmos ad=0.2128p pd=1.5u as=0.2128p ps=1.5u w=1.12u l=0.13u
X4379 sg13cmos5l_dfrbpq_1_39.Q a_20682_17508# VSS.t435 VSS.t225 sg13_lv_nmos ad=0.2516p pd=2.16u as=0.1406p ps=1.12u w=0.74u l=0.13u
X4380 VSS.t677 a_22005_16904# a_21084_16710# VSS.t676 sg13_lv_nmos ad=0.1626p pd=1.415u as=0.2516p ps=2.16u w=0.74u l=0.13u
X4381 VSS.t120 a_14534_10702# a_14646_10766# VSS.t2598 sg13_lv_nmos ad=0.1426p pd=1.16u as=0.1428p ps=1.52u w=0.42u l=0.5u
X4382 a_6383_9263# a_5541_9165# a_6289_9263# VSS.t365 sg13_lv_nmos ad=0.12665p pd=1.145u as=0.1428p ps=1.52u w=0.42u l=0.13u
X4383 VSS.t316 a_18382_6351# sg13cmos5l_dlygate4sd3_1_29.X VSS.t285 sg13_lv_nmos ad=0.1426p pd=1.16u as=0.2516p ps=2.16u w=0.74u l=0.13u
X4384 VSS.t948 a_6021_12983# a_6123_12983# VSS.t1535 sg13_lv_nmos ad=6.29922p pd=42.355u as=0.2516p ps=2.16u w=0.74u l=0.13u
X4385 a_18564_19458# sg13cmos5l_dfrbpq_1_35.D a_18470_19458# VSS.t1103 sg13_lv_nmos ad=60.89999f pd=0.71u as=0.1428p ps=1.52u w=0.42u l=0.13u
X4386 VSS.t396 sg13cmos5l_dfrbpq_1_28.RESET_B.t4 a_20388_13722# VSS.t128 sg13_lv_nmos ad=0.1626p pd=1.415u as=60.89999f ps=0.71u w=0.42u l=0.13u
X4387 sg13cmos5l_inv_1_19.Y sg13cmos5l_nand2b_1_4.B VDD.t1433 VDD.t2 sg13_lv_pmos ad=0.3808p pd=2.92u as=0.3808p ps=2.92u w=1.12u l=0.13u
X4388 VSS.t54 sg13cmos5l_nand3b_1_1.C a_10550_16362# VSS.t53 sg13_lv_nmos ad=0.18575p pd=1.26u as=0.1406p ps=1.12u w=0.74u l=0.13u
X4389 VSS.t199 sg13cmos5l_nor4_1_1.D sg13cmos5l_nand4_1_8.B VSS.t1474 sg13_lv_nmos ad=0.23757p pd=2.16u as=0.1406p ps=1.12u w=0.74u l=0.13u
X4390 VDD.t994 sg13cmos5l_dlygate4sd3_1_22.A a_19160_9190# VDD.t52 sg13_lv_pmos ad=0.1523p pd=1.38u as=0.1428p ps=1.52u w=0.42u l=0.13u
X4391 VDD.t1150 a_17615_5773# a_18282_5412# VDD.t5 sg13_lv_pmos ad=0.2128p pd=1.5u as=0.3864p ps=2.93u w=1.12u l=0.13u
X4392 sg13cmos5l_o21ai_1_28.B1 sg13cmos5l_o21ai_1_23.B1 a_12886_15230# VSS.t1510 sg13_lv_nmos ad=0.2516p pd=2.16u as=0.1406p ps=1.12u w=0.74u l=0.15u
X4393 VDD.t56 VSS.t2185 VDD.t55 VDD.t13 sg13_lv_pmos ad=0.19p pd=1.38u as=0 ps=0 w=1u l=1u
X4394 a_16330_5380# a_16773_5423# a_16070_5850# VSS.t2510 sg13_lv_nmos ad=79.8f pd=0.8u as=0.1296p ps=1.52u w=0.42u l=0.13u
X4395 VSS.t306 a_16474_18984# a_16193_19286# VSS.t305 sg13_lv_nmos ad=79.8f pd=0.8u as=0.1428p ps=1.52u w=0.42u l=0.5u
X4396 VDD.t624 VSS.t1690 VDD.t400 VDD.t83 sg13_lv_pmos ad=0.19p pd=1.38u as=0 ps=0 w=1u l=1u
X4397 VDD.t757 sg13cmos5l_inv_1_8.A a_14253_13320# VDD.t83 sg13_lv_pmos ad=0.1918p pd=1.5u as=0.1596p ps=1.22u w=0.84u l=0.13u
X4398 VSS.t1683 VDD.t2529 VSS.t1682 VSS.t1681 sg13_lv_nmos ad=0.1428p pd=1.52u as=0 ps=0 w=0.42u l=1u
X4399 VDD.t52 a_5541_9165# a_5643_9308# VDD.t52 sg13_lv_pmos ad=1.8716p pd=12.115u as=0.3864p ps=2.93u w=1.12u l=0.13u
X4400 a_19995_9190# sg13cmos5l_buf_8_2.A.t2 VDD.t1749 VDD.t52 sg13_lv_pmos ad=0.2128p pd=1.5u as=0.2128p ps=1.5u w=1.12u l=0.13u
X4401 sg13cmos5l_nand2_1_15.Y sg13cmos5l_inv_1_8.A a_14842_13342# VSS.t246 sg13_lv_nmos ad=0.2516p pd=2.16u as=0.1406p ps=1.12u w=0.74u l=0.13u
X4402 a_6958_6162# a_7199_6432# a_6487_6126# VSS.t2394 sg13_lv_nmos ad=0.1428p pd=1.52u as=0.12665p ps=1.145u w=0.42u l=0.13u
X4403 a_10607_19847# a_9765_19749# a_9348_20088# VDD.t270 sg13_lv_pmos ad=0.2048p pd=1.63u as=0.34p ps=2.68u w=1u l=0.13u
X4404 VDD.t52 a_8879_10309# a_9136_10190# VDD.t52 sg13_lv_pmos ad=1.8716p pd=12.115u as=79.8f ps=0.8u w=0.42u l=0.13u
X4405 a_20997_6935# sg13cmos5l_inv_1_2.A VDD.t2 VDD.t2 sg13_lv_pmos ad=0.4088p pd=2.97u as=2.1916p ps=14.26u w=1.12u l=0.13u
X4406 a_19173_17519# sg13cmos5l_inv_1_31.A VSS.t242 VSS.t2298 sg13_lv_nmos ad=0.2516p pd=2.16u as=3.77667p ps=24.67u w=0.74u l=0.13u
X4407 VDD.t2089 a_17109_9344# a_16188_9150# VDD.t52 sg13_lv_pmos ad=0.36237p pd=2.605u as=0.34p ps=2.68u w=1u l=0.13u
X4408 VDD.t1896 VSS.t1923 VDD.t7 VDD.t5 sg13_lv_pmos ad=0.19p pd=1.38u as=0 ps=0 w=1u l=1u
X4409 VDD.t1093 a_14350_10215# sg13cmos5l_nand2_1_0.A VDD.t52 sg13_lv_pmos ad=0.2254p pd=1.53u as=0.4256p ps=3u w=1.12u l=0.13u
X4410 VSS.t176 a_4917_16904# a_3996_16710# VSS.t1342 sg13_lv_nmos ad=0.1626p pd=1.415u as=0.2516p ps=2.16u w=0.74u l=0.13u
X4411 sg13cmos5l_o21ai_1_15.Y sg13cmos5l_o21ai_1_15.B1 VDD.t1647 VDD.t310 sg13_lv_pmos ad=0.2128p pd=1.5u as=0.3808p ps=2.92u w=1.12u l=0.15u
X4412 sg13cmos5l_a21oi_1_14.Y sg13cmos5l_a21oi_1_18.B1 VSS.t636 VSS.t197 sg13_lv_nmos ad=0.1406p pd=1.12u as=0.2516p ps=2.16u w=0.74u l=0.13u
X4413 sg13cmos5l_inv_1_22.Y sg13cmos5l_dfrbpq_1_13.CLK VSS.t569 VSS.t943 sg13_lv_nmos ad=0.2516p pd=2.16u as=0.2516p ps=2.16u w=0.74u l=0.13u
X4414 a_15804_7638# a_15935_7944# a_15223_7638# VDD.t8 sg13_lv_pmos ad=0.34p pd=2.68u as=0.2048p ps=1.63u w=1u l=0.13u
X4415 VSS.t1875 VDD.t2471 VSS.t1877 VSS.t1876 sg13_lv_nmos ad=79.8f pd=0.8u as=0 ps=0 w=0.42u l=1u
X4416 a_21350_19020# a_21080_19061# VDD.t1771 VDD.t231 sg13_lv_pmos ad=0.34p pd=2.68u as=0.1523p ps=1.38u w=1u l=0.5u
X4417 VSS.t31 a_16725_7832# a_15804_7638# VSS.t325 sg13_lv_nmos ad=0.1626p pd=1.415u as=0.2516p ps=2.16u w=0.74u l=0.13u
X4418 VSS.t468 a_3500_19734# code8 VSS.t995 sg13_lv_nmos ad=0.14875p pd=1.16u as=0.2886p ps=2.26u w=0.74u l=0.13u
X4419 sg13cmos5l_a21o_1_2.B1 sg13cmos5l_o21ai_1_5.A2 VSS.t124 VSS.t2614 sg13_lv_nmos ad=0.1694p pd=1.21u as=0.1463p ps=1.15u w=0.77u l=0.13u
X4420 a_20868_11885# a_21099_11471# a_20554_11428# VSS.t2208 sg13_lv_nmos ad=0.2373p pd=1.97u as=79.8f ps=0.8u w=0.42u l=0.13u
X4421 code0 a_14920_14484# VSS.t201 VSS.t330 sg13_lv_nmos ad=0.2886p pd=2.26u as=0.14875p ps=1.16u w=0.74u l=0.13u
X4422 VSS.t583 a_20794_12936# a_20513_13238# VSS.t162 sg13_lv_nmos ad=79.8f pd=0.8u as=0.1428p ps=1.52u w=0.42u l=0.5u
X4423 a_20388_12210# sg13cmos5l_dfrbpq_1_28.D a_20294_12210# VSS.t178 sg13_lv_nmos ad=60.89999f pd=0.71u as=0.1428p ps=1.52u w=0.42u l=0.13u
X4424 VDD.t717 sg13cmos5l_and4_1_1.A a_7064_14525# VDD.t19 sg13_lv_pmos ad=0.1523p pd=1.38u as=0.1428p ps=1.52u w=0.42u l=0.13u
X4425 a_9348_5416# a_9322_5380# VDD.t1298 VDD.t5 sg13_lv_pmos ad=0.34p pd=2.68u as=0.36237p ps=2.605u w=1u l=0.13u
X4426 sg13cmos5l_a21oi_1_27.A2 sg13cmos5l_mux2_1_1.A1 VDD.t932 VDD.t83 sg13_lv_pmos ad=0.2128p pd=1.5u as=0.2198p ps=1.53u w=1.12u l=0.13u
X4427 a_16193_10296# sg13cmos5l_a21oi_1_4.A1 sg13cmos5l_dlygate4sd3_1_14.A VSS.t148 sg13_lv_nmos ad=0.1406p pd=1.12u as=0.1406p ps=1.12u w=0.74u l=0.13u
X4428 VSS.t1936 VDD.t2443 VSS.t1935 VSS.t1934 sg13_lv_nmos ad=0.1428p pd=1.52u as=0 ps=0 w=0.42u l=1u
X4429 a_18874_9912# sg13cmos5l_dlygate4sd3_1_18.A VSS.t161 VSS.t558 sg13_lv_nmos ad=0.1428p pd=1.52u as=79.8f ps=0.8u w=0.42u l=0.13u
X4430 VSS.t81 a_17109_9344# a_16188_9150# VSS.t2328 sg13_lv_nmos ad=0.1626p pd=1.415u as=0.2516p ps=2.16u w=0.74u l=0.13u
X4431 VSS.t132 a_19930_15960# a_19649_16262# VSS.t1368 sg13_lv_nmos ad=79.8f pd=0.8u as=0.1428p ps=1.52u w=0.42u l=0.5u
X4432 VSS.t109 a_20176_10918# a_19825_10775# VSS.t108 sg13_lv_nmos ad=79.8f pd=0.8u as=0.1428p ps=1.52u w=0.42u l=0.13u
X4433 VDD.t1414 a_7507_9380# sg13cmos5l_dlygate4sd3_1_42.A VDD.t52 sg13_lv_pmos ad=0.3808p pd=2.92u as=0.3808p ps=2.92u w=1.12u l=0.13u
X4434 VDD.t2246 sg13cmos5l_a21oi_1_9.B1 sg13cmos5l_nand3_1_3.Y VDD.t5 sg13_lv_pmos ad=0.3808p pd=2.92u as=0.2128p ps=1.5u w=1.12u l=0.13u
X4435 a_15404_6888# sg13cmos5l_buf_1_15.A.t1 VDD.t792 VDD.t2 sg13_lv_pmos ad=0.2856p pd=2.36u as=0.2114p ps=1.54u w=0.84u l=0.13u
X4436 a_11337_18649# a_10980_18576# VDD.t1507 VDD.t231 sg13_lv_pmos ad=63f pd=0.72u as=0.1563p ps=1.22u w=0.42u l=0.13u
X4437 a_5230_19959# a_5345_19960# VSS.t369 VSS.t2465 sg13_lv_nmos ad=0.1428p pd=1.52u as=0.1426p ps=1.16u w=0.42u l=0.5u
X4438 a_14661_19749# sg13cmos5l_dfrbpq_1_41.CLK VDD.t270 VDD.t270 sg13_lv_pmos ad=0.4088p pd=2.97u as=2.69447p ps=17.64u w=1.12u l=0.13u
X4439 VSS.t5 a_7498_18226# sg13cmos5l_dfrbpq_1_19.CLK VSS.t2268 sg13_lv_nmos ad=0.1406p pd=1.12u as=0.1406p ps=1.12u w=0.74u l=0.13u
X4440 a_6958_16935# a_7073_16936# VDD.t1663 VDD.t310 sg13_lv_pmos ad=0.34p pd=2.68u as=0.2254p ps=1.53u w=1u l=0.5u
X4441 VSS.t161 a_17914_9912# a_17633_10214# VSS.t827 sg13_lv_nmos ad=79.8f pd=0.8u as=0.1428p ps=1.52u w=0.42u l=0.5u
X4442 VDD.t1392 VSS.t2130 VDD.t1391 VDD.t13 sg13_lv_pmos ad=0.19p pd=1.38u as=0 ps=0 w=1u l=1u
X4443 VDD.t991 sg13cmos5l_buf_1_5.A a_19336_3176# VDD.t13 sg13_lv_pmos ad=0.2114p pd=1.54u as=0.2856p ps=2.36u w=0.84u l=0.13u
X4444 VDD.t1336 a_3900_16357# a_4923_16043# VDD.t16 sg13_lv_pmos ad=0.1563p pd=1.22u as=63f ps=0.72u w=0.42u l=0.13u
X4445 sg13cmos5l_a21oi_1_10.Y sg13cmos5l_a21oi_1_9.Y a_9077_6460# VDD.t2 sg13_lv_pmos ad=0.3808p pd=2.92u as=0.2128p ps=1.5u w=1.12u l=0.13u
X4446 VSS.t97 sg13cmos5l_a22oi_1_2.Y a_15480_8752# VSS.t992 sg13_lv_nmos ad=0.187p pd=1.78u as=0.1045p ps=0.93u w=0.55u l=0.13u
X4447 VDD.t494 VSS.t1724 VDD.t490 VDD.t83 sg13_lv_pmos ad=0.19p pd=1.38u as=0 ps=0 w=1u l=1u
X4448 VDD.t1272 a_18478_10215# sg13cmos5l_dlygate4sd3_1_18.X VDD.t52 sg13_lv_pmos ad=0.2254p pd=1.53u as=0.4256p ps=3u w=1.12u l=0.13u
X4449 VDD.t992 sg13cmos5l_buf_1_13.A a_18952_4688# VDD.t5 sg13_lv_pmos ad=0.2114p pd=1.54u as=0.2856p ps=2.36u w=0.84u l=0.13u
X4450 VSS.t293 sg13cmos5l_a21oi_1_9.Y sg13cmos5l_a21oi_1_10.Y VSS.t2258 sg13_lv_nmos ad=0.2516p pd=2.16u as=0.1406p ps=1.12u w=0.74u l=0.13u
X4451 a_7416_12404# sg13cmos5l_mux2_1_0.S VDD.t2014 VDD.t83 sg13_lv_pmos ad=0.2856p pd=2.36u as=0.253p ps=1.53u w=0.84u l=0.13u
X4452 a_11977_9232# sg13cmos5l_nand3_1_0.A VSS.t569 VSS.t2448 sg13_lv_nmos ad=0.1216p pd=1.02u as=0.1331p ps=1.12u w=0.64u l=0.13u
X4453 VDD.t821 a_13390_7863# sg13cmos5l_and4_1_0.D VDD.t8 sg13_lv_pmos ad=0.2254p pd=1.53u as=0.4256p ps=3u w=1.12u l=0.13u
X4454 VDD.t23 VSS.t1867 VDD.t22 VDD.t8 sg13_lv_pmos ad=0.19p pd=1.38u as=0 ps=0 w=1u l=1u
X4455 VSS.t67 sg13cmos5l_dfrbpq_1_45.Q a_7912_12972# VSS.t149 sg13_lv_nmos ad=0.14875p pd=1.16u as=0.187p ps=1.78u w=0.55u l=0.13u
X4456 VDD.t1575 sg13cmos5l_dfrbpq_1_13.RESET_B a_9322_5380# VDD.t5 sg13_lv_pmos ad=0.1563p pd=1.22u as=0.147p ps=1.54u w=0.42u l=0.13u
X4457 VDD.t1864 a_18106_17472# a_17825_17774# VDD.t310 sg13_lv_pmos ad=0.1523p pd=1.38u as=0.34p ps=2.68u w=1u l=0.5u
X4458 VSS.t48 sg13cmos5l_a21oi_1_27.B1 a_9096_15996# VSS.t2286 sg13_lv_nmos ad=0.14135p pd=1.14u as=0.1045p ps=0.93u w=0.55u l=0.13u
X4459 VDD.t1217 a_3782_9948# a_3894_9972# VDD.t52 sg13_lv_pmos ad=0.2254p pd=1.53u as=0.34p ps=2.68u w=1u l=0.5u
X4460 VSS.t76 sg13cmos5l_dfrbpq_1_5.Q a_20984_10702# VSS.t880 sg13_lv_nmos ad=79.8f pd=0.8u as=0.1428p ps=1.52u w=0.42u l=0.13u
X4461 VSS.t136 a_17038_14751# sg13cmos5l_dlygate4sd3_1_81.X VSS.t1223 sg13_lv_nmos ad=0.1426p pd=1.16u as=0.2516p ps=2.16u w=0.74u l=0.13u
X4462 a_7334_10386# a_8139_9959# a_7594_9916# VDD.t52 sg13_lv_pmos ad=0.1428p pd=1.52u as=79.8f ps=0.8u w=0.42u l=0.13u
X4463 VDD.t2091 sg13cmos5l_a21o_1_0.A1 a_11014_9508# VDD.t52 sg13_lv_pmos ad=0.19p pd=1.38u as=0.2125p ps=1.425u w=1u l=0.13u
X4464 a_5220_7674# sg13cmos5l_dlygate4sd3_1_43.X a_5126_7674# VSS.t2538 sg13_lv_nmos ad=60.89999f pd=0.71u as=0.1428p ps=1.52u w=0.42u l=0.13u
X4465 VDD.t8 a_20176_7894# a_20121_7989# VDD.t8 sg13_lv_pmos ad=1.8716p pd=12.115u as=93.45f ps=0.865u w=0.42u l=0.13u
X4466 a_14350_10215# a_14465_10214# VDD.t1093 VDD.t52 sg13_lv_pmos ad=0.34p pd=2.68u as=0.2254p ps=1.53u w=1u l=0.5u
X4467 VDD.t686 sg13cmos5l_a21oi_1_8.Y a_7895_6553# VDD.t2 sg13_lv_pmos ad=0.1428p pd=1.52u as=79.8f ps=0.8u w=0.42u l=0.13u
X4468 VDD.t823 a_20384_16283# sg13cmos5l_dfrbpq_1_30.Q VDD.t16 sg13_lv_pmos ad=0.2128p pd=1.5u as=0.3808p ps=2.92u w=1.12u l=0.13u
X4469 VSS.t1663 VDD.t2539 VSS.t1660 VSS.t1673 sg13_lv_nmos ad=0.1428p pd=1.52u as=0 ps=0 w=0.42u l=1u
X4470 a_7162_6888# sg13cmos5l_dlygate4sd3_1_43.A VSS.t702 VSS.t843 sg13_lv_nmos ad=0.1428p pd=1.52u as=79.8f ps=0.8u w=0.42u l=0.13u
X4471 a_14378_15532# sg13cmos5l_o21ai_1_5.A1 VDD.t1353 VDD.t16 sg13_lv_pmos ad=0.1176p pd=1.33u as=0.4032p ps=2.96u w=1.12u l=0.13u
X4472 VDD.t1072 sg13cmos5l_inv_1_25.Y a_22523_15532# VDD.t16 sg13_lv_pmos ad=0.2128p pd=1.5u as=0.2128p ps=1.5u w=1.12u l=0.13u
X4473 VSS.t1834 VDD.t2485 VSS.t1833 VSS.t88 sg13_lv_nmos ad=0.1428p pd=1.52u as=0 ps=0 w=0.42u l=1u
X4474 bp3 a_21256_3176# VDD.t1174 VDD.t13 sg13_lv_pmos ad=0.42p pd=2.99u as=0.2114p ps=1.54u w=1.12u l=0.13u
X4475 sg13cmos5l_inv_1_5.A a_17098_6130# VSS.t13 VSS.t529 sg13_lv_nmos ad=0.1406p pd=1.12u as=0.1406p ps=1.12u w=0.74u l=0.13u
X4476 a_18948_7687# a_18660_7992# a_18886_7687# VSS.t23 sg13_lv_nmos ad=0.1428p pd=1.52u as=37.8f ps=0.6u w=0.42u l=0.13u
X4477 VDD.t1681 sg13cmos5l_nand4_1_1.A sg13cmos5l_a21oi_1_3.A2 VDD.t19 sg13_lv_pmos ad=0.3808p pd=2.92u as=0.2128p ps=1.5u w=1.12u l=0.13u
X4478 a_18021_11471# sg13cmos5l_dfrbpq_1_13.CLK VSS.t2 VSS.t946 sg13_lv_nmos ad=0.2516p pd=2.16u as=4.21822p ps=27.295u w=0.74u l=0.13u
X4479 a_8637_12508# sg13cmos5l_mux2_1_0.A1 VDD.t738 VDD.t83 sg13_lv_pmos ad=0.3325p pd=1.665u as=0.253p ps=1.53u w=1u l=0.13u
X4480 a_17817_5535# a_16875_5423# a_17615_5773# VDD.t5 sg13_lv_pmos ad=93.45f pd=0.865u as=0.2048p ps=1.63u w=0.42u l=0.13u
X4481 a_20554_6892# a_20997_6935# a_20294_7362# VSS.t251 sg13_lv_nmos ad=79.8f pd=0.8u as=0.1296p ps=1.52u w=0.42u l=0.13u
X4482 a_16091_9948# sg13cmos5l_a21oi_1_4.B1 sg13cmos5l_dlygate4sd3_1_14.A VDD.t52 sg13_lv_pmos ad=0.2128p pd=1.5u as=0.3808p ps=2.92u w=1.12u l=0.13u
X4483 a_18660_7992# a_19179_7796# a_19919_7751# VSS.t336 sg13_lv_nmos ad=0.3473p pd=2.71u as=0.12665p ps=1.145u w=0.74u l=0.13u
X4484 VSS.t1747 VDD.t2507 VSS.t1749 VSS.t1748 sg13_lv_nmos ad=79.8f pd=0.8u as=0 ps=0 w=0.42u l=1u
X4485 VSS.t1921 VDD.t2455 VSS.t1920 VSS.t1919 sg13_lv_nmos ad=0.1428p pd=1.52u as=0 ps=0 w=0.42u l=1u
X4486 a_17715_7700# sg13cmos5l_a21oi_1_3.A2 VSS.t31 VSS.t314 sg13_lv_nmos ad=0.1406p pd=1.12u as=0.2516p ps=2.16u w=0.74u l=0.13u
X4487 VDD.t1127 a_19066_15960# a_18785_16262# VDD.t16 sg13_lv_pmos ad=0.1523p pd=1.38u as=0.34p ps=2.68u w=1u l=0.5u
X4488 VDD.t1028 a_20794_12936# a_20513_13238# VDD.t83 sg13_lv_pmos ad=0.1523p pd=1.38u as=0.34p ps=2.68u w=1u l=0.5u
X4489 VDD.t1937 a_19430_9190# a_19542_9254# VDD.t52 sg13_lv_pmos ad=0.2254p pd=1.53u as=0.34p ps=2.68u w=1u l=0.5u
X4490 VSS.t1981 VDD.t2431 VSS.t1987 VSS.t1986 sg13_lv_nmos ad=79.8f pd=0.8u as=0 ps=0 w=0.42u l=1u
X4491 VDD.t659 sg13cmos5l_dfrbpq_1_13.RESET_B a_5386_7897# VDD.t8 sg13_lv_pmos ad=0.1563p pd=1.22u as=0.147p ps=1.54u w=0.42u l=0.13u
X4492 VSS.t134 sg13cmos5l_nand4_1_5.D a_17922_16754# VSS.t508 sg13_lv_nmos ad=0.2516p pd=2.16u as=0.1406p ps=1.12u w=0.74u l=0.13u
X4493 a_22005_16904# a_21063_16964# a_21911_17137# VDD.t310 sg13_lv_pmos ad=79.8f pd=0.8u as=0.1428p ps=1.52u w=0.42u l=0.13u
X4494 a_6394_13690# sg13cmos5l_o21ai_1_9.Y VSS.t182 VSS.t1399 sg13_lv_nmos ad=0.1428p pd=1.52u as=79.8f ps=0.8u w=0.42u l=0.13u
X4495 a_18782_12218# sg13cmos5l_nand4_1_1.B a_18680_12218# VSS.t1190 sg13_lv_nmos ad=0.1406p pd=1.12u as=0.1406p ps=1.12u w=0.74u l=0.13u
X4496 VSS.t89 VDD.t2483 VSS.t1839 VSS.t88 sg13_lv_nmos ad=0.1428p pd=1.52u as=0 ps=0 w=0.42u l=1u
X4497 VSS.t407 a_6094_16935# sg13cmos5l_dfrbpq_1_19.D VSS.t1355 sg13_lv_nmos ad=0.1426p pd=1.16u as=0.2516p ps=2.16u w=0.74u l=0.13u
X4498 VSS.t1658 VDD.t2545 VSS.t1660 VSS.t1659 sg13_lv_nmos ad=79.8f pd=0.8u as=0 ps=0 w=0.42u l=1u
X4499 a_18882_13730# sg13cmos5l_nand4_1_1.C a_18780_13730# VSS.t128 sg13_lv_nmos ad=0.1406p pd=1.12u as=0.1406p ps=1.12u w=0.74u l=0.13u
X4500 a_10812_14020# sg13cmos5l_buf_1_65.A a_10710_14020# VDD.t19 sg13_lv_pmos ad=0.2128p pd=1.5u as=0.2128p ps=1.5u w=1.12u l=0.13u
X4501 a_18478_10215# a_18593_10214# VDD.t1272 VDD.t52 sg13_lv_pmos ad=0.34p pd=2.68u as=0.2254p ps=1.53u w=1u l=0.5u
X4502 VDD.t1834 VSS.t1879 VDD.t1988 VDD.t8 sg13_lv_pmos ad=0.34p pd=2.68u as=0 ps=0 w=1u l=1u
X4503 a_20503_18222# a_21063_18476# a_20974_18573# VDD.t231 sg13_lv_pmos ad=0.2048p pd=1.63u as=93.45f ps=0.865u w=0.42u l=0.13u
X4504 a_15104_7849# a_15223_7638# VSS.t99 VSS.t2212 sg13_lv_nmos ad=0.2516p pd=2.16u as=0.1406p ps=1.12u w=0.74u l=0.13u
X4505 VSS.t163 sg13cmos5l_inv_1_16.A a_21160_12972# VSS.t162 sg13_lv_nmos ad=0.14875p pd=1.16u as=0.187p ps=1.78u w=0.55u l=0.13u
X4506 VDD.t2288 sg13cmos5l_inv_1_7.A sg13cmos5l_inv_1_7.Y VDD.t13 sg13_lv_pmos ad=0.3808p pd=2.92u as=0.3808p ps=2.92u w=1.12u l=0.13u
X4507 VDD.t529 VSS.t2190 VDD.t27 VDD.t13 sg13_lv_pmos ad=0.19p pd=1.38u as=0 ps=0 w=1u l=1u
X4508 a_6682_8400# sg13cmos5l_dlygate4sd3_1_42.A VDD.t1124 VDD.t8 sg13_lv_pmos ad=0.1428p pd=1.52u as=0.1523p ps=1.38u w=0.42u l=0.13u
X4509 sg13cmos5l_and4_1_1.A a_6666_14484# VDD.t1198 VDD.t19 sg13_lv_pmos ad=0.3808p pd=2.92u as=0.2128p ps=1.5u w=1.12u l=0.13u
X4510 VSS.t1785 VDD.t2493 VSS.t1787 VSS.t1786 sg13_lv_nmos ad=79.8f pd=0.8u as=0 ps=0 w=0.42u l=1u
X4511 VDD.t244 VSS.t1828 VDD.t249 VDD.t52 sg13_lv_pmos ad=0.34p pd=2.68u as=0 ps=0 w=1u l=1u
X4512 VDD.t768 a_21839_4727# a_22506_4948# VDD.t5 sg13_lv_pmos ad=0.2128p pd=1.5u as=0.3864p ps=2.93u w=1.12u l=0.13u
X4513 sg13cmos5l_a21o_1_2.A1 a_7446_14508# VDD.t676 VDD.t19 sg13_lv_pmos ad=0.4256p pd=3u as=0.2254p ps=1.53u w=1.12u l=0.13u
X4514 VSS.t86 a_12987_10318# sg13cmos5l_dfrbpq_1_13.CLK VSS.t1095 sg13_lv_nmos ad=0.2516p pd=2.16u as=0.1406p ps=1.12u w=0.74u l=0.13u
X4515 a_14218_18226# sg13cmos5l_buf_8_2.A.t6 VSS.t113 VSS.t2608 sg13_lv_nmos ad=0.1406p pd=1.12u as=0.1406p ps=1.12u w=0.74u l=0.13u
X4516 a_5554_13718# sg13cmos5l_mux2_1_0.A1 VSS.t182 VSS.t215 sg13_lv_nmos ad=0.2516p pd=2.16u as=0.1406p ps=1.12u w=0.74u l=0.15u
X4517 VSS.t153 a_12987_12214# sg13cmos5l_buf_8_2.A VSS.t2624 sg13_lv_nmos ad=0.1406p pd=1.12u as=0.1406p ps=1.12u w=0.74u l=0.13u
X4518 VSS.t1628 VDD.t2553 VSS.t1627 VSS.t1626 sg13_lv_nmos ad=0.1428p pd=1.52u as=0 ps=0 w=0.42u l=1u
X4519 VSS.t816 a_8037_9959# a_8139_9959# VSS.t815 sg13_lv_nmos ad=4.90217p pd=31.68u as=0.2516p ps=2.16u w=0.74u l=0.13u
X4520 sg13cmos5l_o21ai_1_14.A1 sg13cmos5l_nand3b_1_1.C VDD.t389 VDD.t310 sg13_lv_pmos ad=0.2128p pd=1.5u as=0.2198p ps=1.53u w=1.12u l=0.13u
X4521 a_9290_17044# sg13cmos5l_a21oi_1_27.B1 VDD.t2050 VDD.t310 sg13_lv_pmos ad=0.1176p pd=1.33u as=0.4032p ps=2.96u w=1.12u l=0.13u
X4522 sg13cmos5l_a21oi_1_13.A2 sg13cmos5l_nand4_1_5.D VDD.t967 VDD.t19 sg13_lv_pmos ad=0.2128p pd=1.5u as=0.3808p ps=2.92u w=1.12u l=0.13u
X4523 VSS.t204 sg13cmos5l_buf_1_20.A a_13096_15996# VSS.t203 sg13_lv_nmos ad=0.14875p pd=1.16u as=0.187p ps=1.78u w=0.55u l=0.13u
X4524 sg13cmos5l_a21oi_1_27.A2 a_9147_13028# a_9349_13342# VSS.t149 sg13_lv_nmos ad=0.333p pd=2.38u as=0.1406p ps=1.12u w=0.74u l=0.13u
X4525 VDD.t1639 sg13cmos5l_o21ai_1_17.Y a_11288_19061# VDD.t231 sg13_lv_pmos ad=0.1523p pd=1.38u as=0.1428p ps=1.52u w=0.42u l=0.13u
X4526 VDD.t1773 a_10389_16258# sg13cmos5l_nand3b_1_1.Y VDD.t16 sg13_lv_pmos ad=0.2128p pd=1.5u as=0.3808p ps=2.92u w=1.12u l=0.13u
X4527 a_9993_12601# a_9636_12528# VDD.t1558 VDD.t83 sg13_lv_pmos ad=63f pd=0.72u as=0.1563p ps=1.22u w=0.42u l=0.13u
X4528 VDD.t1997 VSS.t1928 VDD.t1397 VDD.t5 sg13_lv_pmos ad=0.19p pd=1.38u as=0 ps=0 w=1u l=1u
X4529 a_19077_7653# sg13cmos5l_inv_1_2.A VSS.t253 VSS.t267 sg13_lv_nmos ad=0.2516p pd=2.16u as=4.21822p ps=27.295u w=0.74u l=0.13u
X4530 VDD.t2261 a_13679_19381# a_14346_19020# VDD.t231 sg13_lv_pmos ad=0.2128p pd=1.5u as=0.3864p ps=2.93u w=1.12u l=0.13u
X4531 busy a_13768_14484# VDD.t845 VDD.t19 sg13_lv_pmos ad=0.42p pd=2.99u as=0.2114p ps=1.54u w=1.12u l=0.13u
X4532 VSS.t1880 VDD.t2470 VSS.t1882 VSS.t1881 sg13_lv_nmos ad=79.8f pd=0.8u as=0 ps=0 w=0.42u l=1u
X4533 VSS.t1215 sg13cmos5l_dfrbpq_1_13.RESET_B a_4932_9186# VSS.t88 sg13_lv_nmos ad=0.1626p pd=1.415u as=60.89999f ps=0.71u w=0.42u l=0.13u
X4534 a_14842_9154# sg13cmos5l_nor2b_1_0.B_N VSS.t97 VSS.t958 sg13_lv_nmos ad=0.1428p pd=1.52u as=79.8f ps=0.8u w=0.42u l=0.13u
X4535 VSS.t1973 VDD.t2434 VSS.t1973 VSS.t1979 sg13_lv_nmos ad=79.8f pd=0.8u as=0 ps=0 w=0.42u l=1u
X4536 VSS.t702 a_6671_7751# a_7338_7972# VSS.t701 sg13_lv_nmos ad=0.1406p pd=1.12u as=0.2516p ps=2.16u w=0.74u l=0.13u
X4537 VDD.t8 a_18575_8797# a_18832_8678# VDD.t8 sg13_lv_pmos ad=1.8716p pd=12.115u as=79.8f ps=0.8u w=0.42u l=0.13u
X4538 VDD.t864 sg13cmos5l_dfrbpq_1_28.RESET_B a_17002_15457# VDD.t16 sg13_lv_pmos ad=0.1563p pd=1.22u as=0.147p ps=1.54u w=0.42u l=0.13u
X4539 a_10530_14484# sg13cmos5l_nor4_1_4.C a_10428_14484# VDD.t19 sg13_lv_pmos ad=0.2128p pd=1.5u as=0.2128p ps=1.5u w=1.12u l=0.13u
X4540 bn2 a_12232_14484# VDD.t1905 VDD.t19 sg13_lv_pmos ad=0.42p pd=2.99u as=0.2114p ps=1.54u w=1.12u l=0.13u
X4541 a_18382_6351# a_18497_6352# VSS.t316 VSS.t285 sg13_lv_nmos ad=0.1428p pd=1.52u as=0.1426p ps=1.16u w=0.42u l=0.5u
X4542 sg13cmos5l_buf_1_17.X a_1192_8436# VDD.t1295 VDD.t8 sg13_lv_pmos ad=0.42p pd=2.99u as=0.2114p ps=1.54u w=1.12u l=0.13u
X4543 VDD.t2169 a_6958_19959# sg13cmos5l_o21ai_1_20.B1 VDD.t270 sg13_lv_pmos ad=0.2254p pd=1.53u as=0.4256p ps=3u w=1.12u l=0.13u
X4544 VSS.t1790 VDD.t2502 VSS.t1792 VSS.t1791 sg13_lv_nmos ad=79.8f pd=0.8u as=0 ps=0 w=0.42u l=1u
X4545 sg13cmos5l_inv_1_31.A a_19035_16750# VSS.t132 VSS.t444 sg13_lv_nmos ad=0.1406p pd=1.12u as=0.1406p ps=1.12u w=0.74u l=0.13u
X4546 VSS.t2068 VDD.t13 VSS.t2070 VSS.t2069 sg13_lv_nmos ad=79.8f pd=0.8u as=0 ps=0 w=0.42u l=1u
X4547 VSS.t58 sg13cmos5l_o21ai_1_22.Y a_9848_18262# VSS.t114 sg13_lv_nmos ad=79.8f pd=0.8u as=0.1428p ps=1.52u w=0.42u l=0.13u
X4548 a_18660_7992# a_18634_7897# VDD.t361 VDD.t8 sg13_lv_pmos ad=0.34p pd=2.68u as=0.36237p ps=2.605u w=1u l=0.13u
X4549 a_18756_19024# a_18730_18988# VDD.t1757 VDD.t231 sg13_lv_pmos ad=0.34p pd=2.68u as=0.36237p ps=2.605u w=1u l=0.13u
X4550 a_7805_15532# sg13cmos5l_a21oi_1_12.Y sg13cmos5l_a21o_1_2.B1 VDD.t16 sg13_lv_pmos ad=0.2128p pd=1.5u as=0.3808p ps=2.92u w=1.12u l=0.13u
X4551 a_18374_10698# a_19179_10820# a_18634_10921# VDD.t0 sg13_lv_pmos ad=0.1428p pd=1.52u as=79.8f ps=0.8u w=0.42u l=0.13u
X4552 a_14052_16421# a_13764_16000# a_13990_16421# VSS.t955 sg13_lv_nmos ad=0.1428p pd=1.52u as=37.8f ps=0.6u w=0.42u l=0.13u
X4553 VDD.t2211 a_20207_5773# a_20874_5412# VDD.t5 sg13_lv_pmos ad=0.2128p pd=1.5u as=0.3864p ps=2.93u w=1.12u l=0.13u
X4554 VSS.t927 a_15692_18984# code2 VSS.t305 sg13_lv_nmos ad=0.14875p pd=1.16u as=0.2886p ps=2.26u w=0.74u l=0.13u
X4555 a_18982_19445# sg13cmos5l_dfrbpq_1_28.RESET_B.t14 VSS.t931 VSS.t2247 sg13_lv_nmos ad=37.8f pd=0.6u as=0.1701p ps=1.65u w=0.42u l=0.13u
X4556 a_19450_18226# sg13cmos5l_a21oi_1_24.Y VSS.t117 VSS.t116 sg13_lv_nmos ad=0.1428p pd=1.52u as=79.8f ps=0.8u w=0.42u l=0.13u
X4557 VDD.t1292 sg13cmos5l_o21ai_1_26.B1 sg13cmos5l_dlygate4sd3_1_69.A VDD.t310 sg13_lv_pmos ad=0.3808p pd=2.92u as=0.2128p ps=1.5u w=1.12u l=0.15u
X4558 VDD.t5 a_17615_5773# a_17872_5654# VDD.t5 sg13_lv_pmos ad=1.96072p pd=12.69u as=79.8f ps=0.8u w=0.42u l=0.13u
X4559 VSS.t1747 VDD.t2518 VSS.t1749 VSS.t1748 sg13_lv_nmos ad=79.8f pd=0.8u as=0 ps=0 w=0.42u l=1u
X4560 VDD.t287 VSS.t1736 VDD.t286 VDD.t0 sg13_lv_pmos ad=0.34p pd=2.68u as=0 ps=0 w=1u l=1u
X4561 sg13cmos5l_nand2_1_19.A sg13cmos5l_inv_1_18.A VDD.t1048 VDD.t0 sg13_lv_pmos ad=0.2128p pd=1.5u as=0.2128p ps=1.5u w=1.12u l=0.13u
X4562 VDD.t936 a_21358_5679# sg13cmos5l_dfrbpq_1_0.D VDD.t5 sg13_lv_pmos ad=0.2254p pd=1.53u as=0.4256p ps=3u w=1.12u l=0.13u
X4563 VDD.t1124 a_6682_8400# a_6401_8702# VDD.t8 sg13_lv_pmos ad=0.1523p pd=1.38u as=0.34p ps=2.68u w=1u l=0.5u
X4564 a_3879_16083# a_4031_15967# VSS.t674 VSS.t1445 sg13_lv_nmos ad=0.2516p pd=2.16u as=4.4216p ps=27.885u w=0.74u l=0.13u
X4565 VSS.t1803 VDD.t2499 VSS.t1805 VSS.t1804 sg13_lv_nmos ad=79.8f pd=0.8u as=0 ps=0 w=0.42u l=1u
X4566 VSS.t81 sg13cmos5l_buf_1_13.A a_15914_9186# VSS.t2362 sg13_lv_nmos ad=79.8f pd=0.8u as=37.8f ps=0.6u w=0.42u l=0.13u
X4567 sg13cmos5l_dfrbpq_1_38.Q a_15690_17508# VSS.t113 VSS.t1239 sg13_lv_nmos ad=0.2516p pd=2.16u as=0.1406p ps=1.12u w=0.74u l=0.13u
X4568 a_13486_13722# a_13228_13722# VSS.t150 VSS.t66 sg13_lv_nmos ad=0.1428p pd=1.52u as=79.8f ps=0.8u w=0.42u l=0.13u
X4569 VSS.t76 a_21934_10887# sg13cmos5l_dfrbpq_1_7.D VSS.t75 sg13_lv_nmos ad=0.1426p pd=1.16u as=0.2516p ps=2.16u w=0.74u l=0.13u
X4570 VSS.t1906 VDD.t2458 VSS.t1905 VSS.t1904 sg13_lv_nmos ad=0.1428p pd=1.52u as=0 ps=0 w=0.42u l=1u
X4571 VSS.t1865 VDD.t2473 VSS.t1867 VSS.t1866 sg13_lv_nmos ad=79.8f pd=0.8u as=0 ps=0 w=0.42u l=1u
X4572 VDD.t2137 sg13cmos5l_o21ai_1_0.A1 sg13cmos5l_nand3_1_0.A VDD.t8 sg13_lv_pmos ad=0.3808p pd=2.92u as=0.2128p ps=1.5u w=1.12u l=0.15u
X4573 a_7938_16362# sg13cmos5l_nand2_1_11.B a_7836_16362# VSS.t1321 sg13_lv_nmos ad=0.1406p pd=1.12u as=0.1406p ps=1.12u w=0.74u l=0.13u
X4574 a_18101_14020# sg13cmos5l_inv_1_13.Y VDD.t703 VDD.t19 sg13_lv_pmos ad=0.2128p pd=1.5u as=0.2128p ps=1.5u w=1.12u l=0.13u
X4575 VDD.t2134 a_11674_6130# a_11393_6352# VDD.t2 sg13_lv_pmos ad=0.1523p pd=1.38u as=0.34p ps=2.68u w=1u l=0.5u
X4576 a_12758_11826# sg13cmos5l_inv_1_18.A a_12656_11826# VSS.t609 sg13_lv_nmos ad=0.1406p pd=1.12u as=0.1406p ps=1.12u w=0.74u l=0.13u
X4577 VSS.t479 a_22126_6351# sg13cmos5l_buf_1_4.A VSS.t258 sg13_lv_nmos ad=0.1426p pd=1.16u as=0.2516p ps=2.16u w=0.74u l=0.13u
X4578 VDD.t1979 sg13cmos5l_a21oi_1_9.B1 sg13cmos5l_a21oi_1_10.A1 VDD.t2 sg13_lv_pmos ad=0.2198p pd=1.53u as=0.2128p ps=1.5u w=1.12u l=0.13u
X4579 VDD.t150 VSS.t1940 VDD.t524 VDD.t5 sg13_lv_pmos ad=0.34p pd=2.68u as=0 ps=0 w=1u l=1u
X4580 VDD.t231 a_17296_18478# a_17241_18573# VDD.t231 sg13_lv_pmos ad=1.54512p pd=9.865u as=93.45f ps=0.865u w=0.42u l=0.13u
X4581 a_15692_18984# sg13cmos5l_o21ai_1_25.B1 VSS.t927 VSS.t305 sg13_lv_nmos ad=0.187p pd=1.78u as=0.14875p ps=1.16u w=0.55u l=0.13u
X4582 sg13cmos5l_nand4_1_12.Y sg13cmos5l_buf_1_42.A VDD.t1591 VDD.t310 sg13_lv_pmos ad=0.2128p pd=1.5u as=0.3808p ps=2.92u w=1.12u l=0.13u
X4583 sg13cmos5l_nand2b_1_4.Y a_8061_7194# VDD.t1164 VDD.t2 sg13_lv_pmos ad=0.2128p pd=1.5u as=0.3808p ps=2.92u w=1.12u l=0.13u
X4584 a_9274_6888# sg13cmos5l_dfrbpq_1_15.Q VSS.t779 VSS.t778 sg13_lv_nmos ad=0.1428p pd=1.52u as=79.8f ps=0.8u w=0.42u l=0.13u
X4585 a_13679_19381# a_12837_19031# a_13585_19381# VSS.t1161 sg13_lv_nmos ad=0.12665p pd=1.145u as=0.1428p ps=1.52u w=0.42u l=0.13u
X4586 VSS.t1211 VDD.t2515 VSS.t663 VSS.t1760 sg13_lv_nmos ad=79.8f pd=0.8u as=0 ps=0 w=0.42u l=1u
X4587 VDD.t29 VSS.t2175 VDD.t28 VDD.t13 sg13_lv_pmos ad=0.19p pd=1.38u as=0 ps=0 w=1u l=1u
X4588 VDD.t484 VSS.t1219 VDD.t262 VDD.t2 sg13_lv_pmos ad=0.19p pd=1.38u as=0 ps=0 w=1u l=1u
X4589 a_19035_16750# sg13cmos5l_buf_8_2.A.t5 VSS.t132 VSS.t1381 sg13_lv_nmos ad=0.1406p pd=1.12u as=0.1406p ps=1.12u w=0.74u l=0.13u
X4590 VDD.t2024 sg13cmos5l_buf_1_15.A a_5032_9948# VDD.t52 sg13_lv_pmos ad=0.2114p pd=1.54u as=0.2856p ps=2.36u w=0.84u l=0.13u
X4591 VSS.t393 a_18544_15454# a_18193_15311# VSS.t392 sg13_lv_nmos ad=79.8f pd=0.8u as=0.1428p ps=1.52u w=0.42u l=0.13u
X4592 sg13cmos5l_and4_1_1.A a_6666_14484# VSS.t124 VSS.t1331 sg13_lv_nmos ad=0.2516p pd=2.16u as=0.1406p ps=1.12u w=0.74u l=0.13u
X4593 VSS.t1112 sg13cmos5l_dfrbpq_1_24.RESET_B a_4202_18258# VSS.t1125 sg13_lv_nmos ad=79.8f pd=0.8u as=37.8f ps=0.6u w=0.42u l=0.13u
X4594 sg13cmos5l_o21ai_1_10.Y sg13cmos5l_o21ai_1_10.B1 a_5686_16374# VSS.t1462 sg13_lv_nmos ad=0.2516p pd=2.16u as=0.1406p ps=1.12u w=0.74u l=0.15u
X4595 VDD.t1301 sg13cmos5l_buf_1_45.X.t3 a_15784_15272# VDD.t16 sg13_lv_pmos ad=0.2114p pd=1.54u as=0.2856p ps=2.36u w=0.84u l=0.13u
X4596 VDD.t2176 a_10607_19847# a_11274_20068# VDD.t270 sg13_lv_pmos ad=0.2128p pd=1.5u as=0.3864p ps=2.93u w=1.12u l=0.13u
X4597 VDD.t590 VSS.t1913 VDD.t521 VDD.t5 sg13_lv_pmos ad=0.19p pd=1.38u as=0 ps=0 w=1u l=1u
X4598 VSS.t1127 a_7354_19738# a_7073_19960# VSS.t2467 sg13_lv_nmos ad=79.8f pd=0.8u as=0.1428p ps=1.52u w=0.42u l=0.5u
X4599 VDD.t899 a_20012_14448# sg13cmos5l_nand4_1_18.A VDD.t19 sg13_lv_pmos ad=0.2114p pd=1.54u as=0.42p ps=2.99u w=1.12u l=0.13u
X4600 sg13cmos5l_buf_1_43.X a_16840_12972# VDD.t705 VDD.t83 sg13_lv_pmos ad=0.42p pd=2.99u as=0.2114p ps=1.54u w=1.12u l=0.13u
X4601 a_22041_12525# a_21099_12332# a_21839_12287# VDD.t83 sg13_lv_pmos ad=93.45f pd=0.865u as=0.2048p ps=1.63u w=0.42u l=0.13u
X4602 VDD.t52 a_10917_9959# a_11019_9959# VDD.t52 sg13_lv_pmos ad=1.8716p pd=12.115u as=0.3864p ps=2.93u w=1.12u l=0.13u
X4603 sg13cmos5l_a22oi_1_0.A2 sg13cmos5l_a22oi_1_0.B2 a_13420_9484# VDD.t52 sg13_lv_pmos ad=0.3808p pd=2.92u as=0.1176p ps=1.33u w=1.12u l=0.13u
X4604 a_19534_4839# a_19649_4840# VDD.t921 VDD.t5 sg13_lv_pmos ad=0.34p pd=2.68u as=0.2254p ps=1.53u w=1u l=0.5u
X4605 busy a_13768_14484# VSS.t239 VSS.t1461 sg13_lv_nmos ad=0.2886p pd=2.26u as=0.14875p ps=1.16u w=0.74u l=0.13u
X4606 a_12826_9154# sg13cmos5l_nor2_1_0.Y VSS.t569 VSS.t2531 sg13_lv_nmos ad=0.1428p pd=1.52u as=79.8f ps=0.8u w=0.42u l=0.13u
X4607 VSS.t1971 VDD.t2437 VSS.t1973 VSS.t1972 sg13_lv_nmos ad=79.8f pd=0.8u as=0 ps=0 w=0.42u l=1u
X4608 VSS.t11 sg13cmos5l_buf_1_7.X a_18756_5850# VSS.t41 sg13_lv_nmos ad=0.1626p pd=1.415u as=60.89999f ps=0.71u w=0.42u l=0.13u
X4609 a_19077_7653# sg13cmos5l_inv_1_2.A VDD.t8 VDD.t8 sg13_lv_pmos ad=0.4088p pd=2.97u as=1.79022p ps=11.585u w=1.12u l=0.13u
X4610 VSS.t1842 VDD.t2482 VSS.t1829 VSS.t88 sg13_lv_nmos ad=0.1428p pd=1.52u as=0 ps=0 w=0.42u l=1u
X4611 VSS.t117 a_20272_17750# a_19921_17869# VSS.t225 sg13_lv_nmos ad=79.8f pd=0.8u as=0.1428p ps=1.52u w=0.42u l=0.13u
X4612 VDD.t1479 sg13cmos5l_buf_1_26.A sg13cmos5l_a21oi_1_26.A1 VDD.t231 sg13_lv_pmos ad=0.3808p pd=2.92u as=0.3808p ps=2.92u w=1.12u l=0.13u
X4613 bn2 a_12232_14484# VSS.t199 VSS.t1554 sg13_lv_nmos ad=0.2886p pd=2.26u as=0.14875p ps=1.16u w=0.74u l=0.13u
X4614 a_11388_14020# sg13cmos5l_mux2_1_0.S a_11286_14020# VDD.t19 sg13_lv_pmos ad=0.2128p pd=1.5u as=0.2128p ps=1.5u w=1.12u l=0.13u
X4615 VDD.t1036 sg13cmos5l_buf_1_13.X a_18374_10698# VDD.t0 sg13_lv_pmos ad=0.36237p pd=2.605u as=79.8f ps=0.8u w=0.42u l=0.13u
X4616 a_21911_17137# sg13cmos5l_dfrbpq_1_37.D a_22658_16746# VSS.t588 sg13_lv_nmos ad=0.1428p pd=1.52u as=60.89999f ps=0.71u w=0.42u l=0.13u
X4617 VDD.t862 sg13cmos5l_o21ai_1_5.A2.t1 a_7484_15976# VDD.t16 sg13_lv_pmos ad=0.3808p pd=2.92u as=0.2128p ps=1.5u w=1.12u l=0.15u
X4618 VDD.t803 sg13cmos5l_buf_1_29.A a_1192_14484# VDD.t19 sg13_lv_pmos ad=0.2114p pd=1.54u as=0.2856p ps=2.36u w=0.84u l=0.13u
X4619 VDD.t882 sg13cmos5l_inv_1_12.A a_15208_12972# VDD.t83 sg13_lv_pmos ad=0.2114p pd=1.54u as=0.2856p ps=2.36u w=0.84u l=0.13u
X4620 VDD.t1714 sg13cmos5l_nand4_1_18.A sg13cmos5l_a21oi_1_5.A2 VDD.t83 sg13_lv_pmos ad=0.3808p pd=2.92u as=0.2128p ps=1.5u w=1.12u l=0.13u
X4621 VDD.t439 VSS.t563 VDD.t438 VDD.t13 sg13_lv_pmos ad=0.19p pd=1.38u as=0 ps=0 w=1u l=1u
X4622 a_15014_19020# a_14744_19061# VSS.t420 VSS.t305 sg13_lv_nmos ad=0.1428p pd=1.52u as=79.8f ps=0.8u w=0.42u l=0.5u
X4623 a_5554_13718# sg13cmos5l_o21ai_1_9.B1 sg13cmos5l_o21ai_1_9.Y VSS.t623 sg13_lv_nmos ad=0.1406p pd=1.12u as=0.2516p ps=2.16u w=0.74u l=0.15u
X4624 sg13cmos5l_dlygate4sd3_1_2.A sg13cmos5l_a21oi_1_2.B1 VSS.t479 VSS.t10 sg13_lv_nmos ad=0.1406p pd=1.12u as=0.2516p ps=2.16u w=0.74u l=0.13u
X4625 VDD.t1360 sg13cmos5l_dfrbpq_1_47.Q a_12344_6166# VDD.t2 sg13_lv_pmos ad=0.1523p pd=1.38u as=0.1428p ps=1.52u w=0.42u l=0.13u
X4626 VSS.t850 sg13cmos5l_inv_1_7.A sg13cmos5l_inv_1_7.Y VSS.t2544 sg13_lv_nmos ad=0.2516p pd=2.16u as=0.2516p ps=2.16u w=0.74u l=0.13u
X4627 a_22096_7166# sg13cmos5l_buf_1_7.X VDD.t2 VDD.t2 sg13_lv_pmos ad=79.8f pd=0.8u as=2.07625p ps=13.51u w=0.42u l=0.13u
X4628 a_8218_19738# sg13cmos5l_o21ai_1_19.Y VSS.t1130 VSS.t2469 sg13_lv_nmos ad=0.1428p pd=1.52u as=79.8f ps=0.8u w=0.42u l=0.13u
X4629 a_20272_17750# a_20015_17869# a_20434_17946# VSS.t225 sg13_lv_nmos ad=0.1428p pd=1.52u as=37.8f ps=0.6u w=0.42u l=0.13u
X4630 sg13cmos5l_nor2_1_12.Y sg13cmos5l_nand4_1_6.B a_11690_17044# VDD.t310 sg13_lv_pmos ad=0.3808p pd=2.92u as=0.1176p ps=1.33u w=1.12u l=0.13u
X4631 VSS.t479 a_21754_5376# a_21473_5678# VSS.t10 sg13_lv_nmos ad=79.8f pd=0.8u as=0.1428p ps=1.52u w=0.42u l=0.5u
X4632 a_14532_19783# a_14763_19892# a_14218_19993# VSS.t165 sg13_lv_nmos ad=0.2373p pd=1.97u as=79.8f ps=0.8u w=0.42u l=0.13u
X4633 a_12441_18573# a_11499_18380# a_12239_18335# VDD.t231 sg13_lv_pmos ad=93.45f pd=0.865u as=0.2048p ps=1.63u w=0.42u l=0.13u
X4634 VSS.t634 a_20026_15202# a_19745_15424# VSS.t392 sg13_lv_nmos ad=79.8f pd=0.8u as=0.1428p ps=1.52u w=0.42u l=0.5u
X4635 a_17892_11885# a_18123_11471# a_17578_11428# VSS.t170 sg13_lv_nmos ad=0.2373p pd=1.97u as=79.8f ps=0.8u w=0.42u l=0.13u
X4636 VDD.t51 VSS.t1789 VDD.t50 VDD.t0 sg13_lv_pmos ad=0.34p pd=2.68u as=0 ps=0 w=1u l=1u
X4637 VDD.t1538 a_20974_19959# sg13cmos5l_buf_1_24.A VDD.t270 sg13_lv_pmos ad=0.2254p pd=1.53u as=0.4256p ps=3u w=1.12u l=0.13u
X4638 a_11756_19734# sg13cmos5l_o21ai_1_13.B1 VSS.t107 VSS.t2434 sg13_lv_nmos ad=0.187p pd=1.78u as=0.14875p ps=1.16u w=0.55u l=0.13u
X4639 a_3790_16119# a_3532_16434# VDD.t16 VDD.t16 sg13_lv_pmos ad=93.45f pd=0.865u as=2.07625p ps=13.51u w=0.42u l=0.13u
X4640 VSS.t101 sg13cmos5l_nand3_1_0.A a_12662_7656# VSS.t2450 sg13_lv_nmos ad=0.2553p pd=2.17u as=0.13875p ps=1.115u w=0.74u l=0.13u
X4641 a_12463_13726# a_12381_13912# sg13cmos5l_mux2_1_0.A1 VSS.t66 sg13_lv_nmos ad=0.1406p pd=1.12u as=0.333p ps=2.38u w=0.74u l=0.13u
X4642 a_16454_8436# a_16184_8477# VDD.t652 VDD.t8 sg13_lv_pmos ad=0.34p pd=2.68u as=0.1523p ps=1.38u w=1u l=0.5u
X4643 VSS.t1997 VDD.t2425 VSS.t1997 VSS.t1996 sg13_lv_nmos ad=0.1428p pd=1.52u as=0 ps=0 w=0.42u l=1u
X4644 a_6610_19458# sg13cmos5l_dfrbpq_1_24.RESET_B VSS.t1132 VSS.t1131 sg13_lv_nmos ad=37.8f pd=0.6u as=79.8f ps=0.8u w=0.42u l=0.13u
X4645 VDD.t1612 a_16942_19287# sg13cmos5l_dlygate4sd3_1_82.X VDD.t231 sg13_lv_pmos ad=0.2254p pd=1.53u as=0.4256p ps=3u w=1.12u l=0.13u
X4646 sg13cmos5l_dfrbpq_1_45.Q a_8682_11460# VDD.t716 VDD.t0 sg13_lv_pmos ad=0.3808p pd=2.92u as=0.2128p ps=1.5u w=1.12u l=0.13u
X4647 VSS.t1981 VDD.t2433 VSS.t1981 VSS.t1982 sg13_lv_nmos ad=79.8f pd=0.8u as=0 ps=0 w=0.42u l=1u
X4648 VDD.t1927 a_21839_8797# a_22506_8436# VDD.t8 sg13_lv_pmos ad=0.2128p pd=1.5u as=0.3864p ps=2.93u w=1.12u l=0.13u
X4649 VDD.t511 VSS.t468 VDD.t277 VDD.t231 sg13_lv_pmos ad=0.19p pd=1.38u as=0 ps=0 w=1u l=1u
X4650 a_8060_17488# sg13cmos5l_nand3_1_5.Y sg13cmos5l_o21ai_1_19.Y VDD.t310 sg13_lv_pmos ad=0.2128p pd=1.5u as=0.2128p ps=1.5u w=1.12u l=0.15u
X4651 sg13cmos5l_o21ai_1_28.B1 sg13cmos5l_o21ai_1_23.A2 a_12984_15552# VDD.t16 sg13_lv_pmos ad=0.2128p pd=1.5u as=0.2128p ps=1.5u w=1.12u l=0.15u
X4652 VDD.t66 VSS.t1987 VDD.t49 VDD.t13 sg13_lv_pmos ad=0.19p pd=1.38u as=0 ps=0 w=1u l=1u
X4653 a_4823_17137# sg13cmos5l_dfrbpq_1_23.D a_5570_16746# VSS.t809 sg13_lv_nmos ad=0.1428p pd=1.52u as=60.89999f ps=0.71u w=0.42u l=0.13u
X4654 sg13cmos5l_o21ai_1_26.B1 a_13686_18326# VSS.t726 VSS.t1431 sg13_lv_nmos ad=0.2516p pd=2.16u as=0.1426p ps=1.16u w=0.74u l=0.13u
X4655 VSS.t76 a_21254_10702# a_21366_10766# VSS.t784 sg13_lv_nmos ad=0.1426p pd=1.16u as=0.1428p ps=1.52u w=0.42u l=0.5u
X4656 VDD.t1397 VSS.t1925 VDD.t1396 VDD.t5 sg13_lv_pmos ad=0.34p pd=2.68u as=0 ps=0 w=1u l=1u
X4657 a_8061_7194# sg13cmos5l_nand2b_1_1.A_N VDD.t1434 VDD.t2 sg13_lv_pmos ad=0.2856p pd=2.36u as=0.2198p ps=1.53u w=0.84u l=0.13u
X4658 VDD.t10 VSS.t1869 VDD.t9 VDD.t8 sg13_lv_pmos ad=0.34p pd=2.68u as=0 ps=0 w=1u l=1u
X4659 a_20890_15202# sg13cmos5l_a21oi_1_13.Y VSS.t72 VSS.t71 sg13_lv_nmos ad=0.1428p pd=1.52u as=79.8f ps=0.8u w=0.42u l=0.13u
X4660 a_15780_18576# a_15754_18481# VDD.t896 VDD.t231 sg13_lv_pmos ad=0.34p pd=2.68u as=0.36237p ps=2.605u w=1u l=0.13u
X4661 VDD.t932 sg13cmos5l_mux2_1_0.S a_9147_13028# VDD.t83 sg13_lv_pmos ad=0.2198p pd=1.53u as=0.2856p ps=2.36u w=0.84u l=0.13u
X4662 VDD.t1560 sg13cmos5l_dfrbpq_1_13.RESET_B a_6730_11428# VDD.t0 sg13_lv_pmos ad=0.1563p pd=1.22u as=0.147p ps=1.54u w=0.42u l=0.13u
X4663 a_21839_7285# a_20997_6935# a_20580_6928# VDD.t2 sg13_lv_pmos ad=0.2048p pd=1.63u as=0.34p ps=2.68u w=1u l=0.13u
X4664 a_20554_11428# a_20997_11471# a_20937_11507# VDD.t0 sg13_lv_pmos ad=79.8f pd=0.8u as=63f ps=0.72u w=0.42u l=0.13u
X4665 VDD.t0 a_18863_11821# a_19120_11702# VDD.t0 sg13_lv_pmos ad=2.1916p pd=14.26u as=79.8f ps=0.8u w=0.42u l=0.13u
X4666 VSS.t1829 VDD.t2487 VSS.t1828 VSS.t88 sg13_lv_nmos ad=0.1428p pd=1.52u as=0 ps=0 w=0.42u l=1u
X4667 VDD.t371 sg13cmos5l_buf_1_7.X a_16070_5850# VDD.t5 sg13_lv_pmos ad=0.36237p pd=2.605u as=79.8f ps=0.8u w=0.42u l=0.13u
X4668 VSS.t101 sg13cmos5l_and4_1_0.D a_12430_6980# VSS.t1012 sg13_lv_nmos ad=0.17255p pd=1.25u as=0.187p ps=1.78u w=0.55u l=0.13u
X4669 VDD.t1771 sg13cmos5l_a21oi_1_19.Y a_21080_19061# VDD.t231 sg13_lv_pmos ad=0.1523p pd=1.38u as=0.1428p ps=1.52u w=0.42u l=0.13u
X4670 VDD.t169 VSS.t740 VDD.t167 VDD.t0 sg13_lv_pmos ad=0.19p pd=1.38u as=0 ps=0 w=1u l=1u
X4671 VSS.t83 a_18575_8797# a_19242_8436# VSS.t842 sg13_lv_nmos ad=0.1406p pd=1.12u as=0.2516p ps=2.16u w=0.74u l=0.13u
X4672 VDD.t231 a_19173_19031# a_19275_19031# VDD.t231 sg13_lv_pmos ad=1.54512p pd=9.865u as=0.3864p ps=2.93u w=1.12u l=0.13u
X4673 a_12216_17488# sg13cmos5l_buf_1_47.X VDD.t1648 VDD.t310 sg13_lv_pmos ad=0.2128p pd=1.5u as=0.3808p ps=2.92u w=1.12u l=0.15u
X4674 VDD.t2316 VSS.t1744 VDD.t329 VDD.t83 sg13_lv_pmos ad=0.19p pd=1.38u as=0 ps=0 w=1u l=1u
X4675 VDD.t663 a_11372_10662# sg13cmos5l_o21ai_1_5.A2.t0 VDD.t0 sg13_lv_pmos ad=0.2114p pd=1.54u as=0.42p ps=2.99u w=1.12u l=0.13u
X4676 sg13cmos5l_a21oi_1_13.A2 sg13cmos5l_nand4_1_1.A a_19646_14850# VSS.t432 sg13_lv_nmos ad=0.2516p pd=2.16u as=0.1406p ps=1.12u w=0.74u l=0.13u
X4677 a_17015_9577# sg13cmos5l_buf_1_13.A VDD.t2089 VDD.t52 sg13_lv_pmos ad=79.8f pd=0.8u as=0.36237p ps=2.605u w=0.42u l=0.13u
X4678 VSS.t31 sg13cmos5l_buf_1_13.A a_16982_7687# VSS.t2364 sg13_lv_nmos ad=0.1701p pd=1.65u as=37.8f ps=0.6u w=0.42u l=0.13u
X4679 VSS.t1643 VDD.t2548 VSS.t1644 VSS.t227 sg13_lv_nmos ad=79.8f pd=0.8u as=0 ps=0 w=0.42u l=1u
X4680 a_16190_13730# sg13cmos5l_nand4_1_6.B a_16088_13730# VSS.t128 sg13_lv_nmos ad=0.1406p pd=1.12u as=0.1406p ps=1.12u w=0.74u l=0.13u
X4681 a_10308_10386# sg13cmos5l_a21o_1_0.X a_10214_10386# VSS.t363 sg13_lv_nmos ad=60.89999f pd=0.71u as=0.1428p ps=1.52u w=0.42u l=0.13u
X4682 a_17914_9912# sg13cmos5l_dlygate4sd3_1_25.A VSS.t161 VSS.t822 sg13_lv_nmos ad=0.1428p pd=1.52u as=79.8f ps=0.8u w=0.42u l=0.13u
X4683 a_8671_7656# sg13cmos5l_nand2b_1_4.Y VSS.t779 VSS.t2407 sg13_lv_nmos ad=0.13875p pd=1.115u as=0.2553p ps=2.17u w=0.74u l=0.13u
X4684 a_10980_18576# a_10954_18481# VSS.t1140 VSS.t1137 sg13_lv_nmos ad=0.2516p pd=2.16u as=0.1626p ps=1.415u w=0.74u l=0.13u
X4685 a_5386_7897# a_5829_7653# a_5126_7674# VSS.t2340 sg13_lv_nmos ad=79.8f pd=0.8u as=0.1296p ps=1.52u w=0.42u l=0.13u
X4686 VSS.t433 a_20012_14448# sg13cmos5l_nand4_1_18.A VSS.t432 sg13_lv_nmos ad=0.14875p pd=1.16u as=0.2886p ps=2.26u w=0.74u l=0.13u
X4687 bn8 a_19912_11460# VDD.t392 VDD.t0 sg13_lv_pmos ad=0.42p pd=2.99u as=0.2114p ps=1.54u w=1.12u l=0.13u
X4688 VSS.t22 a_22522_3864# a_22241_4166# VSS.t193 sg13_lv_nmos ad=79.8f pd=0.8u as=0.1428p ps=1.52u w=0.42u l=0.5u
X4689 a_17043_12236# sg13cmos5l_a21oi_1_15.A2 VSS.t232 VSS.t231 sg13_lv_nmos ad=0.1406p pd=1.12u as=0.2516p ps=2.16u w=0.74u l=0.13u
X4690 a_20997_11471# sg13cmos5l_dfrbpq_1_5.CLK VSS.t2 VSS.t1562 sg13_lv_nmos ad=0.2516p pd=2.16u as=4.21822p ps=27.295u w=0.74u l=0.13u
X4691 a_17211_9577# a_16319_9456# a_17109_9344# VDD.t52 sg13_lv_pmos ad=63f pd=0.72u as=79.8f ps=0.8u w=0.42u l=0.13u
X4692 sg13cmos5l_a21oi_1_6.A2 sg13cmos5l_nand4_1_18.D VDD.t973 VDD.t19 sg13_lv_pmos ad=0.2128p pd=1.5u as=0.3808p ps=2.92u w=1.12u l=0.13u
X4693 VDD.t620 VSS.t1973 VDD.t618 VDD.t13 sg13_lv_pmos ad=0.19p pd=1.38u as=0 ps=0 w=1u l=1u
X4694 a_3895_18222# a_4455_18476# a_4366_18573# VDD.t231 sg13_lv_pmos ad=0.2048p pd=1.63u as=93.45f ps=0.865u w=0.42u l=0.13u
X4695 VSS.t52 sg13cmos5l_o21ai_1_28.A1 sg13cmos5l_nand3_1_6.C VSS.t77 sg13_lv_nmos ad=0.2516p pd=2.16u as=0.1406p ps=1.12u w=0.74u l=0.13u
X4696 sg13cmos5l_dfrbpq_1_13.CLK a_12987_10318# VDD.t1470 VDD.t52 sg13_lv_pmos ad=0.2128p pd=1.5u as=0.2128p ps=1.5u w=1.12u l=0.13u
X4697 VDD.t1269 a_11840_9389# sg13cmos5l_a21o_1_0.A1 VDD.t52 sg13_lv_pmos ad=0.1918p pd=1.5u as=0.3808p ps=2.92u w=1.12u l=0.13u
X4698 VDD.t153 VSS.t256 VDD.t152 VDD.t5 sg13_lv_pmos ad=0.34p pd=2.68u as=0 ps=0 w=1u l=1u
X4699 a_10042_6130# sg13cmos5l_a21oi_1_10.Y VSS.t293 VSS.t484 sg13_lv_nmos ad=0.1428p pd=1.52u as=79.8f ps=0.8u w=0.42u l=0.13u
X4700 VDD.t19 a_6256_14726# a_6201_14607# VDD.t19 sg13_lv_pmos ad=2.1916p pd=14.26u as=93.45f ps=0.865u w=0.42u l=0.13u
X4701 a_12139_11808# sg13cmos5l_and2_1_6.A a_12045_11808# VSS.t1482 sg13_lv_nmos ad=0.1216p pd=1.02u as=0.2176p ps=1.96u w=0.64u l=0.13u
X4702 VSS.t196 sg13cmos5l_nor4_1_1.D sg13cmos5l_nand4_1_1.B VSS.t66 sg13_lv_nmos ad=0.1463p pd=1.15u as=0.1694p ps=1.21u w=0.77u l=0.13u
X4703 a_9348_20088# a_9322_19993# VDD.t1535 VDD.t270 sg13_lv_pmos ad=0.34p pd=2.68u as=0.36237p ps=2.605u w=1u l=0.13u
X4704 sg13cmos5l_dlygate4sd3_1_18.A sg13cmos5l_inv_1_9.Y a_17523_12236# VSS.t1490 sg13_lv_nmos ad=0.1406p pd=1.12u as=0.1406p ps=1.12u w=0.74u l=0.13u
X4705 VDD.t410 VSS.t1734 VDD.t409 VDD.t0 sg13_lv_pmos ad=0.19p pd=1.38u as=0 ps=0 w=1u l=1u
X4706 VDD.t186 VSS.t2180 VDD.t185 VDD.t13 sg13_lv_pmos ad=0.19p pd=1.38u as=0 ps=0 w=1u l=1u
X4707 a_7822_19959# a_7937_19960# VSS.t1127 VSS.t2533 sg13_lv_nmos ad=0.1428p pd=1.52u as=0.1426p ps=1.16u w=0.42u l=0.5u
X4708 a_17253_19749# sg13cmos5l_inv_1_31.A VDD.t270 VDD.t270 sg13_lv_pmos ad=0.4088p pd=2.97u as=2.69447p ps=17.64u w=1.12u l=0.13u
X4709 VSS.t1056 a_21370_19738# a_21089_19960# VSS.t1055 sg13_lv_nmos ad=79.8f pd=0.8u as=0.1428p ps=1.52u w=0.42u l=0.5u
X4710 VSS.t312 sg13cmos5l_buf_1_29.A a_1192_14484# VSS.t311 sg13_lv_nmos ad=0.14875p pd=1.16u as=0.187p ps=1.78u w=0.55u l=0.13u
X4711 comp_clk a_18952_3176# VDD.t849 VDD.t13 sg13_lv_pmos ad=0.42p pd=2.99u as=0.2114p ps=1.54u w=1.12u l=0.13u
X4712 VDD.t270 a_15503_19847# a_15760_19990# VDD.t270 sg13_lv_pmos ad=2.69447p pd=17.64u as=79.8f ps=0.8u w=0.42u l=0.13u
X4713 a_12631_5376# a_13191_5499# a_13212_5773# VSS.t281 sg13_lv_nmos ad=0.12665p pd=1.145u as=0.3473p ps=2.71u w=0.74u l=0.13u
X4714 a_17412_6928# a_17386_6892# VDD.t376 VDD.t2 sg13_lv_pmos ad=0.34p pd=2.68u as=0.36237p ps=2.605u w=1u l=0.13u
X4715 VSS.t242 a_19173_17519# a_19275_17519# VSS.t241 sg13_lv_nmos ad=4.1963p pd=27.415u as=0.2516p ps=2.16u w=0.74u l=0.13u
X4716 VSS.t176 sg13cmos5l_o21ai_1_9.A2 a_5686_16374# VSS.t1325 sg13_lv_nmos ad=0.1406p pd=1.12u as=0.2516p ps=2.16u w=0.74u l=0.15u
X4717 VDD.t824 sg13cmos5l_a21oi_1_7.A2 a_21269_9484# VDD.t52 sg13_lv_pmos ad=0.2128p pd=1.5u as=0.3808p ps=2.92u w=1.12u l=0.13u
X4718 a_8716_8436# sg13cmos5l_or4_1_0.C a_8614_8436# VDD.t8 sg13_lv_pmos ad=0.2925p pd=1.585u as=0.19p ps=1.38u w=1u l=0.13u
X4719 VSS.t1790 VDD.t2492 VSS.t1792 VSS.t1791 sg13_lv_nmos ad=79.8f pd=0.8u as=0 ps=0 w=0.42u l=1u
X4720 VDD.t837 a_19995_9190# sg13cmos5l_inv_1_2.A VDD.t52 sg13_lv_pmos ad=0.3864p pd=2.93u as=0.2128p ps=1.5u w=1.12u l=0.13u
X4721 VDD.t1468 a_12987_10318# sg13cmos5l_dfrbpq_1_13.CLK VDD.t52 sg13_lv_pmos ad=0.2128p pd=1.5u as=0.2128p ps=1.5u w=1.12u l=0.13u
X4722 VSS.t369 a_5230_19959# sg13cmos5l_o21ai_1_21.B1 VSS.t368 sg13_lv_nmos ad=0.1426p pd=1.16u as=0.2516p ps=2.16u w=0.74u l=0.13u
X4723 sg13cmos5l_nand4_1_8.B sg13cmos5l_nor3_1_4.A VSS.t653 VSS.t652 sg13_lv_nmos ad=0.1406p pd=1.12u as=0.2516p ps=2.16u w=0.74u l=0.13u
X4724 VSS.t2088 VDD.t300 VSS.t2087 VSS.t2086 sg13_lv_nmos ad=0.1428p pd=1.52u as=0 ps=0 w=0.42u l=1u
X4725 VDD.t713 a_10118_18262# a_10230_18326# VDD.t231 sg13_lv_pmos ad=0.2254p pd=1.53u as=0.34p ps=2.68u w=1u l=0.5u
X4726 a_15694_7989# a_15436_7674# VDD.t8 VDD.t8 sg13_lv_pmos ad=93.45f pd=0.865u as=1.8716p ps=12.115u w=0.42u l=0.13u
X4727 sg13cmos5l_dfrbpq_1_45.Q a_8682_11460# VSS.t74 VSS.t187 sg13_lv_nmos ad=0.2516p pd=2.16u as=0.1406p ps=1.12u w=0.74u l=0.13u
X4728 VDD.t1696 sg13cmos5l_inv_1_0.Y a_18587_4948# VDD.t5 sg13_lv_pmos ad=0.2128p pd=1.5u as=0.2128p ps=1.5u w=1.12u l=0.13u
X4729 VSS.t1973 VDD.t2436 VSS.t1973 VSS.t1975 sg13_lv_nmos ad=79.8f pd=0.8u as=0 ps=0 w=0.42u l=1u
X4730 VDD.t5 a_20207_5773# a_20464_5654# VDD.t5 sg13_lv_pmos ad=1.96072p pd=12.69u as=79.8f ps=0.8u w=0.42u l=0.13u
X4731 VDD.t993 sg13cmos5l_dfrbpq_1_13.RESET_B a_5126_7674# VDD.t8 sg13_lv_pmos ad=0.36237p pd=2.605u as=79.8f ps=0.8u w=0.42u l=0.13u
X4732 a_9062_19770# a_9867_19892# a_9322_19993# VDD.t270 sg13_lv_pmos ad=0.1428p pd=1.52u as=79.8f ps=0.8u w=0.42u l=0.13u
X4733 VDD.t1484 a_3776_18433# sg13cmos5l_dfrbpq_1_20.Q VDD.t231 sg13_lv_pmos ad=0.2128p pd=1.5u as=0.3808p ps=2.92u w=1.12u l=0.13u
X4734 VSS.t124 sg13cmos5l_and4_1_1.A a_7064_14525# VSS.t616 sg13_lv_nmos ad=79.8f pd=0.8u as=0.1428p ps=1.52u w=0.42u l=0.13u
X4735 a_9446_13726# a_9176_13726# VSS.t67 VSS.t66 sg13_lv_nmos ad=0.1428p pd=1.52u as=79.8f ps=0.8u w=0.42u l=0.5u
X4736 a_22126_6351# a_22241_6352# VSS.t479 VSS.t258 sg13_lv_nmos ad=0.1428p pd=1.52u as=0.1426p ps=1.16u w=0.42u l=0.5u
X4737 a_14438_6162# a_15243_6284# a_14698_6385# VDD.t2 sg13_lv_pmos ad=0.1428p pd=1.52u as=79.8f ps=0.8u w=0.42u l=0.13u
X4738 VSS.t273 sg13cmos5l_buf_1_13.A a_18952_4688# VSS.t2366 sg13_lv_nmos ad=0.14875p pd=1.16u as=0.187p ps=1.78u w=0.55u l=0.13u
X4739 a_20294_7362# sg13cmos5l_dfrbpq_1_8.D VDD.t1990 VDD.t2 sg13_lv_pmos ad=79.8f pd=0.8u as=0.1428p ps=1.52u w=0.42u l=0.13u
X4740 a_16810_19993# a_17253_19749# a_17193_20161# VDD.t270 sg13_lv_pmos ad=79.8f pd=0.8u as=63f ps=0.72u w=0.42u l=0.13u
X4741 VDD.t1715 sg13cmos5l_nand4_1_18.A sg13cmos5l_a21oi_1_0.A2 VDD.t83 sg13_lv_pmos ad=0.3808p pd=2.92u as=0.2128p ps=1.5u w=1.12u l=0.13u
X4742 VDD.t190 VSS.t2165 VDD.t189 VDD.t13 sg13_lv_pmos ad=0.19p pd=1.38u as=0 ps=0 w=1u l=1u
X4743 a_11268_18271# a_11499_18380# a_10954_18481# VSS.t1137 sg13_lv_nmos ad=0.2373p pd=1.97u as=79.8f ps=0.8u w=0.42u l=0.13u
X4744 a_10833_14874# sg13cmos5l_mux2_1_1.A1 VDD.t931 VDD.t19 sg13_lv_pmos ad=0.1848p pd=1.28u as=0.1596p ps=1.22u w=0.84u l=0.13u
X4745 VDD.t545 VSS.t645 VDD.t145 VDD.t83 sg13_lv_pmos ad=0.19p pd=1.38u as=0 ps=0 w=1u l=1u
X4746 VSS.t134 a_18286_16935# sg13cmos5l_inv_1_1.A VSS.t1420 sg13_lv_nmos ad=0.1426p pd=1.16u as=0.2516p ps=2.16u w=0.74u l=0.13u
X4747 a_14052_16421# a_14283_16007# a_13738_15964# VSS.t735 sg13_lv_nmos ad=0.2373p pd=1.97u as=79.8f ps=0.8u w=0.42u l=0.13u
X4748 a_16949_12508# sg13cmos5l_inv_1_20.Y VDD.t747 VDD.t83 sg13_lv_pmos ad=0.2128p pd=1.5u as=0.2128p ps=1.5u w=1.12u l=0.13u
X4749 a_20294_4650# a_21099_4772# a_20554_4873# VDD.t5 sg13_lv_pmos ad=0.1428p pd=1.52u as=79.8f ps=0.8u w=0.42u l=0.13u
X4750 a_13478_16434# sg13cmos5l_dlygate4sd3_1_80.X VDD.t829 VDD.t16 sg13_lv_pmos ad=79.8f pd=0.8u as=0.1428p ps=1.52u w=0.42u l=0.13u
X4751 VSS.t1059 a_19930_12936# a_19649_13238# VSS.t128 sg13_lv_nmos ad=79.8f pd=0.8u as=0.1428p ps=1.52u w=0.42u l=0.5u
X4752 VSS.t1737 VDD.t2509 VSS.t1736 VSS.t1735 sg13_lv_nmos ad=0.1428p pd=1.52u as=0 ps=0 w=0.42u l=1u
X4753 a_22522_3864# sg13cmos5l_dlygate4sd3_1_3.A VDD.t2110 VDD.t13 sg13_lv_pmos ad=0.1428p pd=1.52u as=0.1523p ps=1.38u w=0.42u l=0.13u
X4754 a_16240_6382# a_15983_6239# a_16402_6162# VSS.t711 sg13_lv_nmos ad=0.1428p pd=1.52u as=37.8f ps=0.6u w=0.42u l=0.13u
X4755 VSS.t26 a_19919_7751# a_20586_7972# VSS.t2297 sg13_lv_nmos ad=0.1406p pd=1.12u as=0.2516p ps=2.16u w=0.74u l=0.13u
X4756 a_16827_8065# a_15935_7944# a_16725_7832# VDD.t8 sg13_lv_pmos ad=63f pd=0.72u as=79.8f ps=0.8u w=0.42u l=0.13u
X4757 sg13cmos5l_dfrbpq_1_28.Q a_22506_12508# VDD.t1275 VDD.t83 sg13_lv_pmos ad=0.3808p pd=2.92u as=0.2128p ps=1.5u w=1.12u l=0.13u
X4758 VSS.t105 sg13cmos5l_buf_1_45.X.t15 a_14052_19770# VSS.t421 sg13_lv_nmos ad=0.1626p pd=1.415u as=60.89999f ps=0.71u w=0.42u l=0.13u
X4759 VDD.t646 a_5222_17508# a_5334_17532# VDD.t310 sg13_lv_pmos ad=0.2254p pd=1.53u as=0.34p ps=2.68u w=1u l=0.5u
X4760 a_3319_15960# a_3879_16083# a_3900_16357# VSS.t227 sg13_lv_nmos ad=0.12665p pd=1.145u as=0.3473p ps=2.71u w=0.74u l=0.13u
X4761 VDD.t921 a_19534_4839# sg13cmos5l_buf_1_6.A VDD.t5 sg13_lv_pmos ad=0.2254p pd=1.53u as=0.4256p ps=3u w=1.12u l=0.13u
X4762 a_14950_6175# sg13cmos5l_buf_1_13.A VSS.t206 VSS.t205 sg13_lv_nmos ad=37.8f pd=0.6u as=0.1701p ps=1.65u w=0.42u l=0.13u
X4763 VDD.t1263 sg13cmos5l_nor4_1_0.Y a_12632_8477# VDD.t8 sg13_lv_pmos ad=0.1523p pd=1.38u as=0.1428p ps=1.52u w=0.42u l=0.13u
X4764 a_7354_16714# sg13cmos5l_dlygate4sd3_1_62.A VDD.t855 VDD.t310 sg13_lv_pmos ad=0.1428p pd=1.52u as=0.1523p ps=1.38u w=0.42u l=0.13u
X4765 a_19930_15960# sg13cmos5l_nand2_1_1.A VSS.t132 VSS.t989 sg13_lv_nmos ad=0.1428p pd=1.52u as=79.8f ps=0.8u w=0.42u l=0.13u
X4766 a_19930_12936# sg13cmos5l_dfrbpq_1_28.Q VDD.t1438 VDD.t83 sg13_lv_pmos ad=0.1428p pd=1.52u as=0.1523p ps=1.38u w=0.42u l=0.13u
X4767 bn8 a_19912_11460# VSS.t7 VSS.t61 sg13_lv_nmos ad=0.2886p pd=2.26u as=0.14875p ps=1.16u w=0.74u l=0.13u
X4768 sg13cmos5l_nand3_1_1.Y sg13cmos5l_inv_1_8.A a_13400_10706# VSS.t249 sg13_lv_nmos ad=0.2516p pd=2.16u as=0.1406p ps=1.12u w=0.74u l=0.13u
X4769 a_5036_13686# sg13cmos5l_buf_1_15.A VSS.t645 VSS.t2461 sg13_lv_nmos ad=0.187p pd=1.78u as=0.14875p ps=1.16u w=0.55u l=0.13u
X4770 VDD.t13 VSS.t1973 VDD.t268 VDD.t13 sg13_lv_pmos ad=0.19p pd=1.38u as=0 ps=0 w=1u l=1u
X4771 VDD.t827 sg13cmos5l_nor2_1_3.Y a_12045_11808# VDD.t0 sg13_lv_pmos ad=0.1918p pd=1.5u as=0.1596p ps=1.22u w=0.84u l=0.13u
X4772 sg13cmos5l_a21oi_1_23.A2 sg13cmos5l_nand4_1_1.A a_18206_14850# VSS.t432 sg13_lv_nmos ad=0.2516p pd=2.16u as=0.1406p ps=1.12u w=0.74u l=0.13u
X4773 VSS.t196 sg13cmos5l_a21oi_1_27.A1 sg13cmos5l_buf_1_20.A VSS.t149 sg13_lv_nmos ad=0.1463p pd=1.15u as=0.2618p ps=2.22u w=0.77u l=0.13u
X4774 VSS.t206 sg13cmos5l_inv_1_5.A sg13cmos5l_inv_1_5.Y VSS.t416 sg13_lv_nmos ad=0.2516p pd=2.16u as=0.2516p ps=2.16u w=0.74u l=0.13u
X4775 VDD.t946 VSS.t1930 VDD.t945 VDD.t5 sg13_lv_pmos ad=0.34p pd=2.68u as=0 ps=0 w=1u l=1u
X4776 VDD.t1507 sg13cmos5l_dfrbpq_1_24.RESET_B a_10954_18481# VDD.t231 sg13_lv_pmos ad=0.1563p pd=1.22u as=0.147p ps=1.54u w=0.42u l=0.13u
X4777 VDD.t566 VSS.t1874 VDD.t565 VDD.t8 sg13_lv_pmos ad=0.34p pd=2.68u as=0 ps=0 w=1u l=1u
X4778 a_16137_18649# a_15780_18576# VDD.t897 VDD.t231 sg13_lv_pmos ad=63f pd=0.72u as=0.1563p ps=1.22u w=0.42u l=0.13u
X4779 VDD.t392 sg13cmos5l_inv_1_17.A a_19912_11460# VDD.t0 sg13_lv_pmos ad=0.2114p pd=1.54u as=0.2856p ps=2.36u w=0.84u l=0.13u
X4780 a_10330_9154# sg13cmos5l_or4_1_0.C VSS.t571 VSS.t2387 sg13_lv_nmos ad=0.1428p pd=1.52u as=79.8f ps=0.8u w=0.42u l=0.13u
X4781 VSS.t344 VDD.t2513 VSS.t153 VSS.t1763 sg13_lv_nmos ad=0.1428p pd=1.52u as=0 ps=0 w=0.42u l=1u
X4782 VSS.t2 a_18021_11471# a_18123_11471# VSS.t964 sg13_lv_nmos ad=4.7455p pd=30.71u as=0.2516p ps=2.16u w=0.74u l=0.13u
X4783 VSS.t2005 VDD.t2402 VSS.t2005 VSS.t2058 sg13_lv_nmos ad=79.8f pd=0.8u as=0 ps=0 w=0.42u l=1u
X4784 a_5098_9409# a_5541_9165# a_4838_9186# VSS.t88 sg13_lv_nmos ad=79.8f pd=0.8u as=0.1296p ps=1.52u w=0.42u l=0.13u
X4785 sg13cmos5l_o21ai_1_28.Y sg13cmos5l_o21ai_1_28.B1 a_12406_15230# VSS.t622 sg13_lv_nmos ad=0.2516p pd=2.16u as=0.1406p ps=1.12u w=0.74u l=0.15u
X4786 a_10508_10662# sg13cmos5l_buf_1_21.A VDD.t1828 VDD.t0 sg13_lv_pmos ad=0.2856p pd=2.36u as=0.2114p ps=1.54u w=0.84u l=0.13u
X4787 sg13cmos5l_inv_1_5.A a_17098_6130# VDD.t982 VDD.t2 sg13_lv_pmos ad=0.2128p pd=1.5u as=0.2128p ps=1.5u w=1.12u l=0.13u
X4788 VDD.t1116 sg13cmos5l_a21oi_1_9.A2 a_13460_6924# VDD.t2 sg13_lv_pmos ad=0.2128p pd=1.5u as=0.2128p ps=1.5u w=1.12u l=0.13u
X4789 VDD.t670 a_9466_18226# a_9185_18448# VDD.t231 sg13_lv_pmos ad=0.1523p pd=1.38u as=0.34p ps=2.68u w=1u l=0.5u
X4790 a_15820_9186# a_15607_9150# VDD.t52 VDD.t52 sg13_lv_pmos ad=79.8f pd=0.8u as=1.8716p ps=12.115u w=0.42u l=0.13u
X4791 VDD.t782 a_21466_7642# a_21185_7864# VDD.t8 sg13_lv_pmos ad=0.1523p pd=1.38u as=0.34p ps=2.68u w=1u l=0.5u
X4792 sg13cmos5l_dfrbpq_1_30.D a_21462_17532# VSS.t435 VSS.t225 sg13_lv_nmos ad=0.2516p pd=2.16u as=0.1426p ps=1.16u w=0.74u l=0.13u
X4793 a_7858_16742# sg13cmos5l_buf_1_66.X VSS.t839 VSS.t838 sg13_lv_nmos ad=0.2516p pd=2.16u as=0.1406p ps=1.12u w=0.74u l=0.15u
X4794 a_11152_12430# sg13cmos5l_dfrbpq_1_13.RESET_B VDD.t83 VDD.t83 sg13_lv_pmos ad=79.8f pd=0.8u as=2.51485p ps=16.46u w=0.42u l=0.13u
X4795 VSS.t2073 VDD.t13 VSS.t2072 VSS.t2071 sg13_lv_nmos ad=0.1428p pd=1.52u as=0 ps=0 w=0.42u l=1u
X4796 VDD.t1758 a_6670_18447# sg13cmos5l_dfrbpq_1_20.D VDD.t231 sg13_lv_pmos ad=0.2254p pd=1.53u as=0.4256p ps=3u w=1.12u l=0.13u
X4797 a_8540_17488# sg13cmos5l_o21ai_1_18.A2 sg13cmos5l_o21ai_1_19.B1 VDD.t310 sg13_lv_pmos ad=0.2128p pd=1.5u as=0.2128p ps=1.5u w=1.12u l=0.15u
X4798 a_18094_9375# a_18209_9376# VDD.t995 VDD.t52 sg13_lv_pmos ad=0.34p pd=2.68u as=0.2254p ps=1.53u w=1u l=0.5u
X4799 a_5230_19959# a_5345_19960# VDD.t851 VDD.t270 sg13_lv_pmos ad=0.34p pd=2.68u as=0.2254p ps=1.53u w=1u l=0.5u
X4800 sg13cmos5l_dlygate4sd3_1_16.A a_22506_9948# VSS.t547 VSS.t546 sg13_lv_nmos ad=0.2516p pd=2.16u as=0.1406p ps=1.12u w=0.74u l=0.13u
X4801 a_21838_19959# a_21953_19960# VSS.t1056 VSS.t1055 sg13_lv_nmos ad=0.1428p pd=1.52u as=0.1426p ps=1.16u w=0.42u l=0.5u
X4802 a_12134_19458# a_12939_19031# a_12394_18988# VDD.t231 sg13_lv_pmos ad=0.1428p pd=1.52u as=79.8f ps=0.8u w=0.42u l=0.13u
X4803 sg13cmos5l_buf_8_2.A a_12987_12214# VSS.t153 VSS.t2625 sg13_lv_nmos ad=0.1406p pd=1.12u as=0.1406p ps=1.12u w=0.74u l=0.13u
X4804 VDD.t1277 sg13cmos5l_buf_1_5.A sg13cmos5l_dlygate4sd3_1_25.A VDD.t0 sg13_lv_pmos ad=0.3808p pd=2.92u as=0.2128p ps=1.5u w=1.12u l=0.15u
X4805 VDD.t979 a_14842_9154# a_14561_9376# VDD.t52 sg13_lv_pmos ad=0.1523p pd=1.38u as=0.34p ps=2.68u w=1u l=0.5u
X4806 sg13cmos5l_a21o_1_2.A1 a_7446_14508# VSS.t124 VSS.t1309 sg13_lv_nmos ad=0.2516p pd=2.16u as=0.1426p ps=1.16u w=0.74u l=0.13u
X4807 VDD.t1262 sg13cmos5l_buf_8_2.A a_12987_10318# VDD.t52 sg13_lv_pmos ad=0.2128p pd=1.5u as=0.2128p ps=1.5u w=1.12u l=0.13u
X4808 a_11150_9232# sg13cmos5l_a21o_1_0.A1 a_10771_9380# VSS.t2356 sg13_lv_nmos ad=81.6f pd=0.895u as=0.1216p ps=1.02u w=0.64u l=0.13u
X4809 a_22096_4870# sg13cmos5l_buf_1_7.X VDD.t5 VDD.t5 sg13_lv_pmos ad=79.8f pd=0.8u as=1.8716p ps=12.115u w=0.42u l=0.13u
X4810 VDD.t384 sg13cmos5l_nor2b_1_1.A sg13cmos5l_o21ai_1_14.A1 VDD.t310 sg13_lv_pmos ad=0.2128p pd=1.5u as=0.2128p ps=1.5u w=1.12u l=0.13u
X4811 VSS.t113 a_15280_17750# a_14929_17869# VSS.t112 sg13_lv_nmos ad=79.8f pd=0.8u as=0.1428p ps=1.52u w=0.42u l=0.13u
X4812 VSS.t46 sg13cmos5l_buf_1_66.X a_8410_14854# VSS.t837 sg13_lv_nmos ad=0.2516p pd=2.16u as=0.1406p ps=1.12u w=0.74u l=0.13u
X4813 sg13cmos5l_nand3_1_8.Y sg13cmos5l_nand4_1_1.A VDD.t1446 VDD.t83 sg13_lv_pmos ad=0.2128p pd=1.5u as=0.2128p ps=1.5u w=1.12u l=0.13u
X4814 VDD.t52 a_12016_10190# a_11961_10071# VDD.t52 sg13_lv_pmos ad=1.8716p pd=12.115u as=93.45f ps=0.865u w=0.42u l=0.13u
X4815 VDD.t583 VSS.t1915 VDD.t586 VDD.t5 sg13_lv_pmos ad=0.34p pd=2.68u as=0 ps=0 w=1u l=1u
X4816 a_20997_14495# sg13cmos5l_dfrbpq_1_5.CLK VDD.t19 VDD.t19 sg13_lv_pmos ad=0.4088p pd=2.97u as=2.07625p ps=13.51u w=1.12u l=0.13u
X4817 sg13cmos5l_dfrbpq_1_19.CLK a_7498_18226# VDD.t2035 VDD.t231 sg13_lv_pmos ad=0.2128p pd=1.5u as=0.2128p ps=1.5u w=1.12u l=0.13u
X4818 a_16078_9186# a_16319_9456# a_15607_9150# VSS.t2202 sg13_lv_nmos ad=0.1428p pd=1.52u as=0.12665p ps=1.145u w=0.42u l=0.13u
X4819 VDD.t202 VSS.t2150 VDD.t15 VDD.t13 sg13_lv_pmos ad=0.19p pd=1.38u as=0 ps=0 w=1u l=1u
X4820 VSS.t1870 VDD.t2472 VSS.t1869 VSS.t1868 sg13_lv_nmos ad=0.1428p pd=1.52u as=0 ps=0 w=0.42u l=1u
X4821 VDD.t8 a_21839_8797# a_22096_8678# VDD.t8 sg13_lv_pmos ad=1.8716p pd=12.115u as=79.8f ps=0.8u w=0.42u l=0.13u
X4822 a_20580_8440# a_20554_8404# VSS.t15 VSS.t732 sg13_lv_nmos ad=0.2516p pd=2.16u as=0.1626p ps=1.415u w=0.74u l=0.13u
X4823 sg13cmos5l_o21ai_1_0.A1 a_14061_8784# VDD.t941 VDD.t8 sg13_lv_pmos ad=0.3808p pd=2.92u as=0.1918p ps=1.5u w=1.12u l=0.13u
X4824 a_18730_17476# a_19173_17519# a_18470_17946# VSS.t240 sg13_lv_nmos ad=79.8f pd=0.8u as=0.1296p ps=1.52u w=0.42u l=0.13u
X4825 a_20580_14040# a_20554_13945# VSS.t396 VSS.t128 sg13_lv_nmos ad=0.2516p pd=2.16u as=0.1626p ps=1.415u w=0.74u l=0.13u
X4826 VDD.t1438 a_19930_12936# a_19649_13238# VDD.t83 sg13_lv_pmos ad=0.1523p pd=1.38u as=0.34p ps=2.68u w=1u l=0.5u
X4827 VSS.t850 a_17804_4614# sg13cmos5l_buf_1_13.X VSS.t891 sg13_lv_nmos ad=0.14875p pd=1.16u as=0.2886p ps=2.26u w=0.74u l=0.13u
X4828 a_5019_17137# a_4127_17016# a_4917_16904# VDD.t310 sg13_lv_pmos ad=63f pd=0.72u as=79.8f ps=0.8u w=0.42u l=0.13u
X4829 VSS.t1737 VDD.t2520 VSS.t1736 VSS.t1735 sg13_lv_nmos ad=0.1428p pd=1.52u as=0 ps=0 w=0.42u l=1u
X4830 a_17718_16754# sg13cmos5l_buf_1_42.A sg13cmos5l_a21oi_1_24.A2 VSS.t1234 sg13_lv_nmos ad=0.1406p pd=1.12u as=0.2516p ps=2.16u w=0.74u l=0.13u
X4831 a_10461_11730# sg13cmos5l_mux2_1_1.A1 VDD.t934 VDD.t0 sg13_lv_pmos ad=0.2856p pd=2.36u as=0.2198p ps=1.53u w=0.84u l=0.13u
X4832 VDD.t16 sg13cmos5l_buf_1_15.A.t4 a_20716_16434# VDD.t16 sg13_lv_pmos ad=2.07625p pd=13.51u as=79.8f ps=0.8u w=0.42u l=0.13u
X4833 VSS.t2010 VDD.t2420 VSS.t2010 VSS.t2011 sg13_lv_nmos ad=79.8f pd=0.8u as=0 ps=0 w=0.42u l=1u
R0 VDD.n38 VDD.t1932 17.3952
R1 VDD.n73 VDD.t1575 17.3693
R2 VDD.n479 VDD.t378 17.3693
R3 VDD.n946 VDD.t362 17.3693
R4 VDD.n66 VDD.t369 17.3693
R5 VDD.n403 VDD.t1992 17.3693
R6 VDD.n443 VDD.t360 17.3693
R7 VDD.n565 VDD.t377 17.3693
R8 VDD.n152 VDD.t1566 17.3693
R9 VDD.n395 VDD.t659 17.3693
R10 VDD.n894 VDD.t374 17.3693
R11 VDD.n363 VDD.t1297 17.3693
R12 VDD.n399 VDD.t1043 17.3693
R13 VDD.n116 VDD.t365 17.3693
R14 VDD.n580 VDD.t2126 17.3693
R15 VDD.n869 VDD.t724 17.3693
R16 VDD.n500 VDD.t1187 17.3693
R17 VDD.n476 VDD.t1568 17.3693
R18 VDD.n90 VDD.t1034 17.3693
R19 VDD.n441 VDD.t1560 17.3693
R20 VDD.n847 VDD.t1041 17.3693
R21 VDD.n97 VDD.t1040 17.3693
R22 VDD.n124 VDD.t363 17.3693
R23 VDD.n831 VDD.t1558 17.3693
R24 VDD.n14 VDD.t1514 17.3693
R25 VDD.n405 VDD.t844 17.3693
R26 VDD.n467 VDD.t1306 17.3693
R27 VDD.n383 VDD.t1513 17.3693
R28 VDD.n77 VDD.t868 17.3693
R29 VDD.n77 VDD.t1026 17.3693
R30 VDD.n172 VDD.t888 17.3693
R31 VDD.n19 VDD.t864 17.3693
R32 VDD.n413 VDD.t1632 17.3693
R33 VDD.n417 VDD.t1336 17.3693
R34 VDD.n421 VDD.t1325 17.3693
R35 VDD.n8 VDD.t1509 17.3693
R36 VDD.n409 VDD.t1309 17.3693
R37 VDD.n161 VDD.t1254 17.3693
R38 VDD.n675 VDD.t1255 17.3693
R39 VDD.n462 VDD.t897 17.3693
R40 VDD.n629 VDD.t1507 17.3693
R41 VDD.n643 VDD.t1505 17.3693
R42 VDD.n641 VDD.t1501 17.3693
R43 VDD.n139 VDD.t1503 17.3693
R44 VDD.n193 VDD.t893 17.3693
R45 VDD.n463 VDD.t1756 17.3693
R46 VDD.n709 VDD.t892 17.3693
R47 VDD.n536 VDD.t889 17.3693
R48 VDD.n723 VDD.t1536 17.3693
R49 VDD.n110 VDD.t2134 17.366
R50 VDD.n262 VDD.t1186 17.3585
R51 VDD.n71 VDD.t2337 17.3517
R52 VDD.n947 VDD.t1435 17.3517
R53 VDD.n66 VDD.t1844 17.3517
R54 VDD.n39 VDD.t886 17.3517
R55 VDD.n38 VDD.t903 17.3517
R56 VDD.n50 VDD.t1423 17.3517
R57 VDD.n226 VDD.t1991 17.3517
R58 VDD.n560 VDD.t1990 17.3517
R59 VDD.n574 VDD.t686 17.3517
R60 VDD.n354 VDD.t2283 17.3517
R61 VDD.n904 VDD.t1123 17.3517
R62 VDD.n398 VDD.t796 17.3517
R63 VDD.n362 VDD.t2105 17.3517
R64 VDD.n910 VDD.t2113 17.3517
R65 VDD.n69 VDD.t2338 17.3517
R66 VDD.n863 VDD.t2103 17.3517
R67 VDD.n58 VDD.t1934 17.3517
R68 VDD.n855 VDD.t847 17.3517
R69 VDD.n90 VDD.t2335 17.3517
R70 VDD.n106 VDD.t1091 17.3517
R71 VDD.n96 VDD.t2309 17.3517
R72 VDD.n95 VDD.t2285 17.3517
R73 VDD.n849 VDD.t709 17.3517
R74 VDD.n156 VDD.t1913 17.3517
R75 VDD.n14 VDD.t1586 17.3517
R76 VDD.n364 VDD.t1687 17.3517
R77 VDD.n817 VDD.t1798 17.3517
R78 VDD.n382 VDD.t856 17.3517
R79 VDD.n79 VDD.t2290 17.3517
R80 VDD.n78 VDD.t1025 17.3517
R81 VDD.n431 VDD.t829 17.3517
R82 VDD.n454 VDD.t1672 17.3517
R83 VDD.n772 VDD.t1031 17.3517
R84 VDD.n377 VDD.t978 17.3517
R85 VDD.n736 VDD.t1483 17.3517
R86 VDD.n741 VDD.t1211 17.3517
R87 VDD.n745 VDD.t1088 17.3517
R88 VDD.n5 VDD.t1645 17.3517
R89 VDD.n618 VDD.t1045 17.3517
R90 VDD.t231 VDD.t1776 17.3517
R91 VDD.n655 VDD.t1620 17.3517
R92 VDD.n645 VDD.t1614 17.3517
R93 VDD.n639 VDD.t1489 17.3517
R94 VDD.n436 VDD.t2172 17.3517
R95 VDD.n661 VDD.t1523 17.3517
R96 VDD.n115 VDD.t1774 17.3517
R97 VDD.n711 VDD.t2218 17.3517
R98 VDD.n715 VDD.t1462 17.3517
R99 VDD.n450 VDD.t2045 17.3517
R100 VDD.n26 VDD.t797 17.3326
R101 VDD.n307 VDD.t1200 17.3326
R102 VDD.n307 VDD.t2110 17.3326
R103 VDD.n950 VDD.t719 17.3326
R104 VDD.n940 VDD.t1965 17.3326
R105 VDD.n110 VDD.t1360 17.3326
R106 VDD.n444 VDD.t1246 17.3326
R107 VDD.n569 VDD.t1069 17.3326
R108 VDD.n558 VDD.t765 17.3326
R109 VDD.n228 VDD.t980 17.3326
R110 VDD.n553 VDD.t781 17.3326
R111 VDD.n196 VDD.t1753 17.3326
R112 VDD.n403 VDD.t1180 17.3326
R113 VDD.n0 VDD.t1250 17.3326
R114 VDD.n435 VDD.t940 17.3326
R115 VDD.n917 VDD.t1239 17.3326
R116 VDD.n929 VDD.t1185 17.3326
R117 VDD.n446 VDD.t1170 17.3326
R118 VDD.n22 VDD.t782 17.3326
R119 VDD.n429 VDD.t1370 17.3326
R120 VDD.n891 VDD.t1124 17.3326
R121 VDD.n427 VDD.t1223 17.3326
R122 VDD.n232 VDD.t780 17.3326
R123 VDD.n231 VDD.t1263 17.3326
R124 VDD.n900 VDD.t652 17.3326
R125 VDD.n448 VDD.t826 17.3326
R126 VDD.n90 VDD.t994 17.3326
R127 VDD.n68 VDD.t653 17.3326
R128 VDD.n356 VDD.t656 17.3326
R129 VDD.n210 VDD.t979 17.3326
R130 VDD.n182 VDD.t2277 17.3326
R131 VDD.n475 VDD.t1015 17.3326
R132 VDD.n861 VDD.t718 17.3326
R133 VDD.n210 VDD.t1175 17.3326
R134 VDD.n881 VDD.t674 17.3326
R135 VDD.n884 VDD.t1942 17.3326
R136 VDD.n69 VDD.t1220 17.3326
R137 VDD.n886 VDD.t1006 17.3326
R138 VDD.n90 VDD.t1458 17.3326
R139 VDD.n169 VDD.t871 17.3326
R140 VDD.n124 VDD.t1004 17.3326
R141 VDD.n133 VDD.t1954 17.3326
R142 VDD.n95 VDD.t706 17.3326
R143 VDD.n94 VDD.t1389 17.3326
R144 VDD.n59 VDD.t695 17.3326
R145 VDD.n94 VDD.t744 17.3326
R146 VDD.n347 VDD.t1701 17.3326
R147 VDD.n154 VDD.t1350 17.3326
R148 VDD.n425 VDD.t1638 17.3326
R149 VDD.n102 VDD.t696 17.3326
R150 VDD.n366 VDD.t1438 17.3326
R151 VDD.n405 VDD.t1028 17.3326
R152 VDD.n241 VDD.t925 17.3326
R153 VDD.n798 VDD.t1764 17.3326
R154 VDD.n299 VDD.t717 17.3326
R155 VDD.n129 VDD.t1067 17.3326
R156 VDD.n7 VDD.t687 17.3326
R157 VDD.n118 VDD.t2082 17.3326
R158 VDD.n431 VDD.t1754 17.3326
R159 VDD.n413 VDD.t725 17.3326
R160 VDD.n305 VDD.t647 17.3326
R161 VDD.n149 VDD.t1070 17.3326
R162 VDD.n125 VDD.t1127 17.3326
R163 VDD.n149 VDD.t1362 17.3326
R164 VDD.n10 VDD.t1426 17.3326
R165 VDD.n36 VDD.t877 17.3326
R166 VDD.n358 VDD.t746 17.3326
R167 VDD.n754 VDD.t1019 17.3326
R168 VDD.n752 VDD.t1540 17.3326
R169 VDD.n409 VDD.t1542 17.3326
R170 VDD.n135 VDD.t855 17.3326
R171 VDD.n208 VDD.t956 17.3326
R172 VDD.n8 VDD.t861 17.3326
R173 VDD.n208 VDD.t1607 17.3326
R174 VDD.n206 VDD.t1626 17.3326
R175 VDD.n235 VDD.t396 17.3326
R176 VDD.t310 VDD.t860 17.3326
R177 VDD.t310 VDD.t1092 17.3326
R178 VDD.n5 VDD.t1864 17.3326
R179 VDD.n766 VDD.t1897 17.3326
R180 VDD.n769 VDD.t922 17.3326
R181 VDD.n665 VDD.t671 17.3326
R182 VDD.n115 VDD.t1796 17.3326
R183 VDD.n626 VDD.t1147 17.3326
R184 VDD.n484 VDD.t669 17.3326
R185 VDD.n401 VDD.t670 17.3326
R186 VDD.n437 VDD.t1778 17.3326
R187 VDD.n287 VDD.t1628 17.3326
R188 VDD.n631 VDD.t1312 17.3326
R189 VDD.n658 VDD.t1639 17.3326
R190 VDD.t231 VDD.t2275 17.3326
R191 VDD.n625 VDD.t798 17.3326
R192 VDD.n211 VDD.t842 17.3326
R193 VDD.n670 VDD.t1771 17.3326
R194 VDD.n620 VDD.t1532 17.3326
R195 VDD.n699 VDD.t1436 17.3326
R196 VDD.n702 VDD.t1488 17.3326
R197 VDD.n704 VDD.t1775 17.3326
R198 VDD.n707 VDD.t1779 17.3326
R199 VDD.n731 VDD.t1243 17.3326
R200 VDD.n687 VDD.t665 17.3326
R201 VDD.n180 VDD.t2220 17.3326
R202 VDD.n728 VDD.t2173 17.3326
R203 VDD.n178 VDD.t2171 17.3326
R204 VDD.n174 VDD.t2214 17.3326
R205 VDD.n387 VDD.t738 17.2755
R206 VDD.n215 VDD.t2014 17.2755
R207 VDD.n27 VDD.t2055 17.2581
R208 VDD.n264 VDD.t1904 17.2506
R209 VDD.n26 VDD.t825 17.2247
R210 VDD.n26 VDD.t812 17.2247
R211 VDD.n26 VDD.t675 17.2247
R212 VDD.n222 VDD.t926 17.2247
R213 VDD.n223 VDD.t991 17.2247
R214 VDD.n237 VDD.t849 17.2247
R215 VDD.n237 VDD.t1009 17.2247
R216 VDD.n223 VDD.t1167 17.2247
R217 VDD.n222 VDD.t1103 17.2247
R218 VDD.n25 VDD.t1174 17.2247
R219 VDD.n25 VDD.t789 17.2247
R220 VDD.n545 VDD.t732 17.2247
R221 VDD.n545 VDD.t721 17.2247
R222 VDD.n144 VDD.t1113 17.2247
R223 VDD.n410 VDD.t2334 17.2247
R224 VDD.n66 VDD.t992 17.2247
R225 VDD.n66 VDD.t1696 17.2247
R226 VDD.n66 VDD.t1767 17.2247
R227 VDD.n66 VDD.t1279 17.2247
R228 VDD.n376 VDD.t1002 17.2247
R229 VDD.n110 VDD.t1179 17.2247
R230 VDD.n196 VDD.t1116 17.2247
R231 VDD.n546 VDD.t792 17.2247
R232 VDD.n228 VDD.t655 17.2247
R233 VDD.n40 VDD.t1112 17.2247
R234 VDD.n927 VDD.t1012 17.2247
R235 VDD.n152 VDD.t1164 17.2247
R236 VDD.n434 VDD.t2238 17.2247
R237 VDD.n397 VDD.t1288 17.2247
R238 VDD.n888 VDD.t1295 17.2247
R239 VDD.n399 VDD.t678 17.2247
R240 VDD.n909 VDD.t1578 17.2247
R241 VDD.n579 VDD.t824 17.2247
R242 VDD.n867 VDD.t2024 17.2247
R243 VDD.n870 VDD.t1437 17.2247
R244 VDD.n872 VDD.t1968 17.2247
R245 VDD.n883 VDD.t689 17.2247
R246 VDD.n141 VDD.t814 17.2247
R247 VDD.n142 VDD.t1828 17.2247
R248 VDD.n142 VDD.t386 17.2247
R249 VDD.n142 VDD.t1022 17.2247
R250 VDD.n330 VDD.t742 17.2247
R251 VDD.n101 VDD.t663 17.2247
R252 VDD.n848 VDD.t392 17.2247
R253 VDD.n215 VDD.t1172 17.2247
R254 VDD.n157 VDD.t1596 17.2247
R255 VDD.n833 VDD.t804 17.2247
R256 VDD.n122 VDD.t1691 17.2247
R257 VDD.n373 VDD.t1368 17.2247
R258 VDD.n592 VDD.t1549 17.2247
R259 VDD.n220 VDD.t747 17.2247
R260 VDD.n91 VDD.t693 17.2247
R261 VDD.n391 VDD.t694 17.2247
R262 VDD.n491 VDD.t794 17.2247
R263 VDD.n485 VDD.t882 17.2247
R264 VDD.n91 VDD.t1594 17.2247
R265 VDD.n220 VDD.t705 17.2247
R266 VDD.n594 VDD.t938 17.2247
R267 VDD.n590 VDD.t1073 17.2247
R268 VDD.n595 VDD.t702 17.2247
R269 VDD.n79 VDD.t1694 17.2247
R270 VDD.n7 VDD.t703 17.2247
R271 VDD.n7 VDD.t680 17.2247
R272 VDD.n439 VDD.t1703 17.2247
R273 VDD.n383 VDD.t1078 17.2247
R274 VDD.n791 VDD.t803 17.2247
R275 VDD.n303 VDD.t644 17.2247
R276 VDD.n303 VDD.t1905 17.2247
R277 VDD.n806 VDD.t1482 17.2247
R278 VDD.n805 VDD.t1342 17.2247
R279 VDD.n803 VDD.t845 17.2247
R280 VDD.n801 VDD.t753 17.2247
R281 VDD.n467 VDD.t1752 17.2247
R282 VDD.n800 VDD.t816 17.2247
R283 VDD.n225 VDD.t905 17.2247
R284 VDD.n197 VDD.t685 17.2247
R285 VDD.n79 VDD.t899 17.2247
R286 VDD.n394 VDD.t726 17.2247
R287 VDD.n614 VDD.t1348 17.2247
R288 VDD.n18 VDD.t1349 17.2247
R289 VDD.n18 VDD.t1480 17.2247
R290 VDD.n502 VDD.t1839 17.2247
R291 VDD.n455 VDD.t729 17.2247
R292 VDD.n412 VDD.t1072 17.2247
R293 VDD.n113 VDD.t1301 17.2247
R294 VDD.n113 VDD.t727 17.2247
R295 VDD.n113 VDD.t1077 17.2247
R296 VDD.n112 VDD.t1191 17.2247
R297 VDD.n19 VDD.t683 17.2247
R298 VDD.n164 VDD.t809 17.2247
R299 VDD.n159 VDD.t712 17.2247
R300 VDD.n17 VDD.t1670 17.2247
R301 VDD.n17 VDD.t1610 17.2247
R302 VDD.n188 VDD.t1122 17.2247
R303 VDD.n666 VDD.t1769 17.2247
R304 VDD.n663 VDD.t2262 17.2247
R305 VDD.n453 VDD.t1311 17.2247
R306 VDD.n678 VDD.t929 17.2247
R307 VDD.n733 VDD.t1366 17.2247
R308 VDD.n689 VDD.t1293 17.2247
R309 VDD.n684 VDD.t2071 17.2247
R310 VDD.n682 VDD.t2180 17.2247
R311 VDD.n727 VDD.t852 17.2247
R312 VDD.n726 VDD.t927 17.2247
R313 VDD.n222 VDD.n130 0.300609
R314 VDD.n224 VDD.t13 1.58941
R315 VDD.n224 VDD.n237 0.510365
R316 VDD.n505 VDD.t13 5.61512
R317 VDD.n15 VDD.n181 0.091496
R318 VDD.n54 VDD.n163 0.353752
R319 VDD.n527 VDD.n47 0.21293
R320 VDD.n482 VDD.n250 0.220067
R321 VDD.n250 VDD.n248 0.0638698
R322 VDD.n155 VDD.t5 1.2965
R323 VDD.n71 VDD.t1298 17.0005
R324 VDD.t5 VDD.n480 3.31341
R325 VDD.n947 VDD.t375 17.0005
R326 VDD.n66 VDD.t379 17.0005
R327 VDD.n39 VDD.t371 17.0005
R328 VDD.n38 VDD.t2108 17.0005
R329 VDD.n404 VDD.n403 0.224424
R330 VDD.t2 VDD.n51 1.21266
R331 VDD.n51 VDD.n196 0.462264
R332 VDD.n110 VDD.n111 0.350351
R333 VDD.n40 VDD.t2 0.800726
R334 VDD.n435 VDD.n397 0.121689
R335 VDD.t2 VDD.n278 1.99335
R336 VDD.n229 VDD.n228 0.178
R337 VDD.n50 VDD.t730 17.0005
R338 VDD.n226 VDD.t376 17.0005
R339 VDD.n560 VDD.t364 17.0005
R340 VDD.n574 VDD.t1564 17.0005
R341 VDD.n430 VDD.n363 0.262947
R342 VDD.t8 VDD.n296 1.33035
R343 VDD.n419 VDD.n418 0.127368
R344 VDD.n240 VDD.n346 0.341223
R345 VDD.t8 VDD.n537 5.64901
R346 VDD.n201 VDD.n1 0.489293
R347 VDD.t8 VDD.n428 1.29256
R348 VDD.n428 VDD.n429 0.232688
R349 VDD.n291 VDD.n290 0.122441
R350 VDD.t8 VDD.n483 1.76044
R351 VDD.t8 VDD.n355 3.34921
R352 VDD.n319 VDD.n353 0.173595
R353 VDD.n354 VDD.t993 17.0005
R354 VDD.t8 VDD.n460 2.36951
R355 VDD.n494 VDD.n514 0.315598
R356 VDD.n341 VDD.n342 0.162709
R357 VDD.n334 VDD.n342 0.518724
R358 VDD.t8 VDD.n342 2.04762
R359 VDD.n333 VDD.n516 0.338448
R360 VDD.t8 VDD.n333 2.35052
R361 VDD.n471 VDD.n331 0.315598
R362 VDD.t8 VDD.n185 4.15224
R363 VDD.n904 VDD.t361 17.0005
R364 VDD.n398 VDD.t811 17.0005
R365 VDD.n362 VDD.t1044 17.0005
R366 VDD.n910 VDD.t366 17.0005
R367 VDD.n400 VDD.n68 0.225315
R368 VDD.n191 VDD.n210 0.220144
R369 VDD.t52 VDD.n385 1.0101
R370 VDD.n385 VDD.n384 0.440212
R371 VDD.n477 VDD.n476 0.174958
R372 VDD.n375 VDD.n374 0.214713
R373 VDD.n69 VDD.t2089 17.0005
R374 VDD.t52 VDD.n357 1.1278
R375 VDD.n357 VDD.n457 0.320932
R376 VDD.n863 VDD.t1555 17.0005
R377 VDD.n58 VDD.t846 17.0005
R378 VDD.n855 VDD.t1569 17.0005
R379 VDD.n90 VDD.t1037 17.0005
R380 VDD.n170 VDD.n169 0.120199
R381 VDD.n93 VDD.n330 0.729886
R382 VDD.t0 VDD.n60 0.531117
R383 VDD.n127 VDD.n101 0.289996
R384 VDD.n127 VDD.n142 0.496336
R385 VDD.n134 VDD.n133 0.292619
R386 VDD.t0 VDD.n282 1.79668
R387 VDD.n106 VDD.t391 17.0005
R388 VDD.n96 VDD.t1036 17.0005
R389 VDD.n95 VDD.t1039 17.0005
R390 VDD.n849 VDD.t368 17.0005
R391 VDD.n406 VDD.n405 0.224418
R392 VDD.t83 VDD.n365 17.0005
R393 VDD.t83 VDD.n407 1.13606
R394 VDD.n221 VDD.n220 0.204697
R395 VDD.t83 VDD.n221 1.99795
R396 VDD.t83 VDD.n120 0.991002
R397 VDD.n122 VDD.n154 0.194738
R398 VDD.n158 VDD.n157 0.133162
R399 VDD.t83 VDD.n216 2.29764
R400 VDD.n156 VDD.t1557 17.0005
R401 VDD.n14 VDD.t1492 17.0005
R402 VDD.n364 VDD.t708 17.0005
R403 VDD.n79 VDD.n118 0.393092
R404 VDD.n62 VDD.n118 1.34967
R405 VDD.n198 VDD.n197 0.22512
R406 VDD.t19 VDD.n198 1.99314
R407 VDD.t19 VDD.n440 4.17915
R408 VDD.n440 VDD.n439 0.187608
R409 VDD.t19 VDD.n466 2.03582
R410 VDD.n318 VDD.n317 0.20646
R411 VDD.n817 VDD.t1247 17.0005
R412 VDD.t19 VDD.n129 2.03504
R413 VDD.n368 VDD.n128 0.140406
R414 VDD.n242 VDD.n241 0.154965
R415 VDD.n205 VDD.n204 0.30398
R416 VDD.t19 VDD.n380 2.75013
R417 VDD.t19 VDD.n277 1.17103
R418 VDD.n344 VDD.n360 0.188139
R419 VDD.n344 VDD.n343 0.139756
R420 VDD.t19 VDD.n344 2.35291
R421 VDD.n337 VDD.n511 0.338448
R422 VDD.t19 VDD.n337 2.35052
R423 VDD.n469 VDD.n335 0.315598
R424 VDD.t19 VDD.n187 4.15224
R425 VDD.n382 VDD.t1496 17.0005
R426 VDD.n79 VDD.t869 17.0005
R427 VDD.n78 VDD.t1066 17.0005
R428 VDD.t16 VDD.n456 2.04645
R429 VDD.n456 VDD.n502 0.39294
R430 VDD.n431 VDD.t887 17.0005
R431 VDD.n114 VDD.n113 0.465405
R432 VDD.n414 VDD.n413 0.276164
R433 VDD.t16 VDD.n293 1.34525
R434 VDD.n125 VDD.n149 0.615036
R435 VDD.n126 VDD.n125 0.26144
R436 VDD.n454 VDD.t684 17.0005
R437 VDD.n772 VDD.t1195 17.0005
R438 VDD.t16 VDD.n396 2.77689
R439 VDD.n146 VDD.n165 0.314999
R440 VDD.t16 VDD.n379 2.74058
R441 VDD.n377 VDD.t707 17.0005
R442 VDD.t16 VDD.n359 1.1278
R443 VDD.n359 VDD.n458 0.320932
R444 VDD.t310 VDD.n420 1.57783
R445 VDD.t310 VDD.n520 1.69793
R446 VDD.n160 VDD.n159 0.136799
R447 VDD.t310 VDD.n286 1.61523
R448 VDD.n286 VDD.n752 0.30938
R449 VDD.n244 VDD.n392 0.184862
R450 VDD.t310 VDD.n311 2.76788
R451 VDD.n137 VDD.n518 0.519537
R452 VDD.t310 VDD.n137 1.74275
R453 VDD.n137 VDD.n136 0.525352
R454 VDD.n411 VDD.n135 0.273316
R455 VDD.t310 VDD.n411 1.29241
R456 VDD.t310 VDD.n207 1.52219
R457 VDD.t310 VDD.n743 17.0005
R458 VDD.n736 VDD.t1102 17.0005
R459 VDD.n741 VDD.t1510 17.0005
R460 VDD.n745 VDD.t1308 17.0005
R461 VDD.n5 VDD.t1062 17.0005
R462 VDD.t231 VDD.n530 1.69793
R463 VDD.t231 VDD.n464 1.7829
R464 VDD.t231 VDD.n461 1.7829
R465 VDD.n194 VDD.t231 4.18812
R466 VDD.t231 VDD.n167 5.6006
R467 VDD.n438 VDD.n437 0.121689
R468 VDD.t231 VDD.n288 0.774504
R469 VDD.n618 VDD.t1228 17.0005
R470 VDD.n349 VDD.n340 0.338448
R471 VDD.n340 VDD.t231 2.35052
R472 VDD.n338 VDD.n493 0.315598
R473 VDD.n190 VDD.t231 4.15224
R474 VDD.t231 VDD.t896 17.0005
R475 VDD.n655 VDD.t1508 17.0005
R476 VDD.n645 VDD.t1506 17.0005
R477 VDD.n639 VDD.t1498 17.0005
R478 VDD.n436 VDD.t1502 17.0005
R479 VDD.n661 VDD.t894 17.0005
R480 VDD.n115 VDD.t1757 17.0005
R481 VDD.n175 VDD.t270 1.72299
R482 VDD.t270 VDD.n178 1.7748
R483 VDD.n452 VDD.t270 1.57548
R484 VDD.n711 VDD.t891 17.0005
R485 VDD.n715 VDD.t664 17.0005
R486 VDD.n450 VDD.t1535 17.0005
R487 VDD.n937 VDD.t2424 15.2621
R488 VDD.n936 VDD.t2426 15.2621
R489 VDD.n27 VDD.t2429 15.2621
R490 VDD.n954 VDD.t2418 15.2621
R491 VDD.n195 VDD.t2450 15.2621
R492 VDD.n34 VDD.t2451 15.2621
R493 VDD.n2 VDD.t2468 15.2621
R494 VDD.n492 VDD.t2469 15.2621
R495 VDD.n106 VDD.t2496 15.2621
R496 VDD.n103 VDD.t2513 15.2621
R497 VDD.n381 VDD.t2530 15.2621
R498 VDD.n18 VDD.t2542 15.2621
R499 VDD.n350 VDD.t2556 15.2621
R500 VDD.n724 VDD.t2563 15.2621
R501 VDD.n504 VDD.t2398 15.2617
R502 VDD.n34 VDD.t2460 15.2617
R503 VDD.n110 VDD.t2459 15.2617
R504 VDD.n897 VDD.t2475 15.2617
R505 VDD.n106 VDD.t2505 15.2617
R506 VDD.n312 VDD.t2537 15.2617
R507 VDD.n53 VDD.t2546 15.2617
R508 VDD.n734 VDD.n80 14.1658
R509 VDD.n45 VDD.n957 14.1658
R510 VDD.n735 VDD.n617 14.1658
R511 VDD.n352 VDD.n734 13.5005
R512 VDD.n52 VDD.n495 13.5005
R513 VDD.n788 VDD.n53 13.5005
R514 VDD.n824 VDD.n343 13.5005
R515 VDD.n3 VDD.n825 13.5005
R516 VDD.n265 VDD.n496 13.5005
R517 VDD.n887 VDD.n75 13.5005
R518 VDD.n913 VDD.n341 13.5005
R519 VDD.n131 VDD.n914 13.5005
R520 VDD.n107 VDD.n497 13.5005
R521 VDD.n958 VDD.t268 13.5005
R522 VDD.n957 VDD.n38 13.5005
R523 VDD.n933 VDD.n489 13.5005
R524 VDD.n230 VDD.n498 13.5005
R525 VDD.n182 VDD.n853 13.5005
R526 VDD.n852 VDD.n59 13.5005
R527 VDD.n836 VDD.n103 13.5005
R528 VDD.n283 VDD.n295 13.5005
R529 VDD.n455 VDD.n771 13.5005
R530 VDD.n770 VDD.t310 13.5005
R531 VDD.n735 VDD.n194 13.5005
R532 VDD.n730 VDD.t872 8.95263
R533 VDD.n609 VDD.t1821 8.84404
R534 VDD.n103 VDD.t1110 8.79392
R535 VDD.n67 VDD.t1182 8.769
R536 VDD.n607 VDD.t1169 8.769
R537 VDD.n410 VDD.t787 8.76264
R538 VDD.n489 VDD.t1347 8.76264
R539 VDD.n152 VDD.t1434 8.76264
R540 VDD.n435 VDD.t1979 8.76264
R541 VDD.n40 VDD.t1249 8.76264
R542 VDD.n859 VDD.t863 8.76264
R543 VDD.n101 VDD.t934 8.76264
R544 VDD.n157 VDD.t932 8.76264
R545 VDD.n302 VDD.t1229 8.76264
R546 VDD.n874 VDD.t2091 8.76207
R547 VDD.n500 VDD.t784 8.76207
R548 VDD.n299 VDD.t698 8.76207
R549 VDD.n308 VDD.t1430 8.76154
R550 VDD.n66 VDD.t921 8.76154
R551 VDD.n110 VDD.t1271 8.76154
R552 VDD.n573 VDD.t1166 8.76154
R553 VDD.n567 VDD.t1163 8.76154
R554 VDD.n563 VDD.t1011 8.76154
R555 VDD.n555 VDD.t1119 8.76154
R556 VDD.n551 VDD.t807 8.76154
R557 VDD.n549 VDD.t1744 8.76154
R558 VDD.n547 VDD.t988 8.76154
R559 VDD.n443 VDD.t986 8.76154
R560 VDD.n426 VDD.t984 8.76154
R561 VDD.n227 VDD.t982 8.76154
R562 VDD.n51 VDD.t857 8.76154
R563 VDD.n40 VDD.t1159 8.76154
R564 VDD.n931 VDD.t1007 8.76154
R565 VDD.n893 VDD.t1094 8.76154
R566 VDD.n116 VDD.t937 8.76154
R567 VDD.n427 VDD.t2044 8.76154
R568 VDD.n310 VDD.t821 8.76154
R569 VDD.n575 VDD.t2195 8.76154
R570 VDD.n90 VDD.t835 8.76154
R571 VDD.n90 VDD.t833 8.76154
R572 VDD.n90 VDD.t831 8.76154
R573 VDD.n90 VDD.t830 8.76154
R574 VDD.n90 VDD.t1749 8.76154
R575 VDD.n90 VDD.t1937 8.76154
R576 VDD.n69 VDD.t995 8.76154
R577 VDD.n457 VDD.t1944 8.76154
R578 VDD.n209 VDD.t2132 8.76154
R579 VDD.n384 VDD.t1130 8.76154
R580 VDD.n416 VDD.t1014 8.76154
R581 VDD.n415 VDD.t1819 8.76154
R582 VDD.n878 VDD.t1269 8.76154
R583 VDD.n873 VDD.t1160 8.76154
R584 VDD.n499 VDD.t1291 8.76154
R585 VDD.n837 VDD.t649 8.76154
R586 VDD.n24 VDD.t947 8.76154
R587 VDD.n218 VDD.t783 8.76154
R588 VDD.n133 VDD.t990 8.76154
R589 VDD.n846 VDD.t1949 8.76154
R590 VDD.n844 VDD.t1407 8.76154
R591 VDD.n842 VDD.t1406 8.76154
R592 VDD.n441 VDD.t2157 8.76154
R593 VDD.n841 VDD.t2155 8.76154
R594 VDD.n281 VDD.t2153 8.76154
R595 VDD.n97 VDD.t920 8.76154
R596 VDD.n94 VDD.t2018 8.76154
R597 VDD.n366 VDD.t1427 8.76154
R598 VDD.n91 VDD.t1344 8.76154
R599 VDD.n91 VDD.t1711 8.76154
R600 VDD.n391 VDD.t1449 8.76154
R601 VDD.n490 VDD.t2361 8.76154
R602 VDD.n491 VDD.t2365 8.76154
R603 VDD.n102 VDD.t2363 8.76154
R604 VDD.n102 VDD.t1138 8.76154
R605 VDD.n103 VDD.t1136 8.76154
R606 VDD.n367 VDD.t643 8.76154
R607 VDD.n796 VDD.t953 8.76154
R608 VDD.n129 VDD.t723 8.76154
R609 VDD.n172 VDD.t1071 8.76154
R610 VDD.n774 VDD.t950 8.76154
R611 VDD.n148 VDD.t1013 8.76154
R612 VDD.n149 VDD.t969 8.76154
R613 VDD.n164 VDD.t808 8.76154
R614 VDD.n417 VDD.t1140 8.76154
R615 VDD.n458 VDD.t1059 8.76154
R616 VDD.n761 VDD.t917 8.76154
R617 VDD.n759 VDD.t915 8.76154
R618 VDD.n757 VDD.t913 8.76154
R619 VDD.n755 VDD.t912 8.76154
R620 VDD.n161 VDD.t1746 8.76154
R621 VDD.n5 VDD.t1783 8.76154
R622 VDD.n750 VDD.t902 8.76154
R623 VDD.n29 VDD.t1577 8.7727
R624 VDD.n206 VDD.t1663 8.76154
R625 VDD.n389 VDD.t1704 8.76154
R626 VDD.n463 VDD.t881 8.76154
R627 VDD.n115 VDD.t657 8.76154
R628 VDD.t231 VDD.t2351 8.76154
R629 VDD.t231 VDD.t1793 8.76154
R630 VDD.t231 VDD.t1791 8.76154
R631 VDD.t231 VDD.t1789 8.76154
R632 VDD.t231 VDD.t1787 8.76154
R633 VDD.n28 VDD.t1146 8.82323
R634 VDD.n166 VDD.t713 8.76154
R635 VDD.n633 VDD.t1609 8.76154
R636 VDD.n651 VDD.t1741 8.76154
R637 VDD.n139 VDD.t1740 8.76154
R638 VDD.n139 VDD.t2037 8.76154
R639 VDD.n139 VDD.t2035 8.76154
R640 VDD.n139 VDD.t2033 8.76154
R641 VDD.n649 VDD.t1758 8.76154
R642 VDD.n701 VDD.t1534 8.76154
R643 VDD.n696 VDD.t1538 8.76154
R644 VDD.n706 VDD.t1800 8.76154
R645 VDD.n693 VDD.t1412 8.76154
R646 VDD.n719 VDD.t1207 8.76154
R647 VDD.n179 VDD.t2216 8.76154
R648 VDD.n176 VDD.t2169 8.76154
R649 VDD.n177 VDD.t2213 8.76154
R650 VDD.n173 VDD.t851 8.76154
R651 VDD.n110 VDD.t662 8.76107
R652 VDD.n280 VDD.t1333 8.76107
R653 VDD.n18 VDD.t681 8.76107
R654 VDD.n26 VDD.t2139 8.76054
R655 VDD.n308 VDD.t720 8.76054
R656 VDD.n942 VDD.t936 8.76054
R657 VDD.n51 VDD.t1176 8.76054
R658 VDD.n0 VDD.t2019 8.76054
R659 VDD.n915 VDD.t2026 8.76054
R660 VDD.n925 VDD.t2251 8.76054
R661 VDD.n40 VDD.t1382 8.76054
R662 VDD.n40 VDD.t2095 8.76054
R663 VDD.n40 VDD.t1117 8.76054
R664 VDD.n890 VDD.t766 8.76054
R665 VDD.n429 VDD.t1936 8.76054
R666 VDD.n230 VDD.t906 8.76054
R667 VDD.n232 VDD.t2146 8.76054
R668 VDD.n233 VDD.t941 8.76054
R669 VDD.n363 VDD.t1374 8.76054
R670 VDD.n260 VDD.t1217 8.76054
R671 VDD.n182 VDD.t1260 8.76054
R672 VDD.n280 VDD.t1262 8.76054
R673 VDD.n585 VDD.t1466 8.76054
R674 VDD.n384 VDD.t1468 8.76054
R675 VDD.n384 VDD.t1470 8.76054
R676 VDD.n209 VDD.t1093 8.76054
R677 VDD.n191 VDD.t989 8.76054
R678 VDD.n582 VDD.t1008 8.76054
R679 VDD.n69 VDD.t2206 8.76054
R680 VDD.n68 VDD.t1272 8.76054
R681 VDD.n90 VDD.t1964 8.76054
R682 VDD.n370 VDD.t1838 8.76054
R683 VDD.n371 VDD.t827 8.76054
R684 VDD.n59 VDD.t1048 8.76054
R685 VDD.n59 VDD.t740 8.76054
R686 VDD.n94 VDD.t1410 8.76054
R687 VDD.n330 VDD.t1804 8.76054
R688 VDD.n330 VDD.t790 8.76054
R689 VDD.n432 VDD.t968 8.76054
R690 VDD.n386 VDD.t1056 8.76054
R691 VDD.n387 VDD.t933 8.76054
R692 VDD.n387 VDD.t923 8.76054
R693 VDD.n153 VDD.t1373 8.76054
R694 VDD.n422 VDD.t819 8.76054
R695 VDD.n390 VDD.t757 8.76054
R696 VDD.n425 VDD.t1323 8.76054
R697 VDD.n587 VDD.t1296 8.76054
R698 VDD.n597 VDD.t2353 8.76054
R699 VDD.n599 VDD.t1597 8.76054
R700 VDD.n601 VDD.t1598 8.76054
R701 VDD.n602 VDD.t1600 8.76054
R702 VDD.n604 VDD.t1602 8.76054
R703 VDD.n789 VDD.t676 8.76054
R704 VDD.n814 VDD.t1054 8.76054
R705 VDD.n474 VDD.t931 8.76054
R706 VDD.n474 VDD.t802 8.76054
R707 VDD.n439 VDD.t688 8.76054
R708 VDD.n7 VDD.t1244 8.76054
R709 VDD.n7 VDD.t1803 8.76054
R710 VDD.n18 VDD.t1773 8.76054
R711 VDD.n778 VDD.t682 8.76054
R712 VDD.n149 VDD.t715 8.76054
R713 VDD.n613 VDD.t810 8.76054
R714 VDD.n36 VDD.t1327 8.76054
R715 VDD.n744 VDD.t646 8.76054
R716 VDD.n389 VDD.t645 8.76054
R717 VDD.n135 VDD.t357 8.76054
R718 VDD.n234 VDD.t384 8.76054
R719 VDD.n217 VDD.t1021 8.76054
R720 VDD.n123 VDD.t1326 8.76054
R721 VDD.t310 VDD.t1087 8.76054
R722 VDD.n5 VDD.t710 8.76054
R723 VDD.n767 VDD.t901 8.76054
R724 VDD.n421 VDD.t1030 8.76054
R725 VDD.n638 VDD.t1490 8.76054
R726 VDD.n654 VDD.t1522 8.76054
R727 VDD.n659 VDD.t1653 8.76054
R728 VDD.t231 VDD.t2263 8.76054
R729 VDD.n462 VDD.t799 8.76054
R730 VDD.n664 VDD.t1612 8.76054
R731 VDD.n672 VDD.t1531 8.76054
R732 VDD.n674 VDD.t1616 8.76054
R733 VDD.n101 VDD.t999 8.74512
R734 VDD.n144 VDD.t1118 8.73192
R735 VDD.n67 VDD.t1184 8.73192
R736 VDD.n59 VDD.t1710 8.73192
R737 VDD.n59 VDD.t759 8.73192
R738 VDD.n373 VDD.t1686 8.73192
R739 VDD.n369 VDD.t1545 8.73192
R740 VDD.n369 VDD.t1713 8.73192
R741 VDD.n369 VDD.t1582 8.73192
R742 VDD.n118 VDD.t1712 8.73192
R743 VDD.n118 VDD.t1581 8.73192
R744 VDD.n7 VDD.t1636 8.73192
R745 VDD.n7 VDD.t1680 8.73192
R746 VDD.n7 VDD.t1685 8.73192
R747 VDD.n7 VDD.t884 8.73192
R748 VDD.n7 VDD.t1681 8.73192
R749 VDD.n197 VDD.t1723 8.73192
R750 VDD.n225 VDD.t1683 8.73192
R751 VDD.n225 VDD.t1707 8.73192
R752 VDD.n112 VDD.t679 8.73192
R753 VDD.n113 VDD.t1781 8.73192
R754 VDD.n5 VDD.t1546 8.73192
R755 VDD.n5 VDD.t1589 8.73192
R756 VDD.n17 VDD.t1637 8.73192
R757 VDD.n17 VDD.t1592 8.73192
R758 VDD.n159 VDD.t1708 8.73192
R759 VDD.n159 VDD.t1590 8.73192
R760 VDD.n285 VDD.t885 8.73192
R761 VDD.n285 VDD.t1591 8.73192
R762 VDD.n0 VDD.t2200 8.73093
R763 VDD.n290 VDD.t1183 8.73093
R764 VDD.n294 VDD.t1369 8.73093
R765 VDD.n91 VDD.t1446 8.73093
R766 VDD.n369 VDD.t749 8.73093
R767 VDD.n369 VDD.t1714 8.73093
R768 VDD.n373 VDD.t1584 8.73093
R769 VDD.n373 VDD.t1715 8.73093
R770 VDD.n7 VDD.t1721 8.73093
R771 VDD.n7 VDD.t1679 8.73093
R772 VDD.n118 VDD.t1726 8.73093
R773 VDD.n118 VDD.t1684 8.73093
R774 VDD.n18 VDD.t1903 8.73093
R775 VDD.n19 VDD.t1587 8.73093
R776 VDD.n19 VDD.t748 8.73093
R777 VDD.n783 VDD.t2047 8.73093
R778 VDD.n780 VDD.t1593 8.73093
R779 VDD.n146 VDD.t691 8.73093
R780 VDD.n392 VDD.t383 8.73093
R781 VDD.n38 VDD.t2237 8.71923
R782 VDD.n898 VDD.t1818 8.71923
R783 VDD.n432 VDD.t1277 8.71923
R784 VDD.n793 VDD.t1061 8.71923
R785 VDD.n455 VDD.t1863 8.71923
R786 VDD.n502 VDD.t1060 8.71923
R787 VDD.n36 VDD.t1017 8.71923
R788 VDD.n36 VDD.t1664 8.71923
R789 VDD.n36 VDD.t930 8.71923
R790 VDD.n747 VDD.t2264 8.71923
R791 VDD.t310 VDD.t1064 8.71923
R792 VDD.n217 VDD.t1647 8.71923
R793 VDD.n217 VDD.t791 8.71923
R794 VDD.n136 VDD.t1210 8.71923
R795 VDD.n135 VDD.t1367 8.71923
R796 VDD.n110 VDD.t760 8.71823
R797 VDD.n67 VDD.t2111 8.71823
R798 VDD.n346 VDD.t2137 8.71823
R799 VDD.n306 VDD.t2202 8.71823
R800 VDD.n612 VDD.t1815 8.71823
R801 VDD.n301 VDD.t1543 8.71823
R802 VDD.n9 VDD.t2170 8.71823
R803 VDD.n9 VDD.t928 8.71823
R804 VDD.n136 VDD.t394 8.71823
R805 VDD.n136 VDD.t2070 8.71823
R806 VDD.n123 VDD.t2057 8.71823
R807 VDD.t310 VDD.t1292 8.71823
R808 VDD.n484 VDD.t2184 8.71823
R809 VDD.n309 VDD.t13 1.43713
R810 VDD.n445 VDD.n444 0.24235
R811 VDD.n447 VDD.n446 0.242312
R812 VDD.n449 VDD.n448 0.242312
R813 VDD.n203 VDD.n202 0.0783236
R814 VDD.n345 VDD.n537 0.0296553
R815 VDD.n540 VDD.t5 5.64879
R816 VDD.n410 VDD.n155 0.291185
R817 VDD.n955 VDD.n541 0.0768462
R818 VDD.n544 VDD.t270 5.64879
R819 VDD.n54 VDD.t13 0.325167
R820 VDD.t16 VDD.n773 8.48418
R821 VDD.t310 VDD.n737 8.48418
R822 VDD.t8 VDD.n889 8.48045
R823 VDD.t19 VDD.n792 8.48045
R824 VDD.n677 VDD.t231 8.48045
R825 VDD.t13 VDD.n243 1.9761
R826 VDD.n25 VDD.n243 0.22736
R827 VDD.n130 VDD.t13 1.27321
R828 VDD.n247 VDD.n238 0.0959984
R829 VDD.n238 VDD.t13 1.45958
R830 VDD.n239 VDD.n505 0.229165
R831 VDD.n506 VDD.n478 0.365047
R832 VDD.t13 VDD.n478 4.1963
R833 VDD.n15 VDD.t13 1.08078
R834 VDD.n46 VDD.n45 0.0490136
R835 VDD.t13 VDD.n46 0.138603
R836 VDD.t13 VDD.n47 0.678816
R837 VDD.n539 VDD.t13 3.32534
R838 VDD.t5 VDD.n108 0.478576
R839 VDD.n248 VDD.t5 2.02157
R840 VDD.n144 VDD.n145 0.16846
R841 VDD.n73 VDD.t5 1.09306
R842 VDD.t5 VDD.n83 0.60978
R843 VDD.t5 VDD.n37 0.651628
R844 VDD.n37 VDD.n39 0.230516
R845 VDD.n479 VDD.n935 0.140705
R846 VDD.n480 VDD.n479 0.0675881
R847 VDD.t5 VDD.n945 8.47111
R848 VDD.t5 VDD.n541 4.20591
R849 VDD.n111 VDD.t2 0.694207
R850 VDD.n932 VDD.t2 8.47111
R851 VDD.n928 VDD.t2 8.47111
R852 VDD.n924 VDD.t2 8.47111
R853 VDD.n922 VDD.t2 8.47111
R854 VDD.n152 VDD.n151 0.132119
R855 VDD.n151 VDD.t2 2.30355
R856 VDD.n920 VDD.t2 8.47111
R857 VDD.t2 VDD.n548 8.47111
R858 VDD.n426 VDD.n443 0.119605
R859 VDD.n278 VDD.n426 0.205205
R860 VDD.t2 VDD.n566 8.47111
R861 VDD.t2 VDD.n564 8.47111
R862 VDD.t2 VDD.n559 8.47111
R863 VDD.t2 VDD.n556 8.47111
R864 VDD.n85 VDD.t2 0.60978
R865 VDD.t8 VDD.n906 8.47111
R866 VDD.n430 VDD.n399 0.263001
R867 VDD.t8 VDD.n430 1.5786
R868 VDD.n418 VDD.n306 0.229762
R869 VDD.t8 VDD.n419 2.7243
R870 VDD.t8 VDD.n289 1.08677
R871 VDD.n289 VDD.n310 0.215086
R872 VDD.t8 VDD.n240 1.13119
R873 VDD.t8 VDD.n201 1.63682
R874 VDD.t8 VDD.n2 0.626316
R875 VDD.n290 VDD.n294 0.243651
R876 VDD.n355 VDD.n395 0.276767
R877 VDD.t8 VDD.n494 2.75275
R878 VDD.t8 VDD.n471 2.75275
R879 VDD.n185 VDD.n184 0.169135
R880 VDD.t52 VDD.n100 0.436608
R881 VDD.t52 VDD.n70 1.9087
R882 VDD.t52 VDD.n581 8.47111
R883 VDD.t52 VDD.n882 8.47111
R884 VDD.t52 VDD.n279 8.47111
R885 VDD.t52 VDD.n183 0.891215
R886 VDD.t52 VDD.n879 8.47111
R887 VDD.t52 VDD.n854 8.47111
R888 VDD.t52 VDD.n375 1.60108
R889 VDD.t52 VDD.n858 8.47111
R890 VDD.n104 VDD.n58 0.477591
R891 VDD.n105 VDD.n104 0.0524316
R892 VDD.t52 VDD.n871 8.47111
R893 VDD.t52 VDD.n868 8.47111
R894 VDD.n109 VDD.n262 0.403817
R895 VDD.t52 VDD.n109 0.618881
R896 VDD.n98 VDD.n97 0.0957451
R897 VDD.t0 VDD.n347 1.57649
R898 VDD.t0 VDD.n348 2.30256
R899 VDD.n348 VDD.n329 0.12907
R900 VDD.n60 VDD.n92 0.986494
R901 VDD.n59 VDD.n371 0.780761
R902 VDD.t0 VDD.n370 4.20521
R903 VDD.n219 VDD.n264 0.140453
R904 VDD.t0 VDD.n219 1.20309
R905 VDD.t0 VDD.n843 8.47111
R906 VDD.n442 VDD.n441 0.119605
R907 VDD.t0 VDD.n442 4.177
R908 VDD.n282 VDD.n841 0.225037
R909 VDD.n33 VDD.n106 0.786745
R910 VDD.t0 VDD.n87 0.60978
R911 VDD.t83 VDD.n203 4.2188
R912 VDD.t83 VDD.n603 8.47111
R913 VDD.t83 VDD.n600 8.47111
R914 VDD.t83 VDD.n598 8.47111
R915 VDD.n407 VDD.n369 0.297699
R916 VDD.t83 VDD.n589 8.47111
R917 VDD.t83 VDD.n591 8.47111
R918 VDD.t83 VDD.n593 8.47111
R919 VDD.n120 VDD.n485 0.462374
R920 VDD.t83 VDD.n391 2.36347
R921 VDD.t83 VDD.n423 2.72109
R922 VDD.n423 VDD.n422 0.135406
R923 VDD.n372 VDD.n491 0.241186
R924 VDD.t83 VDD.n372 2.02871
R925 VDD.t83 VDD.n103 0.934125
R926 VDD.t83 VDD.n832 8.47111
R927 VDD.n157 VDD.n830 0.196493
R928 VDD.t83 VDD.n158 2.72105
R929 VDD.t83 VDD.n14 0.73483
R930 VDD.t83 VDD.n4 0.848081
R931 VDD.t83 VDD.n89 0.60978
R932 VDD.t19 VDD.n62 0.338508
R933 VDD.t19 VDD.n822 8.47111
R934 VDD.n440 VDD.n821 0.214861
R935 VDD.t19 VDD.n799 8.47111
R936 VDD.t19 VDD.n807 8.47111
R937 VDD.n304 VDD.n303 0.119605
R938 VDD.t19 VDD.n304 4.177
R939 VDD.t19 VDD.n811 8.47111
R940 VDD.t19 VDD.n473 2.76104
R941 VDD.t19 VDD.n813 8.47111
R942 VDD.t19 VDD.n815 8.47111
R943 VDD.n368 VDD.n367 0.112647
R944 VDD.t19 VDD.n368 1.82456
R945 VDD.t19 VDD.n242 5.60338
R946 VDD.t19 VDD.n469 2.75275
R947 VDD.n187 VDD.n186 0.169135
R948 VDD.n456 VDD.n455 0.102306
R949 VDD.t16 VDD.n503 2.76044
R950 VDD.t16 VDD.n393 8.47111
R951 VDD.t16 VDD.n615 8.47111
R952 VDD.t16 VDD.n20 0.891852
R953 VDD.t16 VDD.n781 8.47111
R954 VDD.t16 VDD.n784 8.47111
R955 VDD.t16 VDD.n608 8.47111
R956 VDD.n147 VDD.n146 0.173395
R957 VDD.t16 VDD.n36 0.938381
R958 VDD.n378 VDD.n612 0.208324
R959 VDD.n379 VDD.n378 0.0712099
R960 VDD.t310 VDD.n763 8.47111
R961 VDD.t310 VDD.n760 8.47111
R962 VDD.t310 VDD.n758 8.47111
R963 VDD.t310 VDD.n756 8.47111
R964 VDD.n161 VDD.n755 0.175682
R965 VDD.n162 VDD.n161 0.129688
R966 VDD.t310 VDD.n162 2.721
R967 VDD.t310 VDD.n6 0.647301
R968 VDD.n6 VDD.n5 0.197001
R969 VDD.n6 VDD.n17 1.22362
R970 VDD.n159 VDD.n17 0.197233
R971 VDD.t310 VDD.n160 2.72244
R972 VDD.n286 VDD.n285 0.385484
R973 VDD.t310 VDD.n748 8.47111
R974 VDD.t310 VDD.n519 2.76044
R975 VDD.n29 VDD.n746 0.168774
R976 VDD.t310 VDD.n123 1.04651
R977 VDD.n123 VDD.n168 0.351449
R978 VDD.t310 VDD.n244 2.03421
R979 VDD.t231 VDD.n676 8.47111
R980 VDD.t231 VDD.n115 3.34604
R981 VDD.t231 VDD.n628 8.47111
R982 VDD.t231 VDD.n630 8.47111
R983 VDD.t231 VDD.n657 8.47111
R984 VDD.n167 VDD.n166 0.0818905
R985 VDD.t231 VDD.n140 1.51728
R986 VDD.n140 VDD.n139 0.449379
R987 VDD.n437 VDD.n138 0.137209
R988 VDD.t231 VDD.n438 3.30696
R989 VDD.t231 VDD.n647 8.47111
R990 VDD.n493 VDD.t231 2.75275
R991 VDD.n189 VDD.n190 0.169135
R992 VDD.n725 VDD.n532 0.272394
R993 VDD.n532 VDD.t270 4.177
R994 VDD.n531 VDD.t270 4.177
R995 VDD.n727 VDD.n534 0.254894
R996 VDD.n534 VDD.t270 4.177
R997 VDD.n174 VDD.n175 0.222301
R998 VDD.n529 VDD.t270 3.30688
R999 VDD.n528 VDD.t270 4.177
R1000 VDD.n180 VDD.t270 2.01372
R1001 VDD.n451 VDD.n452 0.158578
R1002 VDD.n729 VDD.n451 0.285799
R1003 VDD.t270 VDD.n686 8.47111
R1004 VDD.n80 VDD.n81 0.178499
R1005 VDD.n49 VDD.t2397 7.62628
R1006 VDD.n48 VDD.t2396 7.62628
R1007 VDD.n526 VDD.t2395 7.62628
R1008 VDD.n315 VDD.t2394 7.62628
R1009 VDD.n56 VDD.t2393 7.62628
R1010 VDD.n56 VDD.t2392 7.62628
R1011 VDD.n163 VDD.t2391 7.62628
R1012 VDD.n65 VDD.t2390 7.62628
R1013 VDD.n64 VDD.t2389 7.62628
R1014 VDD.n45 VDD.t2388 7.62628
R1015 VDD.n44 VDD.t2387 7.62628
R1016 VDD.n41 VDD.t2386 7.62628
R1017 VDD.n45 VDD.t2385 7.62628
R1018 VDD.n45 VDD.t2384 7.62628
R1019 VDD.n16 VDD.t2383 7.62628
R1020 VDD.n63 VDD.t2382 7.62628
R1021 VDD.n16 VDD.t2381 7.62628
R1022 VDD.n181 VDD.t2380 7.62628
R1023 VDD.n523 VDD.t2379 7.62628
R1024 VDD.n506 VDD.t2378 7.62628
R1025 VDD.n246 VDD.t2377 7.62628
R1026 VDD.n249 VDD.t2425 7.62628
R1027 VDD.n72 VDD.t2427 7.62628
R1028 VDD.n83 VDD.t2439 7.62628
R1029 VDD.n83 VDD.t2438 7.62628
R1030 VDD.n252 VDD.t2437 7.62628
R1031 VDD.n322 VDD.t2436 7.62628
R1032 VDD.n76 VDD.t2435 7.62628
R1033 VDD.n76 VDD.t2434 7.62628
R1034 VDD.n76 VDD.t2433 7.62628
R1035 VDD.n76 VDD.t2432 7.62628
R1036 VDD.n76 VDD.t2431 7.62628
R1037 VDD.n27 VDD.t2430 7.62628
R1038 VDD.n73 VDD.t2428 7.62628
R1039 VDD.n934 VDD.t2419 7.62628
R1040 VDD.n39 VDD.t2420 7.62628
R1041 VDD.n38 VDD.t2421 7.62628
R1042 VDD.n38 VDD.t2422 7.62628
R1043 VDD.n38 VDD.t2423 7.62628
R1044 VDD.n85 VDD.t2458 7.62628
R1045 VDD.n85 VDD.t2457 7.62628
R1046 VDD.n255 VDD.t2456 7.62628
R1047 VDD.n324 VDD.t2455 7.62628
R1048 VDD.n34 VDD.t2454 7.62628
R1049 VDD.n34 VDD.t2453 7.62628
R1050 VDD.n34 VDD.t2452 7.62628
R1051 VDD.n184 VDD.t2474 7.62628
R1052 VDD.n517 VDD.t2473 7.62628
R1053 VDD.n515 VDD.t2472 7.62628
R1054 VDD.n334 VDD.t2471 7.62628
R1055 VDD.n513 VDD.t2470 7.62628
R1056 VDD.n75 VDD.t2487 7.62628
R1057 VDD.n75 VDD.t2486 7.62628
R1058 VDD.n261 VDD.t2485 7.62628
R1059 VDD.n313 VDD.t2484 7.62628
R1060 VDD.n263 VDD.t2495 7.62628
R1061 VDD.n320 VDD.t2494 7.62628
R1062 VDD.n87 VDD.t2503 7.62628
R1063 VDD.n87 VDD.t2502 7.62628
R1064 VDD.n267 VDD.t2501 7.62628
R1065 VDD.n326 VDD.t2500 7.62628
R1066 VDD.n32 VDD.t2499 7.62628
R1067 VDD.n32 VDD.t2498 7.62628
R1068 VDD.n31 VDD.t2497 7.62628
R1069 VDD.n89 VDD.t2523 7.62628
R1070 VDD.n89 VDD.t2522 7.62628
R1071 VDD.n275 VDD.t2521 7.62628
R1072 VDD.n328 VDD.t2520 7.62628
R1073 VDD.n4 VDD.t2519 7.62628
R1074 VDD.n272 VDD.t2518 7.62628
R1075 VDD.n14 VDD.t2517 7.62628
R1076 VDD.n13 VDD.t2516 7.62628
R1077 VDD.n269 VDD.t2515 7.62628
R1078 VDD.n121 VDD.t2514 7.62628
R1079 VDD.n186 VDD.t2535 7.62628
R1080 VDD.n512 VDD.t2534 7.62628
R1081 VDD.n510 VDD.t2533 7.62628
R1082 VDD.n509 VDD.t2532 7.62628
R1083 VDD.n213 VDD.t2531 7.62628
R1084 VDD.n53 VDD.t2543 7.62628
R1085 VDD.n53 VDD.t2544 7.62628
R1086 VDD.n53 VDD.t2545 7.62628
R1087 VDD.n74 VDD.t2551 7.62628
R1088 VDD.n74 VDD.t2550 7.62628
R1089 VDD.n52 VDD.t2549 7.62628
R1090 VDD.n189 VDD.t2559 7.62628
R1091 VDD.n508 VDD.t2558 7.62628
R1092 VDD.n507 VDD.t2557 7.62628
R1093 VDD.n80 VDD.t2564 7.62628
R1094 VDD.t617 VDD.t2417 7.62594
R1095 VDD.t617 VDD.t2416 7.62594
R1096 VDD.n525 VDD.t2415 7.62594
R1097 VDD.n314 VDD.t2414 7.62594
R1098 VDD.n61 VDD.t2413 7.62594
R1099 VDD.n55 VDD.t2412 7.62594
R1100 VDD.n163 VDD.t2411 7.62594
R1101 VDD.n65 VDD.t2410 7.62594
R1102 VDD.n65 VDD.t2409 7.62594
R1103 VDD.n45 VDD.t2408 7.62594
R1104 VDD.n43 VDD.t2407 7.62594
R1105 VDD.n45 VDD.t2406 7.62594
R1106 VDD.n45 VDD.t2405 7.62594
R1107 VDD.n42 VDD.t2404 7.62594
R1108 VDD.n16 VDD.t2403 7.62594
R1109 VDD.n16 VDD.t2402 7.62594
R1110 VDD.n16 VDD.t2401 7.62594
R1111 VDD.n181 VDD.t2400 7.62594
R1112 VDD.n522 VDD.t2399 7.62594
R1113 VDD.n83 VDD.t2449 7.62594
R1114 VDD.n83 VDD.t2448 7.62594
R1115 VDD.n251 VDD.t2447 7.62594
R1116 VDD.n321 VDD.t2446 7.62594
R1117 VDD.n132 VDD.t2445 7.62594
R1118 VDD.n76 VDD.t2444 7.62594
R1119 VDD.n76 VDD.t2443 7.62594
R1120 VDD.n76 VDD.t2442 7.62594
R1121 VDD.n76 VDD.t2441 7.62594
R1122 VDD.n27 VDD.t2440 7.62594
R1123 VDD.n85 VDD.t2467 7.62594
R1124 VDD.n85 VDD.t2466 7.62594
R1125 VDD.n254 VDD.t2465 7.62594
R1126 VDD.n323 VDD.t2464 7.62594
R1127 VDD.n34 VDD.t2463 7.62594
R1128 VDD.n34 VDD.t2462 7.62594
R1129 VDD.n34 VDD.t2461 7.62594
R1130 VDD.n2 VDD.t2477 7.62594
R1131 VDD.n199 VDD.t2476 7.62594
R1132 VDD.n355 VDD.t2478 7.62594
R1133 VDD.n472 VDD.t2483 7.62594
R1134 VDD.n332 VDD.t2482 7.62594
R1135 VDD.n341 VDD.t2481 7.62594
R1136 VDD.n334 VDD.t2480 7.62594
R1137 VDD.n319 VDD.t2479 7.62594
R1138 VDD.n457 VDD.t2493 7.62594
R1139 VDD.n356 VDD.t2492 7.62594
R1140 VDD.n75 VDD.t2491 7.62594
R1141 VDD.n257 VDD.t2490 7.62594
R1142 VDD.n104 VDD.t2489 7.62594
R1143 VDD.n58 VDD.t2488 7.62594
R1144 VDD.n101 VDD.t2504 7.62594
R1145 VDD.n87 VDD.t2512 7.62594
R1146 VDD.n87 VDD.t2511 7.62594
R1147 VDD.n266 VDD.t2510 7.62594
R1148 VDD.n325 VDD.t2509 7.62594
R1149 VDD.n32 VDD.t2508 7.62594
R1150 VDD.n32 VDD.t2507 7.62594
R1151 VDD.n30 VDD.t2506 7.62594
R1152 VDD.n89 VDD.t2529 7.62594
R1153 VDD.n89 VDD.t2528 7.62594
R1154 VDD.n274 VDD.t2527 7.62594
R1155 VDD.n327 VDD.t2526 7.62594
R1156 VDD.n4 VDD.t2525 7.62594
R1157 VDD.n271 VDD.t2524 7.62594
R1158 VDD.n129 VDD.t2536 7.62594
R1159 VDD.n470 VDD.t2541 7.62594
R1160 VDD.n336 VDD.t2540 7.62594
R1161 VDD.n343 VDD.t2539 7.62594
R1162 VDD.n361 VDD.t2538 7.62594
R1163 VDD.n358 VDD.t2547 7.62594
R1164 VDD.n458 VDD.t2548 7.62594
R1165 VDD.n74 VDD.t2555 7.62594
R1166 VDD.n74 VDD.t2554 7.62594
R1167 VDD.n52 VDD.t2553 7.62594
R1168 VDD.n52 VDD.t2552 7.62594
R1169 VDD.n468 VDD.t2562 7.62594
R1170 VDD.n339 VDD.t2561 7.62594
R1171 VDD.n351 VDD.t2560 7.62594
R1172 VDD.n829 VDD.t1052 6.13684
R1173 VDD.n827 VDD.t1090 6.13684
R1174 VDD.n698 VDD.t1919 6.07165
R1175 VDD.n481 VDD.t779 6.0222
R1176 VDD.n889 VDD.t173 6.02101
R1177 VDD.n792 VDD.t630 6.02101
R1178 VDD.n677 VDD.t308 6.02101
R1179 VDD.n457 VDD.t77 6.11246
R1180 VDD.n458 VDD.t316 6.11246
R1181 VDD.n53 VDD.t345 6.00339
R1182 VDD.n353 VDD.t446 6.00295
R1183 VDD.n352 VDD.t511 6.00295
R1184 VDD.n258 VDD.t445 5.99589
R1185 VDD.n260 VDD.t213 5.99545
R1186 VDD.n213 VDD.t228 5.99545
R1187 VDD.n247 VDD.t2286 5.99122
R1188 VDD.n376 VDD.t768 5.98925
R1189 VDD.n0 VDD.t1134 5.98925
R1190 VDD.n292 VDD.t763 5.98925
R1191 VDD.n116 VDD.t2060 5.98925
R1192 VDD.n294 VDD.t1125 5.98925
R1193 VDD.n306 VDD.t661 5.98925
R1194 VDD.n880 VDD.t1264 5.98925
R1195 VDD.n58 VDD.t1985 5.98925
R1196 VDD.n124 VDD.t1273 5.98925
R1197 VDD.n202 VDD.t1275 5.98925
R1198 VDD.n154 VDD.t667 5.98925
R1199 VDD.n283 VDD.t700 5.98925
R1200 VDD.n823 VDD.t735 5.98925
R1201 VDD.n125 VDD.t955 5.98925
R1202 VDD.n52 VDD.t874 5.98925
R1203 VDD.n764 VDD.t1454 5.98925
R1204 VDD.n668 VDD.t672 5.98925
R1205 VDD.n453 VDD.t859 5.98925
R1206 VDD.n194 VDD.t1520 5.98925
R1207 VDD.n287 VDD.t1484 5.98925
R1208 VDD.n710 VDD.t1413 5.98925
R1209 VDD.n713 VDD.t1431 5.98925
R1210 VDD.n722 VDD.t2176 5.98925
R1211 VDD.n144 VDD.t1149 5.98882
R1212 VDD.n66 VDD.t1150 5.98882
R1213 VDD.n944 VDD.t2211 5.98882
R1214 VDD.n557 VDD.t1282 5.98882
R1215 VDD.n444 VDD.t1290 5.98882
R1216 VDD.n907 VDD.t1029 5.98882
R1217 VDD.n446 VDD.t1927 5.98882
R1218 VDD.n374 VDD.t1158 5.98882
R1219 VDD.n416 VDD.t1202 5.98882
R1220 VDD.n448 VDD.t996 5.98882
R1221 VDD.n218 VDD.t716 5.98882
R1222 VDD.n839 VDD.t358 5.98882
R1223 VDD.n214 VDD.t1705 5.98882
R1224 VDD.n204 VDD.t1198 5.98882
R1225 VDD.n823 VDD.t1135 5.98882
R1226 VDD.n113 VDD.t854 5.98882
R1227 VDD.n148 VDD.t823 5.98882
R1228 VDD.n53 VDD.t801 5.98882
R1229 VDD.n285 VDD.t1595 5.98882
R1230 VDD.n765 VDD.t1377 5.98882
R1231 VDD.n635 VDD.t1657 5.98882
R1232 VDD.n401 VDD.t1527 5.98882
R1233 VDD.t231 VDD.t2261 5.98882
R1234 VDD.n669 VDD.t1475 5.98882
R1235 VDD.n67 VDD.t2239 5.98829
R1236 VDD.n67 VDD.t1199 5.98829
R1237 VDD.n1 VDD.t1451 5.98829
R1238 VDD.n1 VDD.t2240 5.98829
R1239 VDD.n230 VDD.t1390 5.98829
R1240 VDD.n231 VDD.t1132 5.98829
R1241 VDD.n346 VDD.t1381 5.98829
R1242 VDD.n346 VDD.t1452 5.98829
R1243 VDD.n374 VDD.t1977 5.98829
R1244 VDD.n374 VDD.t2348 5.98829
R1245 VDD.n347 VDD.t1361 5.98829
R1246 VDD.n347 VDD.t2107 5.98829
R1247 VDD.n329 VDD.t1709 5.98829
R1248 VDD.n329 VDD.t1343 5.98829
R1249 VDD.n59 VDD.t817 5.98829
R1250 VDD.n371 VDD.t756 5.98829
R1251 VDD.n91 VDD.t1143 5.98829
R1252 VDD.n91 VDD.t1284 5.98829
R1253 VDD.n485 VDD.t1144 5.98829
R1254 VDD.n391 VDD.t1805 5.98829
R1255 VDD.t310 VDD.t1872 5.98829
R1256 VDD.t310 VDD.t1729 5.98829
R1257 VDD.n34 VDD.t2235 5.98786
R1258 VDD.n292 VDD.t786 5.98786
R1259 VDD.n919 VDD.t1213 5.98786
R1260 VDD.n150 VDD.t2241 5.98786
R1261 VDD.n101 VDD.t697 5.98786
R1262 VDD.n370 VDD.t952 5.98786
R1263 VDD.n391 VDD.t1762 5.98786
R1264 VDD.n391 VDD.t758 5.98786
R1265 VDD.n91 VDD.t1020 5.98786
R1266 VDD.n91 VDD.t2271 5.98786
R1267 VDD.n241 VDD.t690 5.98786
R1268 VDD.n367 VDD.t1676 5.98786
R1269 VDD.n367 VDD.t677 5.98786
R1270 VDD.n128 VDD.t1234 5.98786
R1271 VDD.n283 VDD.t2356 5.98786
R1272 VDD.n283 VDD.t692 5.98786
R1273 VDD.n164 VDD.t711 5.98786
R1274 VDD.n164 VDD.t1544 5.98786
R1275 VDD.n476 VDD.t1425 5.9846
R1276 VDD.n57 VDD.t1414 5.9846
R1277 VDD.n204 VDD.t900 5.9846
R1278 VDD.n384 VDD.t1049 5.97247
R1279 VDD.n410 VDD.t785 5.97212
R1280 VDD.n227 VDD.t981 5.97212
R1281 VDD.n346 VDD.t2311 5.97212
R1282 VDD.n90 VDD.t837 5.97212
R1283 VDD.n106 VDD.t2152 5.97212
R1284 VDD.n330 VDD.t1332 5.97212
R1285 VDD.n59 VDD.t654 5.97212
R1286 VDD.n371 VDD.t1329 5.97212
R1287 VDD.n422 VDD.t2368 5.97212
R1288 VDD.n128 VDD.t1057 5.97212
R1289 VDD.n474 VDD.t1082 5.97212
R1290 VDD.n816 VDD.t1084 5.97212
R1291 VDD.n317 VDD.t1083 5.97212
R1292 VDD.n785 VDD.t1353 5.97212
R1293 VDD.n146 VDD.t2053 5.97212
R1294 VDD.n611 VDD.t2054 5.97212
R1295 VDD.n53 VDD.t2048 5.97212
R1296 VDD.n762 VDD.t919 5.97212
R1297 VDD.t310 VDD.t1356 5.97212
R1298 VDD.n123 VDD.t1357 5.97212
R1299 VDD.n123 VDD.t1352 5.97212
R1300 VDD.n392 VDD.t2049 5.97212
R1301 VDD.n234 VDD.t2050 5.97212
R1302 VDD.n234 VDD.t1675 5.97212
R1303 VDD.t231 VDD.t1786 5.97212
R1304 VDD.n138 VDD.t2032 5.97212
R1305 VDD.n729 VDD.t2051 5.97212
R1306 VDD.n482 VDD.t1114 5.97169
R1307 VDD.n51 VDD.t1115 5.97169
R1308 VDD.n395 VDD.t2191 5.97169
R1309 VDD.n418 VDD.t1345 5.97169
R1310 VDD.n384 VDD.t1472 5.97169
R1311 VDD.n329 VDD.t741 5.97169
R1312 VDD.n830 VDD.t1058 5.97169
R1313 VDD.n835 VDD.t1080 5.97169
R1314 VDD.n202 VDD.t1604 5.97169
R1315 VDD.n317 VDD.t1081 5.97169
R1316 VDD.n812 VDD.t1079 5.97169
R1317 VDD.n616 VDD.t650 5.97169
R1318 VDD.n394 VDD.t1358 5.97169
R1319 VDD.n165 VDD.t870 5.97169
R1320 VDD.n59 VDD.t1086 5.97069
R1321 VDD.n819 VDD.t1448 5.97069
R1322 VDD.n18 VDD.t390 5.97069
R1323 VDD.n234 VDD.t389 5.97069
R1324 VDD.t617 VDD.t1388 5.97001
R1325 VDD.t617 VDD.t355 5.97001
R1326 VDD.t617 VDD.t402 5.97001
R1327 VDD.t617 VDD.t220 5.97001
R1328 VDD.n316 VDD.t141 5.97001
R1329 VDD.n316 VDD.t413 5.97001
R1330 VDD.n56 VDD.t147 5.97001
R1331 VDD.n56 VDD.t416 5.97001
R1332 VDD.n56 VDD.t415 5.97001
R1333 VDD.n56 VDD.t148 5.97001
R1334 VDD.n56 VDD.t224 5.97001
R1335 VDD.n56 VDD.t417 5.97001
R1336 VDD.n163 VDD.t157 5.97001
R1337 VDD.n163 VDD.t1398 5.97001
R1338 VDD.n65 VDD.t1392 5.97001
R1339 VDD.n65 VDD.t2023 5.97001
R1340 VDD.n65 VDD.t1226 5.97001
R1341 VDD.n65 VDD.t219 5.97001
R1342 VDD.n45 VDD.t155 5.97001
R1343 VDD.n45 VDD.t30 5.97001
R1344 VDD.n45 VDD.t82 5.97001
R1345 VDD.n45 VDD.t14 5.97001
R1346 VDD.n45 VDD.t202 5.97001
R1347 VDD.n45 VDD.t572 5.97001
R1348 VDD.n45 VDD.t513 5.97001
R1349 VDD.n45 VDD.t187 5.97001
R1350 VDD.n45 VDD.t1987 5.97001
R1351 VDD.n45 VDD.t222 5.97001
R1352 VDD.n16 VDD.t190 5.97001
R1353 VDD.n16 VDD.t197 5.97001
R1354 VDD.n16 VDD.t1340 5.97001
R1355 VDD.n16 VDD.t1393 5.97001
R1356 VDD.n16 VDD.t29 5.97001
R1357 VDD.n16 VDD.t580 5.97001
R1358 VDD.n181 VDD.t186 5.97001
R1359 VDD.n181 VDD.t199 5.97001
R1360 VDD.n478 VDD.t26 5.97001
R1361 VDD.n478 VDD.t56 5.97001
R1362 VDD.n239 VDD.t841 5.97001
R1363 VDD.n239 VDD.t529 5.97001
R1364 VDD.n245 VDD.t439 5.97001
R1365 VDD.n38 VDD.t99 5.97001
R1366 VDD.n143 VDD.t124 5.97001
R1367 VDD.n482 VDD.t135 5.97001
R1368 VDD.n73 VDD.t454 5.97001
R1369 VDD.n82 VDD.t550 5.97001
R1370 VDD.n83 VDD.t553 5.97001
R1371 VDD.n83 VDD.t554 5.97001
R1372 VDD.n83 VDD.t557 5.97001
R1373 VDD.n83 VDD.t558 5.97001
R1374 VDD.n107 VDD.t598 5.97001
R1375 VDD.n107 VDD.t599 5.97001
R1376 VDD.n76 VDD.t602 5.97001
R1377 VDD.n76 VDD.t603 5.97001
R1378 VDD.n76 VDD.t606 5.97001
R1379 VDD.n76 VDD.t607 5.97001
R1380 VDD.n76 VDD.t610 5.97001
R1381 VDD.n76 VDD.t611 5.97001
R1382 VDD.n76 VDD.t35 5.97001
R1383 VDD.n76 VDD.t36 5.97001
R1384 VDD.n76 VDD.t39 5.97001
R1385 VDD.n76 VDD.t40 5.97001
R1386 VDD.n76 VDD.t58 5.97001
R1387 VDD.n76 VDD.t59 5.97001
R1388 VDD.n27 VDD.t62 5.97001
R1389 VDD.n410 VDD.t449 5.97001
R1390 VDD.n73 VDD.t453 5.97001
R1391 VDD.n73 VDD.t451 5.97001
R1392 VDD.n479 VDD.t170 5.97001
R1393 VDD.n39 VDD.t92 5.97001
R1394 VDD.n39 VDD.t90 5.97001
R1395 VDD.n39 VDD.t89 5.97001
R1396 VDD.n39 VDD.t115 5.97001
R1397 VDD.n38 VDD.t114 5.97001
R1398 VDD.n38 VDD.t112 5.97001
R1399 VDD.n38 VDD.t111 5.97001
R1400 VDD.n38 VDD.t101 5.97001
R1401 VDD.n84 VDD.t1403 5.97001
R1402 VDD.n85 VDD.t1400 5.97001
R1403 VDD.n85 VDD.t518 5.97001
R1404 VDD.n85 VDD.t588 5.97001
R1405 VDD.n85 VDD.t585 5.97001
R1406 VDD.n131 VDD.t582 5.97001
R1407 VDD.n131 VDD.t3 5.97001
R1408 VDD.n34 VDD.t1894 5.97001
R1409 VDD.n34 VDD.t1394 5.97001
R1410 VDD.n34 VDD.t1995 5.97001
R1411 VDD.n34 VDD.t943 5.97001
R1412 VDD.n34 VDD.t2028 5.97001
R1413 VDD.n34 VDD.t839 5.97001
R1414 VDD.n34 VDD.t515 5.97001
R1415 VDD.n472 VDD.t32 5.97001
R1416 VDD.n472 VDD.t632 5.97001
R1417 VDD.n332 VDD.t9 5.97001
R1418 VDD.n332 VDD.t22 5.97001
R1419 VDD.n341 VDD.t565 5.97001
R1420 VDD.n341 VDD.t569 5.97001
R1421 VDD.n334 VDD.t1988 5.97001
R1422 VDD.n334 VDD.t1908 5.97001
R1423 VDD.n319 VDD.t1833 5.97001
R1424 VDD.n356 VDD.t249 5.97001
R1425 VDD.n75 VDD.t245 5.97001
R1426 VDD.n75 VDD.t243 5.97001
R1427 VDD.n75 VDD.t238 5.97001
R1428 VDD.n75 VDD.t236 5.97001
R1429 VDD.n260 VDD.t162 5.97001
R1430 VDD.n260 VDD.t159 5.97001
R1431 VDD.n218 VDD.t575 5.97001
R1432 VDD.n141 VDD.t166 5.97001
R1433 VDD.n141 VDD.t208 5.97001
R1434 VDD.n142 VDD.t169 5.97001
R1435 VDD.n86 VDD.t75 5.97001
R1436 VDD.n87 VDD.t640 5.97001
R1437 VDD.n87 VDD.t50 5.97001
R1438 VDD.n87 VDD.t182 5.97001
R1439 VDD.n87 VDD.t177 5.97001
R1440 VDD.n265 VDD.t194 5.97001
R1441 VDD.n265 VDD.t191 5.97001
R1442 VDD.n32 VDD.t218 5.97001
R1443 VDD.n32 VDD.t502 5.97001
R1444 VDD.n32 VDD.t210 5.97001
R1445 VDD.n32 VDD.t211 5.97001
R1446 VDD.n32 VDD.t535 5.97001
R1447 VDD.n32 VDD.t536 5.97001
R1448 VDD.n106 VDD.t539 5.97001
R1449 VDD.n154 VDD.t429 5.97001
R1450 VDD.n826 VDD.t507 5.97001
R1451 VDD.n88 VDD.t489 5.97001
R1452 VDD.n89 VDD.t494 5.97001
R1453 VDD.n89 VDD.t264 5.97001
R1454 VDD.n89 VDD.t404 5.97001
R1455 VDD.n89 VDD.t411 5.97001
R1456 VDD.n3 VDD.t408 5.97001
R1457 VDD.n3 VDD.t284 5.97001
R1458 VDD.n4 VDD.t419 5.97001
R1459 VDD.n4 VDD.t328 5.97001
R1460 VDD.n4 VDD.t2316 5.97001
R1461 VDD.n4 VDD.t1385 5.97001
R1462 VDD.n14 VDD.t576 5.97001
R1463 VDD.n12 VDD.t636 5.97001
R1464 VDD.n14 VDD.t525 5.97001
R1465 VDD.n14 VDD.t531 5.97001
R1466 VDD.n14 VDD.t254 5.97001
R1467 VDD.n14 VDD.t253 5.97001
R1468 VDD.n122 VDD.t85 5.97001
R1469 VDD.n470 VDD.t397 5.97001
R1470 VDD.n470 VDD.t337 5.97001
R1471 VDD.n336 VDD.t282 5.97001
R1472 VDD.n336 VDD.t622 5.97001
R1473 VDD.n343 VDD.t288 5.97001
R1474 VDD.n343 VDD.t278 5.97001
R1475 VDD.n361 VDD.t292 5.97001
R1476 VDD.n361 VDD.t296 5.97001
R1477 VDD.n383 VDD.t486 5.97001
R1478 VDD.n53 VDD.t225 5.97001
R1479 VDD.n53 VDD.t304 5.97001
R1480 VDD.n53 VDD.t301 5.97001
R1481 VDD.n53 VDD.t342 5.97001
R1482 VDD.n358 VDD.t908 5.97001
R1483 VDD.n99 VDD.t313 5.97001
R1484 VDD.n74 VDD.t318 5.97001
R1485 VDD.n74 VDD.t324 5.97001
R1486 VDD.n74 VDD.t352 5.97001
R1487 VDD.n74 VDD.t333 5.97001
R1488 VDD.n52 VDD.t350 5.97001
R1489 VDD.n468 VDD.t422 5.97001
R1490 VDD.n468 VDD.t426 5.97001
R1491 VDD.n339 VDD.t320 5.97001
R1492 VDD.n339 VDD.t472 5.97001
R1493 VDD.n352 VDD.t2020 5.97001
R1494 VDD.n80 VDD.t273 5.97001
R1495 VDD.n80 VDD.t272 5.97001
R1496 VDD.t617 VDD.t620 5.96957
R1497 VDD.t617 VDD.t621 5.96957
R1498 VDD.t617 VDD.t43 5.96957
R1499 VDD.t617 VDD.t44 5.96957
R1500 VDD.n316 VDD.t47 5.96957
R1501 VDD.n316 VDD.t48 5.96957
R1502 VDD.n56 VDD.t66 5.96957
R1503 VDD.n56 VDD.t67 5.96957
R1504 VDD.n56 VDD.t70 5.96957
R1505 VDD.n56 VDD.t71 5.96957
R1506 VDD.n56 VDD.t458 5.96957
R1507 VDD.n56 VDD.t459 5.96957
R1508 VDD.n163 VDD.t462 5.96957
R1509 VDD.n163 VDD.t463 5.96957
R1510 VDD.n65 VDD.t466 5.96957
R1511 VDD.n65 VDD.t467 5.96957
R1512 VDD.n65 VDD.t470 5.96957
R1513 VDD.n65 VDD.t471 5.96957
R1514 VDD.n45 VDD.t127 5.96957
R1515 VDD.n45 VDD.t128 5.96957
R1516 VDD.n45 VDD.t131 5.96957
R1517 VDD.n45 VDD.t132 5.96957
R1518 VDD.n45 VDD.t139 5.96957
R1519 VDD.n45 VDD.t102 5.96957
R1520 VDD.n45 VDD.t105 5.96957
R1521 VDD.n45 VDD.t106 5.96957
R1522 VDD.n45 VDD.t109 5.96957
R1523 VDD.n45 VDD.t116 5.96957
R1524 VDD.n16 VDD.t119 5.96957
R1525 VDD.n16 VDD.t120 5.96957
R1526 VDD.n16 VDD.t123 5.96957
R1527 VDD.n16 VDD.t93 5.96957
R1528 VDD.n16 VDD.t96 5.96957
R1529 VDD.n16 VDD.t97 5.96957
R1530 VDD.n181 VDD.t172 5.96957
R1531 VDD.n181 VDD.t477 5.96957
R1532 VDD.n478 VDD.t480 5.96957
R1533 VDD.n82 VDD.t1404 5.96957
R1534 VDD.n83 VDD.t1402 5.96957
R1535 VDD.n83 VDD.t520 5.96957
R1536 VDD.n83 VDD.t590 5.96957
R1537 VDD.n83 VDD.t586 5.96957
R1538 VDD.n107 VDD.t584 5.96957
R1539 VDD.n107 VDD.t6 5.96957
R1540 VDD.n76 VDD.t1896 5.96957
R1541 VDD.n76 VDD.t1396 5.96957
R1542 VDD.n76 VDD.t1997 5.96957
R1543 VDD.n76 VDD.t945 5.96957
R1544 VDD.n76 VDD.t2030 5.96957
R1545 VDD.n76 VDD.t840 5.96957
R1546 VDD.n76 VDD.t517 5.96957
R1547 VDD.n76 VDD.t524 5.96957
R1548 VDD.n76 VDD.t151 5.96957
R1549 VDD.n76 VDD.t152 5.96957
R1550 VDD.n76 VDD.t441 5.96957
R1551 VDD.n76 VDD.t1460 5.96957
R1552 VDD.n27 VDD.t549 5.96957
R1553 VDD.n84 VDD.t175 5.96957
R1554 VDD.n85 VDD.t634 5.96957
R1555 VDD.n85 VDD.t33 5.96957
R1556 VDD.n85 VDD.t25 5.96957
R1557 VDD.n85 VDD.t11 5.96957
R1558 VDD.n131 VDD.t571 5.96957
R1559 VDD.n131 VDD.t567 5.96957
R1560 VDD.n34 VDD.t1910 5.96957
R1561 VDD.n34 VDD.t1989 5.96957
R1562 VDD.n34 VDD.t1836 5.96957
R1563 VDD.n34 VDD.t1832 5.96957
R1564 VDD.n34 VDD.t260 5.96957
R1565 VDD.n34 VDD.t261 5.96957
R1566 VDD.n34 VDD.t484 5.96957
R1567 VDD.n395 VDD.t205 5.96957
R1568 VDD.n67 VDD.t203 5.96957
R1569 VDD.n1 VDD.t431 5.96957
R1570 VDD.n1 VDD.t432 5.96957
R1571 VDD.n200 VDD.t435 5.96957
R1572 VDD.n353 VDD.t447 5.96957
R1573 VDD.n184 VDD.t241 5.96957
R1574 VDD.n331 VDD.t251 5.96957
R1575 VDD.n331 VDD.t256 5.96957
R1576 VDD.n516 VDD.t247 5.96957
R1577 VDD.n516 VDD.t248 5.96957
R1578 VDD.n334 VDD.t240 5.96957
R1579 VDD.n334 VDD.t200 5.96957
R1580 VDD.n514 VDD.t165 5.96957
R1581 VDD.n514 VDD.t160 5.96957
R1582 VDD.n356 VDD.t642 5.96957
R1583 VDD.n356 VDD.t53 5.96957
R1584 VDD.n75 VDD.t184 5.96957
R1585 VDD.n75 VDD.t179 5.96957
R1586 VDD.n75 VDD.t196 5.96957
R1587 VDD.n865 VDD.t216 5.96957
R1588 VDD.n104 VDD.t542 5.96957
R1589 VDD.n104 VDD.t592 5.96957
R1590 VDD.n104 VDD.t593 5.96957
R1591 VDD.n58 VDD.t596 5.96957
R1592 VDD.n101 VDD.t79 5.96957
R1593 VDD.n86 VDD.t491 5.96957
R1594 VDD.n87 VDD.t496 5.96957
R1595 VDD.n87 VDD.t266 5.96957
R1596 VDD.n87 VDD.t406 5.96957
R1597 VDD.n87 VDD.t412 5.96957
R1598 VDD.n265 VDD.t410 5.96957
R1599 VDD.n265 VDD.t286 5.96957
R1600 VDD.n32 VDD.t421 5.96957
R1601 VDD.n32 VDD.t330 5.96957
R1602 VDD.n32 VDD.t2318 5.96957
R1603 VDD.n32 VDD.t1386 5.96957
R1604 VDD.n32 VDD.t638 5.96957
R1605 VDD.n32 VDD.t577 5.96957
R1606 VDD.n106 VDD.t533 5.96957
R1607 VDD.n101 VDD.t437 5.96957
R1608 VDD.n88 VDD.t631 5.96957
R1609 VDD.n89 VDD.t340 5.96957
R1610 VDD.n89 VDD.t399 5.96957
R1611 VDD.n89 VDD.t624 5.96957
R1612 VDD.n89 VDD.t283 5.96957
R1613 VDD.n3 VDD.t281 5.96957
R1614 VDD.n3 VDD.t290 5.96957
R1615 VDD.n4 VDD.t298 5.96957
R1616 VDD.n4 VDD.t294 5.96957
R1617 VDD.n4 VDD.t488 5.96957
R1618 VDD.n4 VDD.t144 5.96957
R1619 VDD.n12 VDD.t545 5.96957
R1620 VDD.n129 VDD.t505 5.96957
R1621 VDD.n186 VDD.t628 5.96957
R1622 VDD.n335 VDD.t910 5.96957
R1623 VDD.n335 VDD.t911 5.96957
R1624 VDD.n511 VDD.t347 5.96957
R1625 VDD.n511 VDD.t348 5.96957
R1626 VDD.n360 VDD.t306 5.96957
R1627 VDD.n360 VDD.t341 5.96957
R1628 VDD.n317 VDD.t21 5.96957
R1629 VDD.n53 VDD.t353 5.96957
R1630 VDD.n358 VDD.t319 5.96957
R1631 VDD.n358 VDD.t326 5.96957
R1632 VDD.n99 VDD.t311 5.96957
R1633 VDD.n74 VDD.t428 5.96957
R1634 VDD.n74 VDD.t424 5.96957
R1635 VDD.n74 VDD.t474 5.96957
R1636 VDD.n74 VDD.t322 5.96957
R1637 VDD.n52 VDD.t2022 5.96957
R1638 VDD.n52 VDD.t499 5.96957
R1639 VDD.n52 VDD.t574 5.96957
R1640 VDD.n189 VDD.t501 5.96957
R1641 VDD.n338 VDD.t233 5.96957
R1642 VDD.n338 VDD.t234 5.96957
R1643 VDD.n349 VDD.t275 5.96957
R1644 VDD.n349 VDD.t276 5.96957
R1645 VDD.n245 VDD.t1010 5.96578
R1646 VDD.n952 VDD.t1242 5.96578
R1647 VDD.n956 VDD.t1953 5.96578
R1648 VDD.n571 VDD.t958 5.96578
R1649 VDD.n903 VDD.t1481 5.96578
R1650 VDD.n418 VDD.t1173 5.96578
R1651 VDD.n577 VDD.t883 5.96578
R1652 VDD.n876 VDD.t1318 5.96578
R1653 VDD.n886 VDD.t731 5.96578
R1654 VDD.n97 VDD.t701 5.96578
R1655 VDD.n370 VDD.t722 5.96578
R1656 VDD.n808 VDD.t2081 5.96578
R1657 VDD.n810 VDD.t1055 5.96578
R1658 VDD.n18 VDD.t1341 5.96578
R1659 VDD.n776 VDD.t2062 5.96578
R1660 VDD.n749 VDD.t1099 5.96578
R1661 VDD.n652 VDD.t1923 5.96578
R1662 VDD.n648 VDD.t2223 5.96578
R1663 VDD.n720 VDD.t2068 5.96578
R1664 VDD.n239 VDD.t2288 5.96534
R1665 VDD.n245 VDD.t1108 5.96534
R1666 VDD.n237 VDD.t775 5.96534
R1667 VDD.n376 VDD.t752 5.96534
R1668 VDD.n39 VDD.t1420 5.96534
R1669 VDD.n39 VDD.t755 5.96534
R1670 VDD.n51 VDD.t2096 5.96534
R1671 VDD.n921 VDD.t1433 5.96534
R1672 VDD.n67 VDD.t1372 5.96534
R1673 VDD.n346 VDD.t1050 5.96534
R1674 VDD.n899 VDD.t788 5.96534
R1675 VDD.n92 VDD.t1068 5.96534
R1676 VDD.n422 VDD.t818 5.96534
R1677 VDD.n129 VDD.t924 5.96534
R1678 VDD.n18 VDD.t387 5.96534
R1679 VDD.n18 VDD.t385 5.96534
R1680 VDD.n115 VDD.t1479 5.96534
R1681 VDD.n447 VDD.t8 1.63741
R1682 VDD.n449 VDD.t52 1.63741
R1683 VDD.n521 VDD.t0 1.43829
R1684 VDD.n205 VDD.t19 2.40463
R1685 VDD.n305 VDD.n293 0.416208
R1686 VDD.n486 VDD.t231 1.32331
R1687 VDD.n402 VDD.t231 1.0037
R1688 VDD.n542 VDD.t231 2.85928
R1689 VDD.n482 VDD.t136 5.96091
R1690 VDD.n939 VDD.t456 5.96091
R1691 VDD.n27 VDD.t63 5.96091
R1692 VDD.n479 VDD.t475 5.96091
R1693 VDD.n489 VDD.t73 5.96091
R1694 VDD.n34 VDD.t522 5.96091
R1695 VDD.n67 VDD.t257 5.96091
R1696 VDD.n319 VDD.t1831 5.96091
R1697 VDD.n106 VDD.t541 5.96091
R1698 VDD.n122 VDD.t86 5.96091
R1699 VDD.n383 VDD.t143 5.96091
R1700 VDD.n18 VDD.t17 5.96091
R1701 VDD.n352 VDD.t497 5.96091
R1702 VDD.n680 VDD.t509 5.96091
R1703 VDD.n478 VDD.t481 5.96047
R1704 VDD.n34 VDD.t546 5.96047
R1705 VDD.n110 VDD.t229 5.96047
R1706 VDD.n200 VDD.t442 5.96047
R1707 VDD.n106 VDD.t526 5.96047
R1708 VDD.n128 VDD.t503 5.96047
R1709 VDD.n53 VDD.t336 5.96047
R1710 VDD.n144 VDD.t2246 5.94251
R1711 VDD.n67 VDD.t2234 5.94251
R1712 VDD.n59 VDD.t997 5.94251
R1713 VDD.n59 VDD.t1000 5.94251
R1714 VDD.n369 VDD.t977 5.94251
R1715 VDD.n588 VDD.t971 5.94251
R1716 VDD.n118 VDD.t976 5.94251
R1717 VDD.n118 VDD.t974 5.94251
R1718 VDD.n7 VDD.t975 5.94251
R1719 VDD.n197 VDD.t970 5.94251
R1720 VDD.n821 VDD.t973 5.94251
R1721 VDD.n113 VDD.t961 5.94251
R1722 VDD.n5 VDD.t962 5.94251
R1723 VDD.n17 VDD.t965 5.94251
R1724 VDD.n17 VDD.t963 5.94251
R1725 VDD.n753 VDD.t964 5.94251
R1726 VDD.n0 VDD.t1363 5.94207
R1727 VDD.n294 VDD.t2233 5.94207
R1728 VDD.n91 VDD.t1724 5.94207
R1729 VDD.n369 VDD.t972 5.94207
R1730 VDD.n369 VDD.t904 5.94207
R1731 VDD.n7 VDD.t1190 5.94207
R1732 VDD.n118 VDD.t967 5.94207
R1733 VDD.n18 VDD.t873 5.94207
R1734 VDD.n19 VDD.t960 5.94207
R1735 VDD.n782 VDD.t966 5.94207
R1736 VDD.n146 VDD.t1777 5.94207
R1737 VDD.n392 VDD.t388 5.94207
R1738 VDD.n38 VDD.t2135 5.92982
R1739 VDD.n233 VDD.t1346 5.92982
R1740 VDD.n101 VDD.t1354 5.92982
R1741 VDD.n840 VDD.t743 5.92982
R1742 VDD.n795 VDD.t736 5.92982
R1743 VDD.n502 VDD.t1235 5.92982
R1744 VDD.n394 VDD.t651 5.92982
R1745 VDD.n301 VDD.t1236 5.92982
R1746 VDD.n36 VDD.t1355 5.92982
R1747 VDD.n378 VDD.t1230 5.92982
R1748 VDD.n409 VDD.t1650 5.92982
R1749 VDD.t310 VDD.t1651 5.92982
R1750 VDD.n392 VDD.t1690 5.92982
R1751 VDD.n235 VDD.t1689 5.92982
R1752 VDD.n518 VDD.t1720 5.92982
R1753 VDD.n136 VDD.t1231 5.92982
R1754 VDD.n110 VDD.t850 5.92938
R1755 VDD.n67 VDD.t1001 5.92938
R1756 VDD.n346 VDD.t1974 5.92938
R1757 VDD.n418 VDD.t660 5.92938
R1758 VDD.n378 VDD.t1688 5.92938
R1759 VDD.n300 VDD.t862 5.92938
R1760 VDD.n9 VDD.t1517 5.92938
R1761 VDD.n9 VDD.t1233 5.92938
R1762 VDD.n136 VDD.t2167 5.92938
R1763 VDD.n518 VDD.t1232 5.92938
R1764 VDD.n168 VDD.t1516 5.92938
R1765 VDD.t310 VDD.t1648 5.92938
R1766 VDD.n166 VDD.t1649 5.92938
R1767 VDD.n67 VDD.t1214 5.92319
R1768 VDD.n346 VDD.t1429 5.92319
R1769 VDD.n310 VDD.t942 5.92275
R1770 VDD.n200 VDD.t1379 5.9217
R1771 VDD.n297 VDD.t815 5.91992
R1772 VDD.n67 VDD.t1267 5.91379
R1773 VDD.n231 VDD.t1165 5.91379
R1774 VDD.n232 VDD.t2147 5.91335
R1775 VDD.t617 VDD.t618 5.65005
R1776 VDD.n49 VDD.t626 5.65005
R1777 VDD.t617 VDD.t42 5.65005
R1778 VDD.n48 VDD.t356 5.65005
R1779 VDD.n525 VDD.t45 5.65005
R1780 VDD.n526 VDD.t140 5.65005
R1781 VDD.n314 VDD.t49 5.65005
R1782 VDD.n315 VDD.t146 5.65005
R1783 VDD.n61 VDD.t68 5.65005
R1784 VDD.n56 VDD.t414 5.65005
R1785 VDD.n55 VDD.t72 5.65005
R1786 VDD.n56 VDD.t149 5.65005
R1787 VDD.n163 VDD.t460 5.65005
R1788 VDD.n163 VDD.t156 5.65005
R1789 VDD.n65 VDD.t464 5.65005
R1790 VDD.n65 VDD.t1391 5.65005
R1791 VDD.n65 VDD.t468 5.65005
R1792 VDD.n64 VDD.t1225 5.65005
R1793 VDD.n45 VDD.t126 5.65005
R1794 VDD.n45 VDD.t154 5.65005
R1795 VDD.n43 VDD.t129 5.65005
R1796 VDD.n44 VDD.t31 5.65005
R1797 VDD.n45 VDD.t133 5.65005
R1798 VDD.n41 VDD.t15 5.65005
R1799 VDD.n45 VDD.t103 5.65005
R1800 VDD.n45 VDD.t512 5.65005
R1801 VDD.n42 VDD.t107 5.65005
R1802 VDD.n45 VDD.t188 5.65005
R1803 VDD.n16 VDD.t117 5.65005
R1804 VDD.n16 VDD.t189 5.65005
R1805 VDD.n16 VDD.t121 5.65005
R1806 VDD.n63 VDD.t198 5.65005
R1807 VDD.n16 VDD.t94 5.65005
R1808 VDD.n16 VDD.t28 5.65005
R1809 VDD.n181 VDD.t98 5.65005
R1810 VDD.n181 VDD.t185 5.65005
R1811 VDD.n522 VDD.t478 5.65005
R1812 VDD.n523 VDD.t55 5.65005
R1813 VDD.n506 VDD.t27 5.65005
R1814 VDD.n246 VDD.t438 5.65005
R1815 VDD.n249 VDD.t125 5.65005
R1816 VDD.n72 VDD.t452 5.65005
R1817 VDD.n83 VDD.t1401 5.65005
R1818 VDD.n83 VDD.t551 5.65005
R1819 VDD.n83 VDD.t521 5.65005
R1820 VDD.n83 VDD.t555 5.65005
R1821 VDD.n251 VDD.t583 5.65005
R1822 VDD.n252 VDD.t559 5.65005
R1823 VDD.n321 VDD.t7 5.65005
R1824 VDD.n322 VDD.t600 5.65005
R1825 VDD.n132 VDD.t1397 5.65005
R1826 VDD.n76 VDD.t604 5.65005
R1827 VDD.n76 VDD.t946 5.65005
R1828 VDD.n76 VDD.t608 5.65005
R1829 VDD.n76 VDD.t516 5.65005
R1830 VDD.n76 VDD.t34 5.65005
R1831 VDD.n76 VDD.t150 5.65005
R1832 VDD.n76 VDD.t37 5.65005
R1833 VDD.n76 VDD.t153 5.65005
R1834 VDD.n76 VDD.t41 5.65005
R1835 VDD.n27 VDD.t548 5.65005
R1836 VDD.n27 VDD.t60 5.65005
R1837 VDD.n73 VDD.t448 5.65005
R1838 VDD.n934 VDD.t91 5.65005
R1839 VDD.n39 VDD.t88 5.65005
R1840 VDD.n38 VDD.t113 5.65005
R1841 VDD.n38 VDD.t110 5.65005
R1842 VDD.n38 VDD.t100 5.65005
R1843 VDD.n85 VDD.t176 5.65005
R1844 VDD.n85 VDD.t1399 5.65005
R1845 VDD.n85 VDD.t24 5.65005
R1846 VDD.n85 VDD.t519 5.65005
R1847 VDD.n254 VDD.t12 5.65005
R1848 VDD.n255 VDD.t581 5.65005
R1849 VDD.n323 VDD.t568 5.65005
R1850 VDD.n324 VDD.t4 5.65005
R1851 VDD.n34 VDD.t1835 5.65005
R1852 VDD.n34 VDD.t1395 5.65005
R1853 VDD.n34 VDD.t259 5.65005
R1854 VDD.n34 VDD.t944 5.65005
R1855 VDD.n34 VDD.t262 5.65005
R1856 VDD.n34 VDD.t514 5.65005
R1857 VDD.n2 VDD.t204 5.65005
R1858 VDD.n199 VDD.t433 5.65005
R1859 VDD.n355 VDD.t206 5.65005
R1860 VDD.n184 VDD.t174 5.65005
R1861 VDD.n472 VDD.t242 5.65005
R1862 VDD.n517 VDD.t23 5.65005
R1863 VDD.n332 VDD.t246 5.65005
R1864 VDD.n515 VDD.t10 5.65005
R1865 VDD.n341 VDD.t239 5.65005
R1866 VDD.n334 VDD.t566 5.65005
R1867 VDD.n334 VDD.t164 5.65005
R1868 VDD.n513 VDD.t1834 5.65005
R1869 VDD.n319 VDD.t161 5.65005
R1870 VDD.n457 VDD.t78 5.65005
R1871 VDD.n356 VDD.t54 5.65005
R1872 VDD.n75 VDD.t244 5.65005
R1873 VDD.n75 VDD.t180 5.65005
R1874 VDD.n75 VDD.t237 5.65005
R1875 VDD.n261 VDD.t158 5.65005
R1876 VDD.n313 VDD.t163 5.65005
R1877 VDD.n257 VDD.t214 5.65005
R1878 VDD.n104 VDD.t543 5.65005
R1879 VDD.n58 VDD.t594 5.65005
R1880 VDD.n263 VDD.t207 5.65005
R1881 VDD.n320 VDD.t167 5.65005
R1882 VDD.n101 VDD.t80 5.65005
R1883 VDD.n87 VDD.t492 5.65005
R1884 VDD.n87 VDD.t76 5.65005
R1885 VDD.n87 VDD.t267 5.65005
R1886 VDD.n87 VDD.t51 5.65005
R1887 VDD.n266 VDD.t409 5.65005
R1888 VDD.n267 VDD.t178 5.65005
R1889 VDD.n325 VDD.t287 5.65005
R1890 VDD.n326 VDD.t192 5.65005
R1891 VDD.n32 VDD.t331 5.65005
R1892 VDD.n32 VDD.t209 5.65005
R1893 VDD.n32 VDD.t637 5.65005
R1894 VDD.n32 VDD.t212 5.65005
R1895 VDD.n30 VDD.t532 5.65005
R1896 VDD.n31 VDD.t537 5.65005
R1897 VDD.n89 VDD.t339 5.65005
R1898 VDD.n89 VDD.t490 5.65005
R1899 VDD.n89 VDD.t400 5.65005
R1900 VDD.n89 VDD.t265 5.65005
R1901 VDD.n274 VDD.t280 5.65005
R1902 VDD.n275 VDD.t407 5.65005
R1903 VDD.n327 VDD.t291 5.65005
R1904 VDD.n328 VDD.t285 5.65005
R1905 VDD.n4 VDD.t295 5.65005
R1906 VDD.n4 VDD.t329 5.65005
R1907 VDD.n271 VDD.t145 5.65005
R1908 VDD.n272 VDD.t635 5.65005
R1909 VDD.n14 VDD.t530 5.65005
R1910 VDD.n13 VDD.t252 5.65005
R1911 VDD.n269 VDD.t255 5.65005
R1912 VDD.n121 VDD.t84 5.65005
R1913 VDD.n129 VDD.t20 5.65005
R1914 VDD.n186 VDD.t338 5.65005
R1915 VDD.n470 VDD.t629 5.65005
R1916 VDD.n512 VDD.t398 5.65005
R1917 VDD.n336 VDD.t346 5.65005
R1918 VDD.n510 VDD.t279 5.65005
R1919 VDD.n343 VDD.t305 5.65005
R1920 VDD.n509 VDD.t289 5.65005
R1921 VDD.n361 VDD.t227 5.65005
R1922 VDD.n213 VDD.t293 5.65005
R1923 VDD.n53 VDD.t226 5.65005
R1924 VDD.n53 VDD.t302 5.65005
R1925 VDD.n53 VDD.t343 5.65005
R1926 VDD.n358 VDD.t327 5.65005
R1927 VDD.n458 VDD.t315 5.65005
R1928 VDD.n74 VDD.t312 5.65005
R1929 VDD.n74 VDD.t314 5.65005
R1930 VDD.n74 VDD.t425 5.65005
R1931 VDD.n74 VDD.t325 5.65005
R1932 VDD.n52 VDD.t323 5.65005
R1933 VDD.n52 VDD.t334 5.65005
R1934 VDD.n52 VDD.t500 5.65005
R1935 VDD.n189 VDD.t309 5.65005
R1936 VDD.n468 VDD.t232 5.65005
R1937 VDD.n508 VDD.t423 5.65005
R1938 VDD.n339 VDD.t235 5.65005
R1939 VDD.n507 VDD.t321 5.65005
R1940 VDD.n351 VDD.t277 5.65005
R1941 VDD.n80 VDD.t271 5.65005
R1942 VDD.n504 VDD.t482 5.64493
R1943 VDD.n937 VDD.t137 5.64493
R1944 VDD.n936 VDD.t455 5.64493
R1945 VDD.n27 VDD.t64 5.64493
R1946 VDD.n954 VDD.t476 5.64493
R1947 VDD.n195 VDD.t74 5.64493
R1948 VDD.n34 VDD.t547 5.64493
R1949 VDD.n34 VDD.t523 5.64493
R1950 VDD.n110 VDD.t230 5.64493
R1951 VDD.n2 VDD.t258 5.64493
R1952 VDD.n897 VDD.t443 5.64493
R1953 VDD.n492 VDD.t1830 5.64493
R1954 VDD.n106 VDD.t527 5.64493
R1955 VDD.n106 VDD.t540 5.64493
R1956 VDD.n103 VDD.t87 5.64493
R1957 VDD.n312 VDD.t504 5.64493
R1958 VDD.n381 VDD.t142 5.64493
R1959 VDD.n18 VDD.t18 5.64493
R1960 VDD.n53 VDD.t335 5.64493
R1961 VDD.n350 VDD.t498 5.64493
R1962 VDD.n724 VDD.t508 5.64493
R1963 VDD.n316 VDD.n56 0.403321
R1964 VDD.n539 VDD.t269 0.103492
R1965 VDD.n259 VDD.n258 0.0641242
R1966 VDD.t52 VDD.n259 2.78967
R1967 VDD.t0 VDD.n127 0.693338
R1968 VDD.t300 VDD.t13 5.64013
R1969 VDD.t231 VDD.n619 5.62352
R1970 VDD.t13 VDD.n119 1.05134
R1971 VDD.t5 VDD.n949 5.61485
R1972 VDD.t5 VDD.n951 5.61485
R1973 VDD.t5 VDD.n953 5.61485
R1974 VDD.n930 VDD.t2 5.61485
R1975 VDD.n926 VDD.t2 5.61485
R1976 VDD.n921 VDD.n152 0.23381
R1977 VDD.t2 VDD.n572 5.61485
R1978 VDD.t2 VDD.n562 5.61485
R1979 VDD.t2 VDD.n229 2.29765
R1980 VDD.t8 VDD.n901 5.61485
R1981 VDD.t8 VDD.n233 5.61485
R1982 VDD.t8 VDD.n291 1.59683
R1983 VDD.n100 VDD.n579 0.777995
R1984 VDD.n70 VDD.n69 0.230354
R1985 VDD.t52 VDD.n192 2.29123
R1986 VDD.n192 VDD.n191 0.177707
R1987 VDD.t52 VDD.n477 2.29763
R1988 VDD.t52 VDD.n857 5.61485
R1989 VDD.n375 VDD.n873 0.481577
R1990 VDD.t52 VDD.n501 2.29753
R1991 VDD.t52 VDD.n105 0.526504
R1992 VDD.t52 VDD.n866 5.61485
R1993 VDD.t0 VDD.n851 5.61485
R1994 VDD.n424 VDD.n366 0.279638
R1995 VDD.n220 VDD.n594 0.212537
R1996 VDD.n388 VDD.n829 0.29576
R1997 VDD.t83 VDD.n388 2.04226
R1998 VDD.n216 VDD.n386 0.424645
R1999 VDD.n216 VDD.n215 0.237565
R2000 VDD.t83 VDD.n828 5.61485
R2001 VDD.t19 VDD.n820 5.61485
R2002 VDD.t19 VDD.n284 1.44502
R2003 VDD.n473 VDD.n812 0.28281
R2004 VDD.t19 VDD.n298 2.02208
R2005 VDD.t19 VDD.n797 5.61485
R2006 VDD.t19 VDD.n794 5.61485
R2007 VDD.t16 VDD.n171 2.02098
R2008 VDD.n503 VDD.n502 0.279005
R2009 VDD.n18 VDD.n614 0.537475
R2010 VDD.t16 VDD.n114 0.798798
R2011 VDD.t16 VDD.n775 5.61485
R2012 VDD.t16 VDD.n779 5.61485
R2013 VDD.t16 VDD.n610 5.61485
R2014 VDD.n396 VDD.n613 0.280212
R2015 VDD.t16 VDD.n147 1.52247
R2016 VDD.n417 VDD.n611 0.244611
R2017 VDD.t310 VDD.n739 5.61485
R2018 VDD.n519 VDD.n747 0.279005
R2019 VDD.t310 VDD.n408 5.61485
R2020 VDD.t310 VDD.n236 2.29762
R2021 VDD.t310 VDD.n465 2.03322
R2022 VDD.t310 VDD.n9 1.97618
R2023 VDD.t231 VDD.n621 5.61485
R2024 VDD.t231 VDD.n627 5.61485
R2025 VDD.t231 VDD.n632 5.61485
R2026 VDD.t231 VDD.n634 5.61485
R2027 VDD.n542 VDD.n635 0.224603
R2028 VDD.t231 VDD.n637 5.61485
R2029 VDD.n288 VDD.n352 0.347211
R2030 VDD.t270 VDD.n543 0.496969
R2031 VDD.t270 VDD.n685 5.61485
R2032 VDD.t270 VDD.n718 5.61485
R2033 VDD.t270 VDD.n690 5.61485
R2034 VDD.t270 VDD.n714 5.61485
R2035 VDD.n81 VDD.t270 1.01302
R2036 VDD.t270 VDD.n679 5.61485
R2037 VDD.n786 VDD.t1450 4.42634
R2038 VDD.n284 VDD.n283 0.144184
R2039 VDD.t0 VDD.n170 1.31541
R2040 VDD.n145 VDD.t5 0.978147
R2041 VDD.n918 VDD.t2 4.17719
R2042 VDD.t8 VDD.n912 4.17719
R2043 VDD.n289 VDD.n232 0.278405
R2044 VDD.n240 VDD.n231 0.439248
R2045 VDD.n428 VDD.n427 0.232066
R2046 VDD.t52 VDD.n576 4.17719
R2047 VDD.t52 VDD.n578 4.17719
R2048 VDD.t52 VDD.n400 1.72302
R2049 VDD.n183 VDD.n416 0.292783
R2050 VDD.t52 VDD.n877 4.17719
R2051 VDD.t52 VDD.n875 4.17719
R2052 VDD.t52 VDD.n860 4.17719
R2053 VDD.n501 VDD.n500 0.172703
R2054 VDD.n23 VDD.n837 0.478165
R2055 VDD.t0 VDD.n838 4.17719
R2056 VDD.t0 VDD.n93 0.857182
R2057 VDD.t0 VDD.n845 4.17719
R2058 VDD.t83 VDD.n596 4.17719
R2059 VDD.t83 VDD.n406 1.72301
R2060 VDD.t83 VDD.n424 1.28631
R2061 VDD.t19 VDD.n802 4.17719
R2062 VDD.t19 VDD.n804 4.17719
R2063 VDD.t19 VDD.n809 4.17719
R2064 VDD.t19 VDD.n318 1.37267
R2065 VDD.n380 VDD.n793 0.330415
R2066 VDD.n11 VDD.n417 0.512922
R2067 VDD.t310 VDD.n738 4.17719
R2068 VDD.t310 VDD.n751 4.17719
R2069 VDD.n236 VDD.n235 0.172535
R2070 VDD.n207 VDD.n389 0.273009
R2071 VDD.n465 VDD.n744 0.346703
R2072 VDD.t231 VDD.n673 4.17719
R2073 VDD.t231 VDD.n622 4.17719
R2074 VDD.t231 VDD.n667 4.17719
R2075 VDD.t231 VDD.n212 0.962422
R2076 VDD.t231 VDD.n624 4.17719
R2077 VDD.n402 VDD.n484 0.426829
R2078 VDD.t231 VDD.n653 4.17719
R2079 VDD.t231 VDD.n650 4.17719
R2080 VDD.t270 VDD.n681 4.17719
R2081 VDD.t270 VDD.n683 4.17719
R2082 VDD.t270 VDD.n721 4.17719
R2083 VDD.t270 VDD.n688 4.17719
R2084 VDD.t270 VDD.n692 4.17719
R2085 VDD.t270 VDD.n708 4.17719
R2086 VDD.t270 VDD.n695 4.17719
R2087 VDD.t270 VDD.n703 4.17719
R2088 VDD.n732 VDD.t270 4.17719
R2089 VDD.t2 VDD.n550 4.17719
R2090 VDD.n403 VDD.n51 0.266692
R2091 VDD.t5 VDD.n943 4.177
R2092 VDD.t2 VDD.n404 1.72294
R2093 VDD.t2 VDD.n570 4.177
R2094 VDD.n20 VDD.n112 0.316596
R2095 VDD.t16 VDD.n777 4.177
R2096 VDD.t83 VDD.n586 3.48613
R2097 VDD.t270 VDD.n698 3.35597
R2098 VDD.n114 VDD.n786 0.568977
R2099 VDD.n916 VDD.t2 3.30723
R2100 VDD.t8 VDD.n21 0.593657
R2101 VDD.t8 VDD.n895 3.30723
R2102 VDD.t8 VDD.n902 3.30723
R2103 VDD.t8 VDD.n896 3.30723
R2104 VDD.n296 VDD.n899 0.465623
R2105 VDD.t8 VDD.n892 3.30723
R2106 VDD.t52 VDD.n583 3.30723
R2107 VDD.t52 VDD.n885 3.30723
R2108 VDD.t52 VDD.n862 3.30723
R2109 VDD.t0 VDD.n23 0.675224
R2110 VDD.t0 VDD.n98 0.944147
R2111 VDD.t0 VDD.n134 1.22845
R2112 VDD.t83 VDD.n605 3.30723
R2113 VDD.t19 VDD.n79 1.09602
R2114 VDD.n298 VDD.n789 0.365977
R2115 VDD.t19 VDD.n790 3.30723
R2116 VDD.t16 VDD.n11 0.525807
R2117 VDD.t310 VDD.n768 3.30723
R2118 VDD.t310 VDD.n740 3.30723
R2119 VDD.t231 VDD.n671 3.30723
R2120 VDD.t231 VDD.n623 3.30723
R2121 VDD.n464 VDD.n665 0.418669
R2122 VDD.n461 VDD.n625 0.418669
R2123 VDD.t231 VDD.n660 3.30723
R2124 VDD.t231 VDD.n644 3.30723
R2125 VDD.t231 VDD.n636 3.30723
R2126 VDD.t231 VDD.n642 3.30723
R2127 VDD.t270 VDD.n717 3.30723
R2128 VDD.t270 VDD.n691 3.30723
R2129 VDD.t270 VDD.n694 3.30723
R2130 VDD.t270 VDD.n705 3.30723
R2131 VDD.t270 VDD.n697 3.30723
R2132 VDD.t270 VDD.n700 3.30723
R2133 VDD.t5 VDD.n941 3.30706
R2134 VDD.t5 VDD.n117 0.79039
R2135 VDD.t2 VDD.n0 0.695748
R2136 VDD.t16 VDD.n414 1.51763
R2137 VDD.t2 VDD.n568 3.30688
R2138 VDD.t2 VDD.n552 3.30688
R2139 VDD.n292 VDD.n35 0.584885
R2140 VDD.n520 VDD.n765 0.219279
R2141 VDD.n530 VDD.n669 0.219279
R2142 VDD.t83 VDD.n606 2.86
R2143 VDD.t5 VDD.n459 1.21699
R2144 VDD.n21 VDD.n893 0.626094
R2145 VDD.t8 VDD.n908 2.72142
R2146 VDD.n483 VDD.n890 0.492399
R2147 VDD.t83 VDD.n834 2.72142
R2148 VDD.t16 VDD.n126 0.700016
R2149 VDD.n433 VDD.t83 1.47626
R2150 VDD.n116 VDD.n911 0.331658
R2151 VDD.n124 VDD.n850 0.331658
R2152 VDD.t2 VDD.n554 2.4164
R2153 VDD.n730 VDD.t270 2.33787
R2154 VDD.n538 VDD.t8 2.09903
R2155 VDD.n445 VDD.t2 1.63933
R2156 VDD.n287 VDD.n288 0.318235
R2157 VDD.t5 VDD.n535 2.08819
R2158 VDD.t52 VDD.n584 2.07686
R2159 VDD.t16 VDD.n787 1.97699
R2160 VDD.n487 VDD.n709 0.971457
R2161 VDD.n488 VDD.n536 0.971999
R2162 VDD.n487 VDD.n710 0.820551
R2163 VDD.n77 VDD.n533 1.04926
R2164 VDD.n543 VDD.n723 0.971457
R2165 VDD.t270 VDD.n488 0.497316
R2166 VDD.n958 VDD.n497 0.66578
R2167 VDD.n914 VDD.n497 0.66578
R2168 VDD.n914 VDD.n913 0.66578
R2169 VDD.n913 VDD.n887 0.66578
R2170 VDD.n887 VDD.n496 0.66578
R2171 VDD.n825 VDD.n496 0.66578
R2172 VDD.n825 VDD.n824 0.66578
R2173 VDD.n824 VDD.n788 0.66578
R2174 VDD.n788 VDD.n495 0.66578
R2175 VDD.n734 VDD.n495 0.66578
R2176 VDD.n957 VDD.n933 0.66578
R2177 VDD.n933 VDD.n498 0.66578
R2178 VDD.n853 VDD.n498 0.66578
R2179 VDD.n853 VDD.n852 0.66578
R2180 VDD.n852 VDD.n836 0.66578
R2181 VDD.n836 VDD.n295 0.66578
R2182 VDD.n771 VDD.n295 0.66578
R2183 VDD.n771 VDD.n770 0.66578
R2184 VDD.n770 VDD.n735 0.66578
R2185 VDD.n787 VDD.n785 0.455756
R2186 VDD.n787 VDD.n786 0.44798
R2187 VDD.n883 VDD.n584 0.385567
R2188 VDD.n908 VDD.n907 0.377842
R2189 VDD.n731 VDD.n730 0.377569
R2190 VDD VDD.n958 0.3525
R2191 VDD.n22 VDD.n21 0.0774733
R2192 VDD.n835 VDD.n834 0.348611
R2193 VDD.n909 VDD.n908 0.346111
R2194 VDD.n834 VDD.n833 0.341592
R2195 VDD.n644 VDD.n643 0.336433
R2196 VDD.n717 VDD.n536 0.336433
R2197 VDD.n709 VDD.n691 0.336433
R2198 VDD.n895 VDD.n894 0.335195
R2199 VDD.n642 VDD.n641 0.335195
R2200 VDD.n486 VDD.n193 0.134839
R2201 VDD.n905 VDD.n895 0.332683
R2202 VDD.n98 VDD.n847 0.551458
R2203 VDD.n79 VDD.n77 0.537594
R2204 VDD.n642 VDD.n640 0.332683
R2205 VDD.n486 VDD.n662 0.515577
R2206 VDD.n646 VDD.n644 0.331445
R2207 VDD.n717 VDD.n716 0.331445
R2208 VDD.n712 VDD.n691 0.331445
R2209 VDD.n767 VDD.n420 0.481608
R2210 VDD.n421 VDD.n420 0.155832
R2211 VDD.n668 VDD.n623 0.318945
R2212 VDD.n833 VDD.n605 0.312695
R2213 VDD.n902 VDD.n399 0.307683
R2214 VDD.n666 VDD.n623 0.307683
R2215 VDD.n900 VDD.n896 0.303933
R2216 VDD.n884 VDD.n583 0.303933
R2217 VDD.n97 VDD.n95 0.444941
R2218 VDD.n768 VDD.n766 0.303933
R2219 VDD.n660 VDD.n658 0.303933
R2220 VDD.n28 VDD.n626 0.497214
R2221 VDD.n671 VDD.n670 0.303933
R2222 VDD.n707 VDD.n694 0.303933
R2223 VDD.n705 VDD.n704 0.303933
R2224 VDD.n702 VDD.n697 0.303933
R2225 VDD.n700 VDD.n699 0.303933
R2226 VDD.n553 VDD.n552 0.303308
R2227 VDD.n569 VDD.n568 0.303308
R2228 VDD.n117 VDD.n950 0.847632
R2229 VDD.n941 VDD.n940 0.302996
R2230 VDD.n917 VDD.n916 0.302695
R2231 VDD.n903 VDD.n902 0.302695
R2232 VDD.n892 VDD.n891 0.302695
R2233 VDD.n862 VDD.n861 0.302695
R2234 VDD.n798 VDD.n790 0.302695
R2235 VDD.n752 VDD.n740 0.302695
R2236 VDD.n212 VDD.n211 0.0888622
R2237 VDD.n554 VDD.n553 0.30173
R2238 VDD.n723 VDD.n452 0.494527
R2239 VDD.n297 VDD.n296 0.119968
R2240 VDD.n940 VDD.n459 0.471173
R2241 VDD.n885 VDD.n884 0.292695
R2242 VDD.n885 VDD.n883 0.290183
R2243 VDD.n465 VDD.n8 0.136201
R2244 VDD.n948 VDD.n535 0.410008
R2245 VDD.n20 VDD.n19 0.169159
R2246 VDD.n938 VDD.n145 0.741382
R2247 VDD.n916 VDD.n915 0.271433
R2248 VDD.n892 VDD.n890 0.271433
R2249 VDD.n499 VDD.n862 0.271433
R2250 VDD.n134 VDD.n846 0.671096
R2251 VDD.n425 VDD.n424 0.235397
R2252 VDD.n796 VDD.n790 0.271433
R2253 VDD.n750 VDD.n740 0.271433
R2254 VDD.n462 VDD.n461 0.146997
R2255 VDD.n212 VDD.n664 0.468318
R2256 VDD.n464 VDD.n463 0.146997
R2257 VDD.n942 VDD.n941 0.271118
R2258 VDD.n552 VDD.n551 0.270799
R2259 VDD.n568 VDD.n567 0.270799
R2260 VDD.n896 VDD.n363 0.270195
R2261 VDD.n583 VDD.n582 0.270195
R2262 VDD.n172 VDD.n171 0.165748
R2263 VDD.n768 VDD.n767 0.270195
R2264 VDD.n660 VDD.n659 0.270195
R2265 VDD.n672 VDD.n671 0.270195
R2266 VDD.n694 VDD.n693 0.270195
R2267 VDD.n706 VDD.n705 0.270195
R2268 VDD.n697 VDD.n696 0.270195
R2269 VDD.n701 VDD.n700 0.270195
R2270 VDD.n551 VDD.n550 0.26778
R2271 VDD.n24 VDD.n23 0.0441458
R2272 VDD.n673 VDD.n672 0.26778
R2273 VDD.n721 VDD.n719 0.26778
R2274 VDD.n693 VDD.n692 0.26778
R2275 VDD.n708 VDD.n706 0.26778
R2276 VDD.n696 VDD.n695 0.26778
R2277 VDD.n703 VDD.n701 0.26778
R2278 VDD.n943 VDD.n942 0.267394
R2279 VDD.n500 VDD.n499 0.267011
R2280 VDD.n576 VDD.n575 0.267011
R2281 VDD.n846 VDD.n845 0.267011
R2282 VDD.n433 VDD.n153 0.095135
R2283 VDD.n751 VDD.n750 0.267011
R2284 VDD.n650 VDD.n649 0.267011
R2285 VDD.n664 VDD.n624 0.267011
R2286 VDD.n674 VDD.n673 0.267011
R2287 VDD.n299 VDD.n298 0.162774
R2288 VDD.t299 VDD.t300 0.263235
R2289 VDD.n539 VDD.t299 0.154919
R2290 VDD.n839 VDD.n838 0.26153
R2291 VDD.n765 VDD.n738 0.26153
R2292 VDD.n669 VDD.n622 0.26153
R2293 VDD.n521 VDD.n847 0.468865
R2294 VDD.n831 VDD.n605 0.261433
R2295 VDD.n641 VDD.n636 0.261433
R2296 VDD.n944 VDD.n943 0.261144
R2297 VDD.n722 VDD.n681 0.260761
R2298 VDD.n710 VDD.n692 0.260761
R2299 VDD.n643 VDD.n636 0.260195
R2300 VDD.n619 VDD.n618 0.255554
R2301 VDD.n596 VDD.n595 0.25528
R2302 VDD.n805 VDD.n804 0.25528
R2303 VDD.n803 VDD.n802 0.25528
R2304 VDD.n801 VDD.n466 0.364808
R2305 VDD.n682 VDD.n681 0.25528
R2306 VDD.n684 VDD.n683 0.25528
R2307 VDD.n689 VDD.n688 0.25528
R2308 VDD.n678 VDD.n80 0.414963
R2309 VDD.n733 VDD.n732 0.25528
R2310 VDD.n546 VDD.n404 0.5373
R2311 VDD.n878 VDD.n877 0.250761
R2312 VDD.n912 VDD.n909 0.24903
R2313 VDD.n579 VDD.n578 0.24903
R2314 VDD.n413 VDD.n412 0.303049
R2315 VDD.n433 VDD.n835 0.409066
R2316 VDD.n877 VDD.n876 0.24528
R2317 VDD.n577 VDD.n576 0.24528
R2318 VDD.n810 VDD.n809 0.24528
R2319 VDD.n11 VDD.n10 0.127235
R2320 VDD.n411 VDD.n206 0.192494
R2321 VDD.n751 VDD.n749 0.24528
R2322 VDD.n650 VDD.n648 0.24528
R2323 VDD.n571 VDD.n570 0.244894
R2324 VDD.n777 VDD.n776 0.244894
R2325 VDD.n210 VDD.n209 0.244511
R2326 VDD.n809 VDD.n808 0.244511
R2327 VDD.n653 VDD.n652 0.244511
R2328 VDD.n721 VDD.n720 0.244511
R2329 VDD.n699 VDD.n698 0.243807
R2330 VDD.n531 VDD.n726 0.254894
R2331 VDD.n528 VDD.n728 0.234894
R2332 VDD.n503 VDD.n394 0.116978
R2333 VDD.n795 VDD.n794 0.235486
R2334 VDD.n301 VDD.n300 0.235486
R2335 VDD.n484 VDD.n166 0.235486
R2336 VDD.n918 VDD.n917 0.23528
R2337 VDD.n861 VDD.n860 0.23528
R2338 VDD.n402 VDD.n401 0.178575
R2339 VDD.n625 VDD.n624 0.23528
R2340 VDD.n667 VDD.n665 0.23528
R2341 VDD.n570 VDD.n569 0.234894
R2342 VDD.n305 VDD.n777 0.234894
R2343 VDD.n876 VDD.n875 0.234511
R2344 VDD.n578 VDD.n577 0.234511
R2345 VDD.n766 VDD.n738 0.234511
R2346 VDD.n670 VDD.n622 0.234511
R2347 VDD.n688 VDD.n687 0.234511
R2348 VDD.n708 VDD.n707 0.234511
R2349 VDD.n704 VDD.n695 0.234511
R2350 VDD.n703 VDD.n702 0.234511
R2351 VDD.n732 VDD.n731 0.234511
R2352 VDD.n388 VDD.n387 0.0856502
R2353 VDD.n919 VDD.n918 0.232011
R2354 VDD.n667 VDD.n666 0.230761
R2355 VDD.n235 VDD.n234 0.22778
R2356 VDD.n638 VDD.n287 0.308388
R2357 VDD.n848 VDD.n838 0.224511
R2358 VDD.n804 VDD.n803 0.224511
R2359 VDD.n802 VDD.n801 0.224511
R2360 VDD.n467 VDD.n466 0.110135
R2361 VDD.n683 VDD.n682 0.224511
R2362 VDD.n214 VDD.n606 0.223931
R2363 VDD.n481 VDD.n108 0.577625
R2364 VDD.n675 VDD.n621 0.218325
R2365 VDD.n408 VDD.n746 0.214575
R2366 VDD.n656 VDD.n632 0.214575
R2367 VDD.n562 VDD.n561 0.214236
R2368 VDD.n69 VDD.n68 0.26519
R2369 VDD.n837 VDD.n169 0.348973
R2370 VDD.n587 VDD.n405 0.267113
R2371 VDD.n881 VDD.n584 0.21051
R2372 VDD.n638 VDD.n637 0.208325
R2373 VDD.n659 VDD.n627 0.208325
R2374 VDD.n573 VDD.n572 0.207986
R2375 VDD.n931 VDD.n930 0.207986
R2376 VDD.n828 VDD.n827 0.207986
R2377 VDD.n797 VDD.n796 0.207986
R2378 VDD.n779 VDD.n778 0.207986
R2379 VDD.n775 VDD.n774 0.207986
R2380 VDD.n634 VDD.n633 0.207986
R2381 VDD.n875 VDD.n874 0.20653
R2382 VDD.n742 VDD.n389 0.25894
R2383 VDD.n912 VDD.n911 0.205761
R2384 VDD.n860 VDD.n859 0.205761
R2385 VDD.n229 VDD.n557 0.439971
R2386 VDD.n215 VDD.n214 0.202075
R2387 VDD.n764 VDD.n739 0.201736
R2388 VDD.n714 VDD.n713 0.201736
R2389 VDD.n119 VDD.t269 0.325115
R2390 VDD.n845 VDD.n844 0.20028
R2391 VDD.n653 VDD.n651 0.20028
R2392 VDD.n773 VDD.n772 0.20009
R2393 VDD.n737 VDD.n736 0.20009
R2394 VDD.n550 VDD.n549 0.199511
R2395 VDD.n597 VDD.n596 0.199511
R2396 VDD.n555 VDD.n554 0.198926
R2397 VDD.n823 VDD.n533 0.650893
R2398 VDD.n870 VDD.n105 0.649976
R2399 VDD.n330 VDD.n329 0.264247
R2400 VDD.n851 VDD.n848 0.195825
R2401 VDD.n247 VDD.n245 0.0815657
R2402 VDD.n107 VDD.n253 0.0809249
R2403 VDD.n131 VDD.n256 0.0809249
R2404 VDD.n262 VDD.n260 0.0803915
R2405 VDD.n264 VDD.n141 0.0804422
R2406 VDD.n268 VDD.n265 0.0809249
R2407 VDD.n826 VDD.n270 0.190118
R2408 VDD.n3 VDD.n276 0.0809249
R2409 VDD.n12 VDD.n273 0.190118
R2410 VDD.n610 VDD.n609 0.187986
R2411 VDD.n953 VDD.n952 0.185825
R2412 VDD.n501 VDD.n57 0.417131
R2413 VDD.n94 VDD.n92 0.229434
R2414 VDD.n409 VDD.n408 0.185486
R2415 VDD.n632 VDD.n631 0.185486
R2416 VDD.n621 VDD.n620 0.185486
R2417 VDD.n778 VDD.n126 0.650765
R2418 VDD.n718 VDD.n617 0.180825
R2419 VDD.n224 VDD.n223 0.174904
R2420 VDD.n26 VDD.n25 0.255023
R2421 VDD.n545 VDD.n309 0.41994
R2422 VDD.n174 VDD.n173 0.271118
R2423 VDD.n529 VDD.n176 0.270808
R2424 VDD.n180 VDD.n179 0.380061
R2425 VDD.n506 VDD.n505 0.119663
R2426 VDD.n952 VDD.n951 0.175825
R2427 VDD.n572 VDD.n571 0.175825
R2428 VDD.n930 VDD.n929 0.175825
R2429 VDD.n901 VDD.n899 0.175825
R2430 VDD.n891 VDD.n291 0.460505
R2431 VDD.n476 VDD.n475 0.229805
R2432 VDD.n776 VDD.n775 0.175825
R2433 VDD.n652 VDD.n634 0.175825
R2434 VDD.n720 VDD.n685 0.175825
R2435 VDD.n840 VDD.n432 0.225155
R2436 VDD.n956 VDD.n953 0.175486
R2437 VDD.n950 VDD.n949 0.175486
R2438 VDD.n558 VDD.n228 0.222537
R2439 VDD.n901 VDD.n900 0.175486
R2440 VDD.n927 VDD.n926 0.171736
R2441 VDD.n780 VDD.n779 0.168325
R2442 VDD.n396 VDD.n164 0.0843809
R2443 VDD.n620 VDD.n619 0.167157
R2444 VDD.n345 VDD.n897 0.16689
R2445 VDD.n128 VDD.n312 0.16689
R2446 VDD.n481 VDD.n937 0.166554
R2447 VDD.n938 VDD.n936 0.166554
R2448 VDD.n955 VDD.n954 0.166554
R2449 VDD.n196 VDD.n195 0.166554
R2450 VDD.n353 VDD.n492 0.166554
R2451 VDD.n383 VDD.n381 0.166554
R2452 VDD.n352 VDD.n350 0.166554
R2453 VDD.n725 VDD.n724 0.166554
R2454 VDD.t579 VDD.t300 0.16604
R2455 VDD.n867 VDD.n866 0.165486
R2456 VDD.n685 VDD.n684 0.165486
R2457 VDD.n690 VDD.n689 0.165486
R2458 VDD.n679 VDD.n678 0.165486
R2459 VDD.n613 VDD.n610 0.164575
R2460 VDD.n794 VDD.n793 0.163325
R2461 VDD.n143 VDD.n248 0.357175
R2462 VDD.n355 VDD.n353 0.162039
R2463 VDD.n333 VDD.n332 0.139056
R2464 VDD.n219 VDD.n218 0.217362
R2465 VDD.n337 VDD.n336 0.139056
R2466 VDD.n340 VDD.n339 0.139056
R2467 VDD.n549 VDD.n548 0.160789
R2468 VDD.n844 VDD.n843 0.160789
R2469 VDD.n598 VDD.n597 0.160789
R2470 VDD.n543 VDD.n722 0.820553
R2471 VDD.n713 VDD.n488 0.820072
R2472 VDD.n56 VDD.n54 0.172671
R2473 VDD.n373 VDD.n407 0.70633
R2474 VDD.n318 VDD.n816 0.592933
R2475 VDD.n209 VDD.n385 0.47004
R2476 VDD.n357 VDD.n356 0.354714
R2477 VDD.n359 VDD.n358 0.354714
R2478 VDD.n391 VDD.n390 0.618204
R2479 VDD.n347 VDD.n432 0.588846
R2480 VDD.n208 VDD.n206 0.586978
R2481 VDD.n208 VDD.n207 0.586768
R2482 VDD.n774 VDD.n414 0.546494
R2483 VDD.n421 VDD.n769 0.574207
R2484 VDD.n183 VDD.n182 0.402814
R2485 VDD.n633 VDD.n401 0.574563
R2486 VDD.n886 VDD.n400 0.527912
R2487 VDD.n595 VDD.n406 0.506912
R2488 VDD.n463 VDD.n115 0.534739
R2489 VDD.n425 VDD.n373 0.521791
R2490 VDD.t270 VDD.n487 0.496968
R2491 VDD.n663 VDD.n462 0.492239
R2492 VDD.n431 VDD.n171 0.582523
R2493 VDD.n485 VDD.n391 0.481656
R2494 VDD.n467 VDD.n800 0.479733
R2495 VDD.n410 VDD.n73 0.462074
R2496 VDD.n429 VDD.n294 0.457424
R2497 VDD.n874 VDD.n477 0.448342
R2498 VDD.n455 VDD.n431 0.446388
R2499 VDD.n383 VDD.n380 0.437173
R2500 VDD.n427 VDD.n67 0.433668
R2501 VDD.n585 VDD.n384 0.431736
R2502 VDD.n154 VDD.n153 0.430979
R2503 VDD.n39 VDD.n935 0.421316
R2504 VDD.n524 VDD.n478 0.421202
R2505 VDD.n194 VDD.n193 0.420979
R2506 VDD.n371 VDD.n370 0.419052
R2507 VDD.n519 VDD.n409 0.417556
R2508 VDD.n423 VDD.n390 0.380806
R2509 VDD.n451 VDD.n450 0.416866
R2510 VDD.n472 VDD.n471 0.415636
R2511 VDD.n470 VDD.n469 0.415636
R2512 VDD.n493 VDD.n468 0.415636
R2513 VDD.n112 VDD.n454 0.413514
R2514 VDD.t19 VDD.n533 0.37595
R2515 VDD.n565 VDD.n564 0.158289
R2516 VDD.n580 VDD.n70 0.863138
R2517 VDD.n869 VDD.n868 0.158289
R2518 VDD.n832 VDD.n831 0.158289
R2519 VDD.n630 VDD.n629 0.158289
R2520 VDD.n763 VDD.n762 0.155789
R2521 VDD.n139 VDD.n138 0.155789
R2522 VDD.n923 VDD.n922 0.154539
R2523 VDD.n859 VDD.n858 0.154539
R2524 VDD.n856 VDD.n854 0.154539
R2525 VDD.n813 VDD.n474 0.154539
R2526 VDD.n303 VDD.n302 0.154539
R2527 VDD.n818 VDD.n799 0.154539
R2528 VDD.n563 VDD.n562 0.153325
R2529 VDD.n926 VDD.n925 0.153325
R2530 VDD.n873 VDD.n857 0.153325
R2531 VDD.n956 VDD.n541 0.201868
R2532 VDD.n719 VDD.n718 0.152986
R2533 VDD.n948 VDD.n947 0.152808
R2534 VDD.n561 VDD.n560 0.152808
R2535 VDD.n923 VDD.n574 0.152808
R2536 VDD.n905 VDD.n904 0.152808
R2537 VDD.n911 VDD.n910 0.152808
R2538 VDD.n864 VDD.n863 0.152808
R2539 VDD.n856 VDD.n855 0.152808
R2540 VDD.n850 VDD.n849 0.152808
R2541 VDD.n157 VDD.n156 0.152808
R2542 VDD.n366 VDD.n364 0.152808
R2543 VDD.n818 VDD.n817 0.152808
R2544 VDD.n383 VDD.n382 0.152808
R2545 VDD.n378 VDD.n377 0.152808
R2546 VDD.n742 VDD.n741 0.152808
R2547 VDD.n746 VDD.n745 0.152808
R2548 VDD.n656 VDD.n655 0.152808
R2549 VDD.n646 VDD.n645 0.152808
R2550 VDD.n640 VDD.n639 0.152808
R2551 VDD.n437 VDD.n436 0.152808
R2552 VDD.n662 VDD.n661 0.152808
R2553 VDD.n712 VDD.n711 0.152808
R2554 VDD.n716 VDD.n715 0.152808
R2555 VDD.n564 VDD.n563 0.148289
R2556 VDD.n567 VDD.n566 0.148289
R2557 VDD.n925 VDD.n924 0.148289
R2558 VDD.n582 VDD.n581 0.148289
R2559 VDD.n158 VDD.n829 0.415251
R2560 VDD.n789 VDD.n242 0.225505
R2561 VDD.n173 VDD.n534 0.267394
R2562 VDD.n179 VDD.n528 0.267394
R2563 VDD.n949 VDD.n948 0.147075
R2564 VDD.n820 VDD.n818 0.147075
R2565 VDD.n716 VDD.n690 0.147075
R2566 VDD.n714 VDD.n712 0.147075
R2567 VDD.n415 VDD.n879 0.147039
R2568 VDD.n607 VDD.n18 0.965382
R2569 VDD.n857 VDD.n856 0.146736
R2570 VDD.n851 VDD.n850 0.146736
R2571 VDD.n640 VDD.n637 0.146736
R2572 VDD.n662 VDD.n627 0.146736
R2573 VDD.n762 VDD.n739 0.145825
R2574 VDD.n547 VDD.n443 0.145789
R2575 VDD.n842 VDD.n441 0.145789
R2576 VDD.n600 VDD.n599 0.145789
R2577 VDD.n756 VDD.n755 0.145789
R2578 VDD.n602 VDD.n586 0.14241
R2579 VDD.n635 VDD.n438 0.324441
R2580 VDD.n278 VDD.n227 0.27566
R2581 VDD.n282 VDD.n281 0.0307397
R2582 VDD.n491 VDD.n490 0.140789
R2583 VDD.n761 VDD.n760 0.140789
R2584 VDD.n434 VDD.n932 0.139539
R2585 VDD.n815 VDD.n814 0.139539
R2586 VDD.n419 VDD.n898 0.393652
R2587 VDD.n822 VDD.n821 0.138289
R2588 VDD.n784 VDD.n782 0.138289
R2589 VDD.n748 VDD.n747 0.138289
R2590 VDD.n753 VDD.n285 0.138289
R2591 VDD.n820 VDD.n819 0.137986
R2592 VDD.n907 VDD.n538 0.283119
R2593 VDD.n521 VDD.n839 0.404003
R2594 VDD.n45 VDD.n41 0.403975
R2595 VDD.n347 VDD.n95 0.56779
R2596 VDD.n308 VDD.n307 0.56708
R2597 VDD.n483 VDD.n395 0.545327
R2598 VDD.n113 VDD.n112 0.542548
R2599 VDD.n387 VDD.n386 0.529472
R2600 VDD.n356 VDD.n75 0.525205
R2601 VDD.n494 VDD.n334 0.524386
R2602 VDD.n310 VDD.n230 0.512853
R2603 VDD.n355 VDD.n354 0.508745
R2604 VDD.n73 VDD.n71 0.50841
R2605 VDD.n363 VDD.n362 0.507136
R2606 VDD.n361 VDD.n277 0.284836
R2607 VDD.n346 VDD.n345 0.495227
R2608 VDD.n588 VDD.n369 0.490932
R2609 VDD.n367 VDD.n241 0.481656
R2610 VDD.n651 VDD.n140 0.61388
R2611 VDD.n129 VDD.n128 0.601566
R2612 VDD.n348 VDD.n840 0.391469
R2613 VDD.n399 VDD.n398 0.470886
R2614 VDD.n103 VDD.n102 0.469287
R2615 VDD.n234 VDD.n311 0.469085
R2616 VDD.n339 VDD.n338 0.463915
R2617 VDD.n336 VDD.n335 0.463915
R2618 VDD.n332 VDD.n331 0.463915
R2619 VDD.n511 VDD.n343 0.463337
R2620 VDD.n516 VDD.n341 0.463337
R2621 VDD.n352 VDD.n351 0.459808
R2622 VDD.n459 VDD.n376 0.455797
R2623 VDD.t617 VDD.n49 0.454589
R2624 VDD.n366 VDD.n365 0.448311
R2625 VDD.n14 VDD.n13 0.438754
R2626 VDD.n165 VDD.n164 0.433578
R2627 VDD.n611 VDD.n379 0.404833
R2628 VDD.n394 VDD.n393 0.426367
R2629 VDD.n392 VDD.n168 0.425789
R2630 VDD.n181 VDD.n524 0.416679
R2631 VDD.n163 VDD.n65 0.416679
R2632 VDD.n383 VDD.n213 0.408656
R2633 VDD.n14 VDD.n12 0.407903
R2634 VDD.n612 VDD.n36 0.406078
R2635 VDD.n474 VDD.n473 0.390102
R2636 VDD.n205 VDD.n798 0.161345
R2637 VDD.n649 VDD.n542 0.0873943
R2638 VDD.n888 VDD.n184 0.135789
R2639 VDD.n868 VDD.n867 0.135789
R2640 VDD.n594 VDD.n593 0.135789
R2641 VDD.n806 VDD.n283 0.241938
R2642 VDD.n800 VDD.n799 0.135789
R2643 VDD.n791 VDD.n186 0.135789
R2644 VDD.n615 VDD.n614 0.135789
R2645 VDD.n189 VDD.n188 0.135789
R2646 VDD.n506 VDD.n504 0.13351
R2647 VDD.n816 VDD.n815 0.133289
R2648 VDD.n812 VDD.n811 0.133289
R2649 VDD.n393 VDD.n616 0.133289
R2650 VDD.n781 VDD.n780 0.133289
R2651 VDD.n866 VDD.n865 0.132075
R2652 VDD.n828 VDD.n826 0.132075
R2653 VDD.n102 VDD.n372 0.122082
R2654 VDD.n603 VDD.n601 0.130789
R2655 VDD.n758 VDD.n757 0.130789
R2656 VDD.n928 VDD.n927 0.129539
R2657 VDD.n592 VDD.n591 0.129539
R2658 VDD.n590 VDD.n589 0.129539
R2659 VDD.n527 VDD.n525 0.12922
R2660 VDD.n316 VDD.n314 0.12922
R2661 VDD.n524 VDD.n522 0.12922
R2662 VDD.n253 VDD.n251 0.12922
R2663 VDD.n107 VDD.n321 0.12922
R2664 VDD.n256 VDD.n254 0.12922
R2665 VDD.n131 VDD.n323 0.12922
R2666 VDD.n200 VDD.n199 0.12922
R2667 VDD.n258 VDD.n257 0.12922
R2668 VDD.n268 VDD.n266 0.12922
R2669 VDD.n265 VDD.n325 0.12922
R2670 VDD.n32 VDD.n30 0.12922
R2671 VDD.n276 VDD.n274 0.12922
R2672 VDD.n3 VDD.n327 0.12922
R2673 VDD.n273 VDD.n271 0.12922
R2674 VDD.n527 VDD.n526 0.128884
R2675 VDD.n316 VDD.n315 0.128884
R2676 VDD.n524 VDD.n523 0.128884
R2677 VDD.n247 VDD.n246 0.128884
R2678 VDD.n250 VDD.n249 0.128884
R2679 VDD.n73 VDD.n72 0.128884
R2680 VDD.n253 VDD.n252 0.128884
R2681 VDD.n107 VDD.n322 0.128884
R2682 VDD.n935 VDD.n934 0.128884
R2683 VDD.n256 VDD.n255 0.128884
R2684 VDD.n131 VDD.n324 0.128884
R2685 VDD.n262 VDD.n261 0.128884
R2686 VDD.n260 VDD.n313 0.128884
R2687 VDD.n264 VDD.n263 0.128884
R2688 VDD.n141 VDD.n320 0.128884
R2689 VDD.n268 VDD.n267 0.128884
R2690 VDD.n265 VDD.n326 0.128884
R2691 VDD.n276 VDD.n275 0.128884
R2692 VDD.n3 VDD.n328 0.128884
R2693 VDD.n273 VDD.n272 0.128884
R2694 VDD.n270 VDD.n269 0.128884
R2695 VDD.n122 VDD.n121 0.128884
R2696 VDD.n920 VDD.n919 0.128289
R2697 VDD.n150 VDD.n920 0.128289
R2698 VDD.n680 VDD.n679 0.127075
R2699 VDD.n797 VDD.n795 0.125825
R2700 VDD.n300 VDD.n147 0.542882
R2701 VDD.n518 VDD.n311 0.20881
R2702 VDD.n559 VDD.n558 0.125789
R2703 VDD.n922 VDD.n921 0.125789
R2704 VDD.n929 VDD.n928 0.125789
R2705 VDD.n475 VDD.n854 0.125789
R2706 VDD.n882 VDD.n881 0.125789
R2707 VDD.n442 VDD.n841 0.244894
R2708 VDD.n603 VDD.n602 0.125789
R2709 VDD.n759 VDD.n758 0.125789
R2710 VDD.n728 VDD.n529 0.303299
R2711 VDD.n687 VDD.n686 0.125789
R2712 VDD.n783 VDD.n781 0.123289
R2713 VDD.n686 VDD.n617 0.120789
R2714 VDD.t617 VDD.n47 0.0465481
R2715 VDD.n822 VDD.n225 0.118289
R2716 VDD.n784 VDD.n783 0.118289
R2717 VDD.n906 VDD.n903 0.115789
R2718 VDD.n811 VDD.n810 0.115789
R2719 VDD.n808 VDD.n304 0.234894
R2720 VDD.n749 VDD.n748 0.115789
R2721 VDD.n162 VDD.n754 0.37607
R2722 VDD.n760 VDD.n759 0.115789
R2723 VDD.n648 VDD.n647 0.115789
R2724 VDD.n631 VDD.n630 0.115789
R2725 VDD.n658 VDD.n628 0.115789
R2726 VDD.n604 VDD.n586 0.115024
R2727 VDD.n832 VDD.n830 0.114539
R2728 VDD.n939 VDD.n540 0.172055
R2729 VDD.n544 VDD.n680 0.172055
R2730 VDD.n151 VDD.n150 0.446105
R2731 VDD.n609 VDD.n608 0.113289
R2732 VDD.n593 VDD.n592 0.112039
R2733 VDD.n591 VDD.n590 0.112039
R2734 VDD.n279 VDD.n585 0.110789
R2735 VDD.n601 VDD.n600 0.110789
R2736 VDD.n757 VDD.n756 0.110789
R2737 VDD.n879 VDD.n878 0.109539
R2738 VDD.n527 VDD.n316 0.190118
R2739 VDD.n185 VDD.n472 0.338174
R2740 VDD.n514 VDD.n460 0.195254
R2741 VDD.n187 VDD.n470 0.338174
R2742 VDD.n361 VDD.n360 0.339614
R2743 VDD.n468 VDD.n190 0.338174
R2744 VDD.n616 VDD.n615 0.108289
R2745 VDD.n864 VDD.n258 0.107618
R2746 VDD.n280 VDD.n279 0.105789
R2747 VDD.n871 VDD.n870 0.105789
R2748 VDD.n807 VDD.n806 0.105789
R2749 VDD.n726 VDD.n532 0.224894
R2750 VDD.n727 VDD.n531 0.224894
R2751 VDD.n872 VDD.n374 0.166372
R2752 VDD.n520 VDD.n764 0.21814
R2753 VDD.n530 VDD.n668 0.21814
R2754 VDD.n589 VDD.n588 0.103289
R2755 VDD.n160 VDD.n753 0.377037
R2756 VDD.n331 VDD.n517 0.103002
R2757 VDD.n516 VDD.n515 0.103002
R2758 VDD.n514 VDD.n513 0.103002
R2759 VDD.n335 VDD.n512 0.103002
R2760 VDD.n511 VDD.n510 0.103002
R2761 VDD.n360 VDD.n509 0.103002
R2762 VDD.n338 VDD.n508 0.103002
R2763 VDD.n349 VDD.n507 0.103002
R2764 VDD.n819 VDD.n439 0.103
R2765 VDD.n769 VDD.n737 0.10271
R2766 VDD.n435 VDD.n434 0.153459
R2767 VDD.n872 VDD.n858 0.102039
R2768 VDD.n814 VDD.n813 0.102039
R2769 VDD.n352 VDD.n349 0.192599
R2770 VDD.n490 VDD.n422 0.163474
R2771 VDD.n203 VDD.n604 0.177851
R2772 VDD.n763 VDD.n761 0.100789
R2773 VDD.n945 VDD.n944 0.099539
R2774 VDD.n557 VDD.n556 0.099539
R2775 VDD.n882 VDD.n880 0.099539
R2776 VDD.n412 VDD.n773 0.0989601
R2777 VDD.n535 VDD.n946 0.253626
R2778 VDD.n889 VDD.n888 0.096447
R2779 VDD.n792 VDD.n791 0.096447
R2780 VDD.n188 VDD.n677 0.096447
R2781 VDD.n548 VDD.n547 0.095789
R2782 VDD.n843 VDD.n842 0.095789
R2783 VDD.n599 VDD.n598 0.095789
R2784 VDD.n416 VDD.n415 0.263445
R2785 VDD.n608 VDD.n607 0.094539
R2786 VDD.n743 VDD.n742 0.09425
R2787 VDD.n556 VDD.n555 0.093289
R2788 VDD.n445 VDD.n573 0.32504
R2789 VDD.n932 VDD.n931 0.093289
R2790 VDD.n893 VDD.n447 0.325068
R2791 VDD.n575 VDD.n449 0.325068
R2792 VDD.n148 VDD.n293 0.150441
R2793 VDD.n657 VDD.n654 0.093289
R2794 VDD.n676 VDD.n674 0.093289
R2795 VDD.n827 VDD.n606 0.088075
R2796 VDD.n309 VDD.n308 0.0928157
R2797 VDD.n365 VDD.n587 0.088
R2798 VDD.n744 VDD.n743 0.088
R2799 VDD.n654 VDD.n167 0.250842
R2800 VDD.n561 VDD.n559 0.087039
R2801 VDD.n924 VDD.n923 0.087039
R2802 VDD.n906 VDD.n905 0.087039
R2803 VDD.n302 VDD.n807 0.087039
R2804 VDD.n647 VDD.n646 0.087039
R2805 VDD.n657 VDD.n656 0.087039
R2806 VDD.n482 VDD.n481 0.143935
R2807 VDD.n540 VDD.n938 0.0296542
R2808 VDD.n955 VDD.n480 0.356984
R2809 VDD.n489 VDD.n196 0.143935
R2810 VDD.n537 VDD.n200 0.172054
R2811 VDD.n725 VDD.n544 0.0296542
R2812 VDD.n946 VDD.n945 0.083289
R2813 VDD.n566 VDD.n565 0.083289
R2814 VDD.n894 VDD.n538 0.255693
R2815 VDD.n581 VDD.n580 0.083289
R2816 VDD.n871 VDD.n869 0.083289
R2817 VDD.n629 VDD.n628 0.083289
R2818 VDD.n676 VDD.n675 0.083289
R2819 VDD.n865 VDD.n864 0.083
R2820 VDD.n245 VDD.n237 0.437328
R2821 VDD.n142 VDD.n141 0.576743
R2822 VDD.n178 VDD.n177 0.562861
R2823 VDD.n729 VDD.n180 0.552942
R2824 VDD.n284 VDD.n805 0.542197
R2825 VDD.n175 VDD.n177 0.547555
R2826 VDD.n281 VDD.n106 0.508497
R2827 VDD.n149 VDD.n148 0.50253
R2828 VDD.n178 VDD.n176 0.501784
R2829 VDD.n915 VDD.n292 0.488036
R2830 VDD.n297 VDD.n306 0.459974
R2831 VDD.n227 VDD.n0 0.444384
R2832 VDD.n144 VDD.n143 0.438134
R2833 VDD.n233 VDD.n232 0.421656
R2834 VDD.n259 VDD.n260 0.483062
R2835 VDD.n222 VDD.n223 0.480138
R2836 VDD.n489 VDD.n111 0.77865
R2837 VDD.n545 VDD.n243 0.451747
R2838 VDD.n91 VDD.n221 0.518266
R2839 VDD.n244 VDD.n217 0.481945
R2840 VDD.n225 VDD.n198 0.53539
R2841 VDD.n45 VDD.n42 0.526721
R2842 VDD.n194 VDD.n626 0.496634
R2843 VDD.n182 VDD.n280 0.491808
R2844 VDD.n277 VDD.n213 0.463931
R2845 VDD.n453 VDD.n211 0.445396
R2846 VDD.n880 VDD.n192 0.440342
R2847 VDD.n201 VDD.n200 0.431726
R2848 VDD.n218 VDD.n133 0.42958
R2849 VDD.n65 VDD.n64 0.424344
R2850 VDD.t617 VDD.n48 0.424344
R2851 VDD.n239 VDD.n238 0.422559
R2852 VDD.n236 VDD.n217 0.394065
R2853 VDD.n4 VDD.n3 0.494408
R2854 VDD.n136 VDD.n135 0.416225
R2855 VDD.n227 VDD.n226 0.408386
R2856 VDD.n231 VDD.n230 0.406683
R2857 VDD.n785 VDD.n172 0.400811
R2858 VDD.n299 VDD.n204 0.399561
R2859 VDD.n898 VDD.n233 0.398311
R2860 VDD.n460 VDD.n319 0.393753
R2861 VDD.t1948 VDD.n170 6.28321
R2862 VDD.n34 VDD.n131 2.03912
R2863 VDD.t5 VDD.n76 1.83632
R2864 VDD.t231 VDD.n663 1.66413
R2865 VDD.n38 VDD.n37 1.61998
R2866 VDD.n52 VDD.n9 1.56372
R2867 VDD.n16 VDD.n15 1.54008
R2868 VDD.t16 VDD.n18 1.47175
R2869 VDD.n0 VDD.n546 1.41774
R2870 VDD.n109 VDD.n75 1.3734
R2871 VDD.n9 VDD.n8 1.3581
R2872 VDD.n4 VDD.n273 1.32163
R2873 VDD.n36 VDD.n301 1.31015
R2874 VDD.n16 VDD.n63 1.30095
R2875 VDD.n5 VDD.n754 1.28883
R2876 VDD.n397 VDD.n40 1.28328
R2877 VDD.n76 VDD.n107 1.28223
R2878 VDD.n108 VDD.n38 1.25529
R2879 VDD.n103 VDD.n122 1.24665
R2880 VDD.n453 VDD.n115 1.22632
R2881 VDD.n2 VDD.n1 1.21651
R2882 VDD.t310 VDD.n74 1.18854
R2883 VDD.n14 VDD.n270 1.17875
R2884 VDD.n62 VDD.n7 0.315974
R2885 VDD.n117 VDD.n66 0.218704
R2886 VDD.n119 VDD.t268 0.0384135
R2887 VDD.n76 VDD.n132 1.17282
R2888 VDD.n197 VDD.n7 1.16552
R2889 VDD.n155 VDD.n27 1.16386
R2890 VDD.n110 VDD.n40 1.16195
R2891 VDD.n34 VDD.n35 0.392615
R2892 VDD.t0 VDD.n33 0.921923
R2893 VDD.n35 VDD.t2 0.372815
R2894 VDD.n358 VDD.n53 1.14217
R2895 VDD.t310 VDD.n29 0.974504
R2896 VDD.n58 VDD.n57 1.1023
R2897 VDD.n265 VDD.n32 1.09875
R2898 VDD.t579 VDD.t617 1.09698
R2899 VDD.n76 VDD.n27 1.09346
R2900 VDD.n317 VDD.n129 1.07872
R2901 VDD.n89 VDD.n276 1.07314
R2902 VDD.n87 VDD.n268 1.07314
R2903 VDD.n256 VDD.n85 1.07314
R2904 VDD.n83 VDD.n253 1.07314
R2905 VDD.n951 VDD.n66 1.07196
R2906 VDD.n51 VDD.n50 1.05316
R2907 VDD.t231 VDD.n28 0.751263
R2908 VDD.n45 VDD.n43 1.0386
R2909 VDD.n45 VDD.n16 1.03708
R2910 VDD.n2 VDD.n67 1.0219
R2911 VDD.n74 VDD.n52 1.02023
R2912 VDD.n74 VDD.n99 1.01693
R2913 VDD.n120 VDD.n91 1.01569
R2914 VDD.n56 VDD.n55 1.01498
R2915 VDD.n60 VDD.n59 0.234248
R2916 VDD.n370 VDD.n101 1.00954
R2917 VDD.n56 VDD.n61 1.00949
R2918 VDD.n100 VDD.n90 1.00306
R2919 VDD.n79 VDD.n78 1.00078
R2920 VDD.n94 VDD.n93 0.999744
R2921 VDD.n886 VDD.n90 0.999493
R2922 VDD.n89 VDD.n88 0.993546
R2923 VDD.n87 VDD.n86 0.993546
R2924 VDD.n85 VDD.n84 0.993546
R2925 VDD.n83 VDD.n82 0.993546
R2926 VDD.n45 VDD.n44 0.991784
R2927 VDD.n939 VDD.n73 0.988937
R2928 VDD.n81 VDD.n733 0.852743
R2929 VDD.n97 VDD.n96 0.985187
R2930 VDD.n33 VDD.n32 0.107981
R2931 VDD.n46 VDD.n65 1.11741
R2932 VDD.n10 VDD.n53 1.10191
R2933 VDD.n130 VDD.n26 1.09956
R2934 VDD.n22 VDD.n116 1.09897
R2935 VDD.n32 VDD.n31 1.06925
R2936 VDD.n24 VDD.n124 1.06647
R2937 VDD.n782 VDD.n19 1.05656
R2938 VSS.t854 VSS.n704 8.25944e+06
R2939 VSS.t170 VSS.t476 5.66199e+06
R2940 VSS.n1434 VSS.t814 5.427e+06
R2941 VSS.t885 VSS.n1148 5.16344e+06
R2942 VSS.t0 VSS.n1435 4.779e+06
R2943 VSS.n982 VSS.t1170 3.411e+06
R2944 VSS.n979 VSS.t491 3.267e+06
R2945 VSS.t627 VSS.n831 1.773e+06
R2946 VSS.n1476 VSS.n1475 1.275e+06
R2947 VSS.n1445 VSS.n1444 1.203e+06
R2948 VSS.t94 VSS.n1193 1.0665e+06
R2949 VSS.n850 VSS.n849 555000
R2950 VSS.n942 VSS.t1493 61740.2
R2951 VSS.t277 VSS.t2349 46598.6
R2952 VSS.n921 VSS.n920 43263.2
R2953 VSS.n1229 VSS.t2540 28582.8
R2954 VSS.t1098 VSS.n983 24099.1
R2955 VSS.n780 VSS.n779 22525.7
R2956 VSS.t1161 VSS.n1002 11278
R2957 VSS.n921 VSS.n919 10588.2
R2958 VSS.t1575 VSS.t487 7891.55
R2959 VSS.t2315 VSS.t2204 7839.39
R2960 VSS.t42 VSS.n1487 4136.46
R2961 VSS.t42 VSS.t10 4108.7
R2962 VSS.t10 VSS.t36 4108.7
R2963 VSS.t36 VSS.t14 4108.7
R2964 VSS.t14 VSS.t546 4108.7
R2965 VSS.t546 VSS.t16 4108.7
R2966 VSS.t16 VSS.n531 4108.7
R2967 VSS.t394 VSS.n531 4108.7
R2968 VSS.t394 VSS.t588 4108.7
R2969 VSS.t588 VSS.t140 4108.7
R2970 VSS.t1098 VSS.t140 4108.7
R2971 VSS.n1160 VSS.n1159 4108.7
R2972 VSS.n1160 VSS.n576 4108.7
R2973 VSS.t88 VSS.n576 4108.7
R2974 VSS.n981 VSS.t227 4108.7
R2975 VSS.n978 VSS.n575 4105.98
R2976 VSS.t227 VSS.n980 4105.98
R2977 VSS.n1353 VSS.t2315 3365.31
R2978 VSS.n1351 VSS.t487 3365.31
R2979 VSS.n1434 VSS.t88 3160.33
R2980 VSS.n979 VSS.n978 3160.33
R2981 VSS.n982 VSS.n981 3160.33
R2982 VSS.n1435 VSS.n376 3157.61
R2983 VSS.t591 VSS.n1147 2699.95
R2984 VSS.t2432 VSS.n995 2699.95
R2985 VSS.t2368 VSS.n1179 2316.83
R2986 VSS.n1226 VSS.t2232 1693.82
R2987 VSS.t578 VSS.n1457 1367.54
R2988 VSS.n1294 VSS.t23 1256.24
R2989 VSS.t2349 VSS.t2368 1143.56
R2990 VSS.n376 VSS.n1434 951.087
R2991 VSS.n1435 VSS.n575 951.087
R2992 VSS.n980 VSS.n979 951.087
R2993 VSS.n983 VSS.n982 951.087
R2994 VSS.n1003 VSS.t426 854.015
R2995 VSS.n1351 VSS.t597 747.441
R2996 VSS.n1353 VSS.t2363 747.441
R2997 VSS.n1149 VSS.t108 726.708
R2998 VSS.n1000 VSS.t930 726.708
R2999 VSS.t1082 VSS.t558 556.593
R3000 VSS.n705 VSS.t139 556.593
R3001 VSS.t1545 VSS.t2 123.802
R3002 VSS.t1786 VSS.n248 110.278
R3003 VSS.t1791 VSS.n249 110.284
R3004 VSS.t780 VSS.n275 274.209
R3005 VSS.n147 VSS.t2 0.0148087
R3006 VSS.t1728 VSS.n146 110.284
R3007 VSS.n263 VSS.t1735 109.29
R3008 VSS.n263 VSS.t2 0.00912099
R3009 VSS.t1743 VSS.t2 244.145
R3010 VSS.n409 VSS.t2325 136.673
R3011 VSS.n182 VSS.t1074 428.315
R3012 VSS.n1159 VSS.n483 427.132
R3013 VSS.t1912 VSS.t271 109.993
R3014 VSS.n21 VSS.t1939 15.0018
R3015 VSS.n267 VSS.t253 0.0148802
R3016 VSS.t253 VSS.n34 0.0194314
R3017 VSS.t2387 VSS.n255 397.755
R3018 VSS.t948 VSS.n258 0.0148802
R3019 VSS.t1694 VSS.n259 109.992
R3020 VSS.n103 VSS.n531 427.132
R3021 VSS.t1621 VSS.t242 108.996
R3022 VSS.n224 VSS.t195 424.017
R3023 VSS.n217 VSS.t160 424.017
R3024 VSS.n518 VSS.t849 423.471
R3025 VSS.n124 VSS.t47 423.469
R3026 VSS.t693 VSS.n500 422.846
R3027 VSS.t1600 VSS.n445 422.846
R3028 VSS.t2544 VSS.n442 422.846
R3029 VSS.n41 VSS.t1051 422.846
R3030 VSS.n117 VSS.t141 422.846
R3031 VSS.n115 VSS.t51 422.846
R3032 VSS.n14 VSS.t2478 422.846
R3033 VSS.n1195 VSS.t2258 419.719
R3034 VSS.t317 VSS.n92 419.719
R3035 VSS.t1471 VSS.n158 419.719
R3036 VSS.n110 VSS.t1405 419.185
R3037 VSS.t895 VSS.n520 418.56
R3038 VSS.n223 VSS.t333 415.421
R3039 VSS.t970 VSS.n221 415.421
R3040 VSS.t723 VSS.n93 415.421
R3041 VSS.t1319 VSS.n160 415.421
R3042 VSS.t125 VSS.n160 415.421
R3043 VSS.n177 VSS.t143 415.421
R3044 VSS.n126 VSS.t1519 414.899
R3045 VSS.t2493 VSS.t1575 414.676
R3046 VSS.t2204 VSS.t2328 414.676
R3047 VSS.t811 VSS.n39 414.274
R3048 VSS.n44 VSS.t797 414.274
R3049 VSS.t1076 VSS.n60 414.274
R3050 VSS.t710 VSS.n59 414.274
R3051 VSS.n1427 VSS.t2221 414.274
R3052 VSS.n247 VSS.n376 428.315
R3053 VSS.t1804 VSS.n370 243.5
R3054 VSS.t2261 VSS.n276 54.3887
R3055 VSS.t2565 VSS.n282 28.6008
R3056 VSS.n1153 VSS.n1152 412.608
R3057 VSS.n388 VSS.n575 428.315
R3058 VSS.t1758 VSS.n311 243.5
R3059 VSS.n980 VSS.n408 412.608
R3060 VSS.n274 VSS.t1670 243.5
R3061 VSS.n304 VSS.t1672 243.5
R3062 VSS.t1674 VSS.n283 243.5
R3063 VSS.n983 VSS.n428 412.608
R3064 VSS.t1606 VSS.n298 243.5
R3065 VSS.n54 VSS.t2451 411.526
R3066 VSS.t271 VSS.n1160 427.5
R3067 VSS.t255 VSS.n347 341.418
R3068 VSS.n358 VSS.n576 427.132
R3069 VSS.n296 VSS.t2217 37.1319
R3070 VSS.n978 VSS.n399 427.132
R3071 VSS.n981 VSS.t242 427.5
R3072 VSS.n1364 VSS.t2397 410.613
R3073 VSS.t900 VSS.n1286 408.979
R3074 VSS.n1068 VSS.t2402 408.31
R3075 VSS.n1469 VSS.t2284 408.31
R3076 VSS.n682 VSS.t1552 408.31
R3077 VSS.n1191 VSS.t2500 407.336
R3078 VSS.t683 VSS.n440 407.144
R3079 VSS.n523 VSS.t272 407.144
R3080 VSS.t760 VSS.n1312 407.144
R3081 VSS.n1428 VSS.t1004 407.144
R3082 VSS.t1348 VSS.n736 407.144
R3083 VSS.n1038 VSS.t234 407.144
R3084 VSS.n1046 VSS.t445 407.144
R3085 VSS.n801 VSS.t2269 407.144
R3086 VSS.t1569 VSS.n787 407.144
R3087 VSS.n1465 VSS.t898 404.012
R3088 VSS.t897 VSS.n539 404.012
R3089 VSS.t1439 VSS.n859 404.012
R3090 VSS.t93 VSS.n313 119.835
R3091 VSS.t95 VSS.n1200 399.714
R3092 VSS.n1218 VSS.t277 399.714
R3093 VSS.n1247 VSS.t2486 399.714
R3094 VSS.t2565 VSS.n1069 399.714
R3095 VSS.n1114 VSS.t2459 399.714
R3096 VSS.t2348 VSS.n1088 399.714
R3097 VSS.n1455 VSS.t639 399.714
R3098 VSS.n381 VSS.t497 415.421
R3099 VSS.t1451 VSS.n550 399.714
R3100 VSS.n1459 VSS.t722 399.714
R3101 VSS.t289 VSS.n608 399.406
R3102 VSS.n1242 VSS.t846 398.572
R3103 VSS.n1249 VSS.t748 398.572
R3104 VSS.n1254 VSS.t2492 398.572
R3105 VSS.t2490 VSS.n600 398.572
R3106 VSS.t2314 VSS.n1356 398.572
R3107 VSS.n1345 VSS.t488 398.572
R3108 VSS.t181 VSS.n760 398.572
R3109 VSS.t1362 VSS.n749 398.572
R3110 VSS.t646 VSS.n716 398.572
R3111 VSS.t988 VSS.n1209 398.228
R3112 VSS.n236 VSS.t2274 398.507
R3113 VSS.t1023 VSS.n231 398.228
R3114 VSS.n221 VSS.t119 398.228
R3115 VSS.n96 VSS.t2324 398.228
R3116 VSS.t651 VSS.n176 398.228
R3117 VSS.n200 VSS.t1271 398.228
R3118 VSS.t2420 VSS.n196 398.228
R3119 VSS.n205 VSS.t2422 398.228
R3120 VSS.t2605 VSS.n47 397.755
R3121 VSS.n528 VSS.t2512 397.132
R3122 VSS.t778 VSS.n44 397.132
R3123 VSS.n60 VSS.t2567 397.132
R3124 VSS.n1405 VSS.t699 397.132
R3125 VSS.n1358 VSS.t789 397.132
R3126 VSS.t301 VSS.n1343 397.132
R3127 VSS.n1341 VSS.t543 397.132
R3128 VSS.t1181 VSS.n111 397.132
R3129 VSS.t575 VSS.n108 397.132
R3130 VSS.t1268 VSS.n16 397.132
R3131 VSS.t1415 VSS.n13 397.132
R3132 VSS.t114 VSS.n18 397.132
R3133 VSS.t936 VSS.n193 397.132
R3134 VSS.t350 VSS.n1327 395.834
R3135 VSS.n930 VSS.t2306 395.834
R3136 VSS.t691 VSS.n1202 395.416
R3137 VSS.n1128 VSS.t148 395.416
R3138 VSS.t1512 VSS.n543 395.416
R3139 VSS.n974 VSS.t1468 395.416
R3140 VSS.t692 VSS.n464 394.286
R3141 VSS.n522 VSS.t2616 394.286
R3142 VSS.n1335 VSS.t1598 394.286
R3143 VSS.t2403 VSS.n1154 391.118
R3144 VSS.t2623 VSS.n555 391.118
R3145 VSS.t1228 VSS.n538 391.118
R3146 VSS.t2578 VSS.n678 391.118
R3147 VSS.t2577 VSS.n672 391.118
R3148 VSS.n914 VSS.t1165 391.118
R3149 VSS.n596 VSS.t2217 390
R3150 VSS.n1408 VSS.t1003 390
R3151 VSS.t1242 VSS.n622 390
R3152 VSS.n1024 VSS.t2576 390
R3153 VSS.n1033 VSS.t2581 390
R3154 VSS.t2323 VSS.t1279 390
R3155 VSS.t2583 VSS.n733 390
R3156 VSS.t2584 VSS.n729 390
R3157 VSS.n1041 VSS.t2586 390
R3158 VSS.t44 VSS.n782 390
R3159 VSS.n704 VSS.n176 389.632
R3160 VSS.n1288 VSS.t336 389.122
R3161 VSS.n651 VSS.t246 387.5
R3162 VSS.t249 VSS.t1090 386.82
R3163 VSS.n1453 VSS.t343 386.82
R3164 VSS.n546 VSS.t2326 386.82
R3165 VSS.t2197 VSS.n1176 386.502
R3166 VSS.t882 VSS.n1391 385.714
R3167 VSS.n1372 VSS.t733 385.714
R3168 VSS.t2585 VSS.t1189 385.714
R3169 VSS.t321 VSS.n159 385.334
R3170 VSS.n169 VSS.t1470 385.334
R3171 VSS.n436 VSS.t679 384.274
R3172 VSS.t2293 VSS.n1188 383.334
R3173 VSS.n1298 VSS.t126 383.334
R3174 VSS.n1447 VSS.t908 383.334
R3175 VSS.n857 VSS.t183 383.334
R3176 VSS.n1198 VSS.t484 382.522
R3177 VSS.n1206 VSS.t2568 382.522
R3178 VSS.t526 VSS.n1169 382.522
R3179 VSS.t2401 VSS.n1061 382.522
R3180 VSS.n1077 VSS.t1601 382.522
R3181 VSS.t766 VSS.n1093 382.522
R3182 VSS.t173 VSS.n1087 382.522
R3183 VSS.t822 VSS.n1084 382.522
R3184 VSS.t2256 VSS.t681 382.522
R3185 VSS.t956 VSS.n550 382.522
R3186 VSS.t1336 VSS.n541 382.522
R3187 VSS.t1352 VSS.n537 382.522
R3188 VSS.t608 VSS.n945 382.522
R3189 VSS.t652 VSS.n679 382.522
R3190 VSS.n934 VSS.t383 382.522
R3191 VSS.t1426 VSS.n841 382.522
R3192 VSS.n869 VSS.t116 382.522
R3193 VSS.t852 VSS.n900 382.522
R3194 VSS.n911 VSS.t2471 382.522
R3195 VSS.t2469 VSS.n884 382.522
R3196 VSS.n1253 VSS.t1002 381.43
R3197 VSS.n1385 VSS.t876 381.43
R3198 VSS.t2531 VSS.n1382 381.43
R3199 VSS.t1244 VSS.n620 381.43
R3200 VSS.n1012 VSS.t1318 381.43
R3201 VSS.t1233 VSS.n735 381.43
R3202 VSS.t1234 VSS.n732 381.43
R3203 VSS.t446 VSS.n721 381.43
R3204 VSS.n797 VSS.t1250 381.43
R3205 VSS.t2268 VSS.n792 381.43
R3206 VSS.n1323 VSS.t994 380.568
R3207 VSS.t2498 VSS.n463 379.99
R3208 VSS.t2484 VSS.n36 379.99
R3209 VSS.n1409 VSS.t2485 379.99
R3210 VSS.t401 VSS.n115 379.99
R3211 VSS.n140 VSS.t705 378.385
R3212 VSS.n82 VSS.t1009 378.384
R3213 VSS.t688 VSS.n1208 378.224
R3214 VSS.n973 VSS.t2285 378.224
R3215 VSS.t322 VSS.n951 378.224
R3216 VSS.n225 VSS.t606 377.36
R3217 VSS.n130 VSS.t1500 377.351
R3218 VSS.t2341 VSS.n38 376.724
R3219 VSS.t829 VSS.n54 376.724
R3220 VSS.n1276 VSS.t252 376.724
R3221 VSS.n1139 VSS.t2384 376.724
R3222 VSS.n987 VSS.t2620 376.724
R3223 VSS.t2261 VSS.n1057 373.926
R3224 VSS.n1066 VSS.t1057 373.926
R3225 VSS.t1593 VSS.n1106 373.926
R3226 VSS.n1113 VSS.t102 373.926
R3227 VSS.n1127 VSS.t1571 373.926
R3228 VSS.t2316 VSS.n569 373.926
R3229 VSS.t1310 VSS.n677 373.926
R3230 VSS.t976 VSS.n673 373.926
R3231 VSS.n671 VSS.t198 373.926
R3232 VSS.n690 VSS.t1554 373.926
R3233 VSS.n692 VSS.t1447 373.926
R3234 VSS.n694 VSS.t1460 373.926
R3235 VSS.n696 VSS.t2219 373.926
R3236 VSS.t1386 VSS.n698 373.926
R3237 VSS.t330 VSS.n661 373.926
R3238 VSS.t1249 VSS.n702 373.926
R3239 VSS.t1062 VSS.n899 373.926
R3240 VSS.n905 VSS.t995 373.926
R3241 VSS.t574 VSS.n896 373.926
R3242 VSS.t891 VSS.n443 372.858
R3243 VSS.t2358 VSS.n441 372.858
R3244 VSS.t2339 VSS.n524 372.858
R3245 VSS.t298 VSS.n1310 372.858
R3246 VSS.n633 VSS.t644 372.858
R3247 VSS.n143 VSS.t1339 46.0421
R3248 VSS.n1027 VSS.t1455 372.858
R3249 VSS.n1034 VSS.t643 372.858
R3250 VSS.n1035 VSS.t1518 372.858
R3251 VSS.n1030 VSS.t1516 370.834
R3252 VSS.t2226 VSS.n1201 369.628
R3253 VSS.t1070 VSS.n1089 369.628
R3254 VSS.t1324 VSS.t171 369.628
R3255 VSS.n699 VSS.t1071 369.628
R3256 VSS.t1442 VSS.n997 369.628
R3257 VSS.t1332 VSS.n439 368.572
R3258 VSS.n1336 VSS.t1225 368.572
R3259 VSS.n1037 VSS.t133 368.572
R3260 VSS.t771 VSS.n1199 368.142
R3261 VSS.n1215 VSS.t275 368.142
R3262 VSS.t607 VSS.n228 368.142
R3263 VSS.n1290 VSS.t1182 367.92
R3264 VSS.n138 VSS.t704 367.137
R3265 VSS.t828 VSS.n52 367.135
R3266 VSS.n858 VSS.t1314 366.214
R3267 VSS.n1073 VSS.t2404 365.329
R3268 VSS.t1089 VSS.n1098 365.329
R3269 VSS.n1468 VSS.t517 365.329
R3270 VSS.n1470 VSS.t522 365.329
R3271 VSS.n683 VSS.t1474 365.329
R3272 VSS.n689 VSS.t459 365.329
R3273 VSS.t137 VSS.t1487 365.329
R3274 VSS.t127 VSS.t1464 365.329
R3275 VSS.t785 VSS.n655 365.329
R3276 VSS.n845 VSS.t1429 365.329
R3277 VSS.t655 VSS.n90 364.466
R3278 VSS.n1263 VSS.t758 364.286
R3279 VSS.n627 VSS.t1241 364.286
R3280 VSS.t510 VSS.n737 364.286
R3281 VSS.n1040 VSS.t507 364.286
R3282 VSS.n1044 VSS.t443 364.286
R3283 VSS.n19 VSS.t57 375.942
R3284 VSS.t992 VSS.n1360 362.846
R3285 VSS.t1445 VSS.n773 362.07
R3286 VSS.t274 VSS.n529 361.033
R3287 VSS.t770 VSS.n29 366.932
R3288 VSS.t2539 VSS.n1223 361.033
R3289 VSS.n1171 VSS.t1588 361.033
R3290 VSS.n1322 VSS.t903 361.033
R3291 VSS.n1077 VSS.t815 361.033
R3292 VSS.n1078 VSS.t2563 361.033
R3293 VSS.t1091 VSS.t551 361.033
R3294 VSS.t1465 VSS.t1092 361.033
R3295 VSS.t1 VSS.n574 361.033
R3296 VSS.t496 VSS.n1452 361.033
R3297 VSS.n549 VSS.t721 361.033
R3298 VSS.n1460 VSS.t971 361.033
R3299 VSS.t964 VSS.n537 361.033
R3300 VSS.n625 VSS.t1364 361.033
R3301 VSS.n656 VSS.t2632 361.033
R3302 VSS.t1114 VSS.n932 361.033
R3303 VSS.t727 VSS.t627 361.033
R3304 VSS.t628 VSS.n842 361.033
R3305 VSS.t1018 VSS.n858 361.033
R3306 VSS.n868 VSS.t241 361.033
R3307 VSS.n910 VSS.t1302 361.033
R3308 VSS.t1166 VSS.n885 361.033
R3309 VSS.t2431 VSS.n996 361.033
R3310 VSS.t2448 VSS.n1390 360
R3311 VSS.n1373 VSS.t486 360
R3312 VSS.t529 VSS.n1236 356.735
R3313 VSS.t1105 VSS.t879 356.735
R3314 VSS.n1117 VSS.t85 356.735
R3315 VSS.t1093 VSS.n1096 356.735
R3316 VSS.n565 VSS.t2626 356.735
R3317 VSS.n963 VSS.t2287 356.735
R3318 VSS.n697 VSS.t981 356.735
R3319 VSS.t1541 VSS.t2299 356.735
R3320 VSS.t1425 VSS.n840 356.735
R3321 VSS.t290 VSS.n471 355.714
R3322 VSS.t2335 VSS.n589 355.714
R3323 VSS.n1369 VSS.t973 355.714
R3324 VSS.n630 VSS.t1245 355.714
R3325 VSS.n1023 VSS.t986 355.714
R3326 VSS.t980 VSS.n750 355.714
R3327 VSS.n1025 VSS.t77 355.714
R3328 VSS.t982 VSS.n748 355.714
R3329 VSS.n800 VSS.t2267 355.714
R3330 VSS.t993 VSS.n1302 354.168
R3331 VSS.n1292 VSS.t2374 352.437
R3332 VSS.n1151 VSS.t739 352.437
R3333 VSS.n1116 VSS.t800 352.437
R3334 VSS.t3 VSS.n572 352.437
R3335 VSS.t157 VSS.n380 366.63
R3336 VSS.t110 VSS.n1450 352.437
R3337 VSS.t1331 VSS.n954 352.437
R3338 VSS.n820 VSS.t1286 352.437
R3339 VSS.n1161 VSS.t2452 351.43
R3340 VSS.t2394 VSS.n1241 351.43
R3341 VSS.t2342 VSS.n608 351.43
R3342 VSS.n1252 VSS.t810 351.43
R3343 VSS.t98 VSS.n1311 351.43
R3344 VSS.t2231 VSS.n1406 351.43
R3345 VSS.t877 VSS.n1362 351.43
R3346 VSS.t1524 VSS.n738 351.43
R3347 VSS.t1333 VSS.n719 351.43
R3348 VSS.t1107 VSS.n941 351.43
R3349 VSS.t2429 VSS.n877 351.43
R3350 VSS.t244 VSS.n646 350
R3351 VSS.n1204 VSS.t818 348.139
R3352 VSS.n25 VSS.t884 86.3386
R3353 VSS.n1081 VSS.t844 348.139
R3354 VSS.n1442 VSS.t73 348.139
R3355 VSS.t1514 VSS.n1449 348.139
R3356 VSS.n1458 VSS.t1073 348.139
R3357 VSS.t965 VSS.t1190 348.139
R3358 VSS.t1543 VSS.n956 348.139
R3359 VSS.t1151 VSS.n823 348.139
R3360 VSS.t112 VSS.n815 348.139
R3361 VSS.n1164 VSS.t2209 347.144
R3362 VSS.n1251 VSS.t2505 347.144
R3363 VSS.n1309 VSS.t883 347.144
R3364 VSS.n1418 VSS.t2388 347.144
R3365 VSS.t2347 VSS.n1379 347.144
R3366 VSS.t892 VSS.n1342 347.144
R3367 VSS.t769 VSS.n621 347.144
R3368 VSS.t1322 VSS.n758 347.144
R3369 VSS.t1191 VSS.n717 347.144
R3370 VSS.t611 VSS.n223 346.652
R3371 VSS.t1188 VSS.n116 346.327
R3372 VSS.t352 VSS.n1325 345.834
R3373 VSS.n472 VSS.t2487 345.704
R3374 VSS.t1340 VSS.n123 345.704
R3375 VSS.n127 VSS.t415 345.704
R3376 VSS.n779 VSS.n777 343.75
R3377 VSS.n1289 VSS.t2345 343.096
R3378 VSS.t2501 VSS.n229 342.976
R3379 VSS.t294 VSS.t2215 342.858
R3380 VSS.t1320 VSS.t1185 342.858
R3381 VSS.n1212 VSS.t278 342.354
R3382 VSS.n150 VSS.t2229 342.976
R3383 VSS.n196 VSS.t1301 342.354
R3384 VSS.n136 VSS.t337 342.041
R3385 VSS.n1281 VSS.t2343 341.668
R3386 VSS.n1144 VSS.t886 341.668
R3387 VSS.t1239 VSS.n852 341.668
R3388 VSS.n992 VSS.t1032 341.668
R3389 VSS.t2212 VSS.n50 341.418
R3390 VSS.t2483 VSS.n1405 341.418
R3391 VSS.n111 VSS.t372 341.418
R3392 VSS.t1264 VSS.n940 341.418
R3393 VSS.n193 VSS.t2425 341.418
R3394 VSS.n1180 VSS.t921 339.543
R3395 VSS.n28 VSS.t559 350.685
R3396 VSS.t377 VSS.n24 350.685
R3397 VSS.t2214 VSS.n1056 339.543
R3398 VSS.n1074 VSS.t2405 339.543
R3399 VSS.t361 VSS.n1071 339.543
R3400 VSS.n1076 VSS.t2481 339.543
R3401 VSS.t2527 VSS.n1107 339.543
R3402 VSS.n1119 VSS.t1088 339.543
R3403 VSS.t666 VSS.n1095 339.543
R3404 VSS.t2259 VSS.n1094 339.543
R3405 VSS.n1131 VSS.t560 339.543
R3406 VSS.t2494 VSS.n1086 339.543
R3407 VSS.t555 VSS.n1085 339.543
R3408 VSS.t2621 VSS.n556 339.543
R3409 VSS.n1467 VSS.t2205 339.543
R3410 VSS.n1474 VSS.t1045 339.543
R3411 VSS.t1560 VSS.n961 339.543
R3412 VSS.n277 VSS.t2249 68.0817
R3413 VSS.t1309 VSS.n971 339.543
R3414 VSS.t1548 VSS.n680 339.543
R3415 VSS.t635 VSS.n664 339.543
R3416 VSS.n818 VSS.t1476 339.543
R3417 VSS.t2236 VSS.n834 339.543
R3418 VSS.t1431 VSS.n836 339.543
R3419 VSS.t1305 VSS.n895 339.543
R3420 VSS.n909 VSS.t368 339.543
R3421 VSS.n915 VSS.t1298 339.543
R3422 VSS.t2466 VSS.n886 339.543
R3423 VSS.t686 VSS.n1285 338.913
R3424 VSS.n1250 VSS.t2263 338.572
R3425 VSS.t1028 VSS.n1313 338.572
R3426 VSS.t2260 VSS.n1307 338.572
R3427 VSS.n1415 VSS.t1084 338.572
R3428 VSS.n1429 VSS.t743 338.572
R3429 VSS.t2201 VSS.n1386 338.572
R3430 VSS.n1381 VSS.t440 338.572
R3431 VSS.t2385 VSS.n1370 338.572
R3432 VSS.n1337 VSS.t2560 338.572
R3433 VSS.t1240 VSS.n623 338.572
R3434 VSS.n1010 VSS.t1355 338.572
R3435 VSS.n1011 VSS.t1323 338.572
R3436 VSS.t1311 VSS.n765 338.572
R3437 VSS.n1028 VSS.t1224 338.572
R3438 VSS.t1420 VSS.n728 338.572
R3439 VSS.t442 VSS.n725 338.572
R3440 VSS.t1393 VSS.n795 338.572
R3441 VSS.t2272 VSS.n789 338.572
R3442 VSS.t184 VSS.n783 338.572
R3443 VSS.n158 VSS.t45 338.057
R3444 VSS.n1459 VSS.t1452 335.245
R3445 VSS.t1349 VSS.n547 335.245
R3446 VSS.t1024 VSS.t221 335.245
R3447 VSS.t617 VSS.n676 335.245
R3448 VSS.t746 VSS.n603 334.286
R3449 VSS.n1258 VSS.t2489 334.286
R3450 VSS.t687 VSS.n597 334.286
R3451 VSS.t772 VSS.n591 334.286
R3452 VSS.t2211 VSS.n1422 334.286
R3453 VSS.t1235 VSS.t509 334.286
R3454 VSS.n195 VSS.t1276 332.336
R3455 VSS.n214 VSS.t2523 332.336
R3456 VSS.t528 VSS.n1235 330.947
R3457 VSS.t2399 VSS.n1062 330.947
R3458 VSS.t548 VSS.n1104 330.947
R3459 VSS.n1122 VSS.t1094 330.947
R3460 VSS.n1130 VSS.t888 330.947
R3461 VSS.n272 VSS.t1226 72.7372
R3462 VSS.n570 VSS.t950 330.947
R3463 VSS.t939 VSS.n559 330.947
R3464 VSS.t2627 VSS.n553 330.947
R3465 VSS.t1497 VSS.n962 330.947
R3466 VSS.n966 VSS.t2631 330.947
R3467 VSS.t469 VSS.n957 330.947
R3468 VSS.n693 VSS.t1510 330.947
R3469 VSS.t1069 VSS.n662 330.947
R3470 VSS.n701 VSS.t1421 330.947
R3471 VSS.n825 VSS.t916 330.947
R3472 VSS.t1424 VSS.n839 330.947
R3473 VSS.t250 VSS.n594 330
R3474 VSS.n1315 VSS.t1467 330
R3475 VSS.n1424 VSS.t2352 330
R3476 VSS.n1388 VSS.t2376 330
R3477 VSS.n1365 VSS.t2449 330
R3478 VSS.t1462 VSS.n768 330
R3479 VSS.n1014 VSS.t998 330
R3480 VSS.n1017 VSS.t2416 330
R3481 VSS.t297 VSS.n756 330
R3482 VSS.n1020 VSS.t1289 330
R3483 VSS.t1411 VSS.n753 330
R3484 VSS.t448 VSS.n720 330
R3485 VSS.t2419 VSS.n939 330
R3486 VSS.t466 VSS.n937 330
R3487 VSS.t2266 VSS.n793 330
R3488 VSS.n802 VSS.t63 330
R3489 VSS.n95 VSS.t999 329.461
R3490 VSS.t968 VSS.n177 329.461
R3491 VSS.t360 VSS.n178 329.461
R3492 VSS.t238 VSS.n179 329.461
R3493 VSS.t467 VSS.n200 329.461
R3494 VSS.n525 VSS.t2545 329.183
R3495 VSS.t787 VSS.n110 329.183
R3496 VSS.n1192 VSS.t2195 329.168
R3497 VSS.n1178 VSS.t890 329.168
R3498 VSS.t694 VSS.n1174 329.168
R3499 VSS.n1283 VSS.t1573 329.168
R3500 VSS.n1329 VSS.t732 329.168
R3501 VSS.n1146 VSS.t823 329.168
R3502 VSS.t1407 VSS.n568 329.168
R3503 VSS.n652 VSS.t857 329.168
R3504 VSS.t90 VSS.n26 66.199
R3505 VSS.n867 VSS.t1287 329.168
R3506 VSS.t1294 VSS.n876 329.168
R3507 VSS.n994 VSS.t1391 329.168
R3508 VSS.n924 VSS.t2435 328.714
R3509 VSS.n520 VSS.t1406 328.56
R3510 VSS.n634 VSS.t2461 328.56
R3511 VSS.t203 VSS.n128 328.56
R3512 VSS.t603 VSS.t2493 327.646
R3513 VSS.t2328 VSS.t2360 327.646
R3514 VSS.n1152 VSS.t2507 326.649
R3515 VSS.t614 VSS.t904 326.649
R3516 VSS.n969 VSS.t794 326.649
R3517 VSS.t1513 VSS.t506 326.649
R3518 VSS.n821 VSS.t1153 326.649
R3519 VSS.t2446 VSS.n1361 325.714
R3520 VSS.n1340 VSS.t842 325.714
R3521 VSS.t178 VSS.n98 321.486
R3522 VSS.t2491 VSS.t911 321.43
R3523 VSS.n1182 VSS.t2594 320.865
R3524 VSS.n240 VSS.t2398 320.865
R3525 VSS.n226 VSS.t363 320.865
R3526 VSS.t1095 VSS.n231 320.865
R3527 VSS.n217 VSS.t2564 320.865
R3528 VSS.t1423 VSS.n838 320.865
R3529 VSS.t1117 VSS.n202 320.865
R3530 VSS.n135 VSS.t449 320.613
R3531 VSS.t177 VSS.n533 320.271
R3532 VSS.n1007 VSS.t175 320.271
R3533 VSS.n1048 VSS.t676 320.271
R3534 VSS.t1054 VSS.n528 319.99
R3535 VSS.t1230 VSS.n634 319.99
R3536 VSS.t2282 VSS.t1288 318.053
R3537 VSS.t511 VSS.t508 317.144
R3538 VSS.t444 VSS.t1398 317.144
R3539 VSS.t712 VSS.n1231 316.668
R3540 VSS.n1282 VSS.t2297 316.668
R3541 VSS.n1145 VSS.t2445 316.668
R3542 VSS.t1454 VSS.n851 316.668
R3543 VSS.n993 VSS.t2427 316.668
R3544 VSS.t527 VSS.n1234 316.099
R3545 VSS.n1059 VSS.t2317 313.755
R3546 VSS.t2392 VSS.n1065 313.755
R3547 VSS.t1025 VSS.n1072 313.755
R3548 VSS.n1111 VSS.t1478 313.755
R3549 VSS.t874 VSS.n1099 313.755
R3550 VSS.n562 VSS.t716 313.755
R3551 VSS.t311 VSS.n408 313.755
R3552 VSS.n975 VSS.t323 313.755
R3553 VSS.n683 VSS.t1104 313.755
R3554 VSS.n687 VSS.t1568 313.755
R3555 VSS.n689 VSS.t1115 313.755
R3556 VSS.t2307 VSS.n670 313.755
R3557 VSS.t1106 VSS.n668 313.755
R3558 VSS.t2319 VSS.n662 313.755
R3559 VSS.t924 VSS.n659 313.755
R3560 VSS.t697 VSS.n428 313.755
R3561 VSS.n904 VSS.t996 313.755
R3562 VSS.n907 VSS.t465 313.755
R3563 VSS.n519 VSS.t2367 312.858
R3564 VSS.n523 VSS.t2366 312.858
R3565 VSS.t561 VSS.n438 312.858
R3566 VSS.n1332 VSS.t1385 312.858
R3567 VSS.n626 VSS.t2613 312.858
R3568 VSS.n804 VSS.t1374 312.858
R3569 VSS.t524 VSS.t1142 312.5
R3570 VSS.n55 VSS.t2234 311.502
R3571 VSS.t302 VSS.n56 311.502
R3572 VSS.t292 VSS.n1183 309.457
R3573 VSS.t2625 VSS.t219 309.457
R3574 VSS.t2618 VSS.t1046 309.457
R3575 VSS.n685 VSS.t2250 309.457
R3576 VSS.n1259 VSS.t2496 308.572
R3577 VSS.t860 VSS.n599 308.572
R3578 VSS.n1268 VSS.t972 308.572
R3579 VSS.t386 VSS.n1421 308.572
R3580 VSS.n102 VSS.t1562 291.829
R3581 VSS.n1488 VSS.t193 305.159
R3582 VSS.t138 VSS.n1184 305.159
R3583 VSS.t1041 VSS.n1219 305.159
R3584 VSS.t416 VSS.n1225 305.159
R3585 VSS.t285 VSS.n1238 305.159
R3586 VSS.n1168 VSS.t258 305.159
R3587 VSS.n1320 VSS.t341 305.159
R3588 VSS.n1136 VSS.t75 305.159
R3589 VSS.n311 VSS.t664 320.865
R3590 VSS.n1465 VSS.t2541 305.159
R3591 VSS.t66 VSS.n644 305.159
R3592 VSS.t376 VSS.n962 305.159
R3593 VSS.t2292 VSS.t492 305.159
R3594 VSS.t144 VSS.n660 305.159
R3595 VSS.t432 VSS.n654 305.159
R3596 VSS.t835 VSS.n935 305.159
R3597 VSS.n831 VSS.n830 305.159
R3598 VSS.n814 VSS.t1413 305.159
R3599 VSS.n863 VSS.t118 305.159
R3600 VSS.n914 VSS.t2421 305.159
R3601 VSS.n874 VSS.t914 305.159
R3602 VSS.t1103 VSS.n999 305.159
R3603 VSS.n278 VSS.t2538 319.99
R3604 VSS.n1256 VSS.t84 304.286
R3605 VSS.t974 VSS.n592 304.286
R3606 VSS.t767 VSS.n1376 304.286
R3607 VSS.n1331 VSS.t2354 304.286
R3608 VSS.t809 VSS.n769 304.286
R3609 VSS.n1022 VSS.t2575 304.286
R3610 VSS.t346 VSS.n745 304.286
R3611 VSS.n19 VSS.t1263 84.0258
R3612 VSS.n1456 VSS.t979 304.168
R3613 VSS.n76 VSS.t615 303.673
R3614 VSS.t2378 VSS.n1207 300.861
R3615 VSS.t2628 VSS.t632 300.861
R3616 VSS.t1029 VSS.t1450 300.861
R3617 VSS.t734 VSS.t621 300.861
R3618 VSS.t573 VSS.t616 300.861
R3619 VSS.t2614 VSS.n952 300.861
R3620 VSS.t658 VSS.t2608 300.861
R3621 VSS.t1269 VSS.t399 300.861
R3622 VSS.t752 VSS.t2557 300
R3623 VSS.n1410 VSS.t1033 300
R3624 VSS.t1043 VSS.n1395 300
R3625 VSS.n919 VSS.t2513 300
R3626 VSS.n1002 VSS.t104 300
R3627 VSS.t2330 VSS.n1392 299.185
R3628 VSS.n59 VSS.t2450 298.56
R3629 VSS.n1413 VSS.t288 298.56
R3630 VSS.t1435 VSS.t1316 296.562
R3631 VSS.t1167 VSS.t2290 296.562
R3632 VSS.t701 VSS.t843 295.714
R3633 VSS.t1085 VSS.n28 89.5753
R3634 VSS.t2382 VSS.n1205 292.264
R3635 VSS.n1213 VSS.t934 292.264
R3636 VSS.n24 VSS.t909 89.5749
R3637 VSS.n1348 VSS.t544 292.264
R3638 VSS.n1126 VSS.t738 292.264
R3639 VSS.n1131 VSS.t1586 292.264
R3640 VSS.t2456 VSS.n1086 292.264
R3641 VSS.t450 VSS.n1085 292.264
R3642 VSS.t784 VSS.n1137 292.264
R3643 VSS.n564 VSS.t315 292.264
R3644 VSS.t513 VSS.n544 292.264
R3645 VSS.t2325 VSS.n948 292.264
R3646 VSS.n277 VSS.t718 305.207
R3647 VSS.n971 VSS.t123 292.264
R3648 VSS.t1418 VSS.t439 292.264
R3649 VSS.t659 VSS.n818 292.264
R3650 VSS.n836 VSS.t725 292.264
R3651 VSS.t696 VSS.n903 292.264
R3652 VSS.n907 VSS.t1119 292.264
R3653 VSS.n909 VSS.t2465 292.264
R3654 VSS.t2470 VSS.n892 292.264
R3655 VSS.n913 VSS.t2418 292.264
R3656 VSS.t2533 VSS.n886 292.264
R3657 VSS.t1564 VSS.n138 291.57
R3658 VSS.n526 VSS.t452 291.43
R3659 VSS.n1250 VSS.t2525 291.43
R3660 VSS.n1255 VSS.t2350 291.43
R3661 VSS.t2580 VSS.t2332 291.43
R3662 VSS.t335 VSS.n590 291.43
R3663 VSS.n1313 VSS.t768 291.43
R3664 VSS.t2417 VSS.n1401 291.43
R3665 VSS.t776 VSS.n1419 291.43
R3666 VSS.t2556 VSS.n1429 291.43
R3667 VSS.n1386 VSS.t568 291.43
R3668 VSS.t2561 VSS.n1381 291.43
R3669 VSS.n1370 VSS.t2373 291.43
R3670 VSS.t1585 VSS.n1337 291.43
R3671 VSS.n1010 VSS.t1344 291.43
R3672 VSS.n1011 VSS.t954 291.43
R3673 VSS.t1306 VSS.n765 291.43
R3674 VSS.n1018 VSS.t2286 291.43
R3675 VSS.n1028 VSS.t1248 291.43
R3676 VSS.t2629 VSS.n741 291.43
R3677 VSS.t1227 VSS.n727 291.43
R3678 VSS.n1045 VSS.t186 291.43
R3679 VSS.t1392 VSS.n795 291.43
R3680 VSS.n807 VSS.t1253 291.43
R3681 VSS.t1356 VSS.n785 291.43
R3682 VSS.t1157 VSS.n879 291.43
R3683 VSS.n928 VSS.t1295 291.43
R3684 VSS.n1199 VSS.t945 290.779
R3685 VSS.t942 VSS.n1215 290.779
R3686 VSS.t944 VSS.n228 290.779
R3687 VSS.t2474 VSS.n197 290.779
R3688 VSS.n207 VSS.t2473 290.779
R3689 VSS.n1400 VSS.t2548 290.777
R3690 VSS.t1036 VSS.n1346 290.777
R3691 VSS.t673 VSS.n112 290.777
R3692 VSS.t2477 VSS.n194 290.777
R3693 VSS.t724 VSS.t1576 287.966
R3694 VSS.n1112 VSS.t1341 287.966
R3695 VSS.n1118 VSS.t873 287.966
R3696 VSS.t429 VSS.n1129 287.966
R3697 VSS.t662 VSS.n574 287.966
R3698 VSS.t715 VSS.n557 287.966
R3699 VSS.t2612 VSS.n624 287.966
R3700 VSS.n967 VSS.t1005 287.966
R3701 VSS.t584 VSS.n955 287.966
R3702 VSS.n970 VSS.t2514 287.966
R3703 VSS.n691 VSS.t1396 287.966
R3704 VSS.t389 VSS.n667 287.966
R3705 VSS.n826 VSS.t379 287.966
R3706 VSS.n848 VSS.t2609 287.966
R3707 VSS.t179 VSS.t1313 287.966
R3708 VSS.n506 VSS.t2590 287.144
R3709 VSS.n1265 VSS.t2223 287.144
R3710 VSS.n1269 VSS.t689 287.144
R3711 VSS.n1316 VSS.t875 287.144
R3712 VSS.n1389 VSS.t749 287.144
R3713 VSS.n1009 VSS.t1187 287.144
R3714 VSS.n1013 VSS.t1338 287.144
R3715 VSS.t1480 VSS.n762 287.144
R3716 VSS.n1016 VSS.t1531 287.144
R3717 VSS.n1019 VSS.t1358 287.144
R3718 VSS.t1186 VSS.n754 287.144
R3719 VSS.t1381 VSS.n726 287.144
R3720 VSS.t1148 VSS.n936 287.144
R3721 VSS.t1529 VSS.n790 287.144
R3722 VSS.t1375 VSS.n788 287.144
R3723 VSS.t185 VSS.t1547 287.144
R3724 VSS.t318 VSS.t147 283.668
R3725 VSS.t491 VSS.n977 283.668
R3726 VSS.t470 VSS.n675 283.668
R3727 VSS.n1277 VSS.t731 283.334
R3728 VSS.t580 VSS.n710 283.334
R3729 VSS.n988 VSS.t1417 283.334
R3730 VSS.n1300 VSS.t30 283.019
R3731 VSS.t2365 VSS.n1300 283.019
R3732 VSS.t2407 VSS.n602 282.858
R3733 VSS.t2497 VSS.n598 282.858
R3734 VSS.t1022 VSS.n1375 282.858
R3735 VSS.t1404 VSS.t1232 282.858
R3736 VSS.t2634 VSS.t1382 282.858
R3737 VSS.t657 VSS.n558 279.37
R3738 VSS.t708 VSS.n558 279.37
R3739 VSS.n700 VSS.t1266 279.37
R3740 VSS.t629 VSS.t1430 279.37
R3741 VSS.t2463 VSS.t1303 279.37
R3742 VSS.t1299 VSS.t2438 279.37
R3743 VSS.n638 VSS.t1326 279.168
R3744 VSS.t1047 VSS.n593 278.572
R3745 VSS.t1060 VSS.t2572 278.572
R3746 VSS.t365 VSS.t259 278.572
R3747 VSS.t656 VSS.n1374 278.572
R3748 VSS.n1374 VSS.t612 278.572
R3749 VSS.t1402 VSS.t1384 278.572
R3750 VSS.t53 VSS.n752 278.572
R3751 VSS.t436 VSS.t1501 278.572
R3752 VSS.n806 VSS.t1546 278.572
R3753 VSS.n806 VSS.t55 278.572
R3754 VSS.t1163 VSS.t2278 278.572
R3755 VSS.t2476 VSS.n774 275.863
R3756 VSS.n1488 VSS.t268 275.072
R3757 VSS.t2591 VSS.n1206 275.072
R3758 VSS.n1225 VSS.t1039 275.072
R3759 VSS.t270 VSS.n1168 275.072
R3760 VSS.n1248 VSS.t2552 275.072
R3761 VSS.t267 VSS.n1290 275.072
R3762 VSS.t262 VSS.n1273 275.072
R3763 VSS.t286 VSS.t667 275.072
R3764 VSS.n1399 VSS.t387 275.072
R3765 VSS.t263 VSS.n1320 275.072
R3766 VSS.t2550 VSS.n1070 275.072
R3767 VSS.t287 VSS.t817 275.072
R3768 VSS.n1125 VSS.t610 275.072
R3769 VSS.n1440 VSS.t2254 275.072
R3770 VSS.t218 VSS.n571 275.072
R3771 VSS.n1462 VSS.t430 275.072
R3772 VSS.n644 VSS.t2551 275.072
R3773 VSS.t2549 VSS.n958 275.072
R3774 VSS.n972 VSS.t1337 275.072
R3775 VSS.n714 VSS.t1565 275.072
R3776 VSS.n935 VSS.t2472 275.072
R3777 VSS.n830 VSS.t671 275.072
R3778 VSS.n844 VSS.t669 275.072
R3779 VSS.n861 VSS.t2300 275.072
R3780 VSS.t2298 VSS.n863 275.072
R3781 VSS.t670 VSS.n874 275.072
R3782 VSS.t2303 VSS.n984 275.072
R3783 VSS.t1488 VSS.t1055 275.072
R3784 VSS.t2606 VSS.t796 274.286
R3785 VSS.t808 VSS.t397 274.286
R3786 VSS.t271 VSS.t2600 274.209
R3787 VSS.t1270 VSS.n199 274.209
R3788 VSS.t803 VSS.n29 95.1438
R3789 VSS.t2199 VSS.n244 274.207
R3790 VSS.t557 VSS.n232 274.207
R3791 VSS.t2464 VSS.n198 274.207
R3792 VSS.n206 VSS.t2532 274.207
R3793 VSS.t2248 VSS.n642 274.2
R3794 VSS.n212 VSS.t804 274.2
R3795 VSS.t2227 VSS.n1182 273.587
R3796 VSS.n93 VSS.t2413 273.587
R3797 VSS.t1044 VSS.n163 273.587
R3798 VSS.n178 VSS.t2318 273.587
R3799 VSS.n52 VSS.t1042 273.586
R3800 VSS.t987 VSS.n63 273.471
R3801 VSS.t1297 VSS.n192 273.471
R3802 VSS.t1097 VSS.t242 273.469
R3803 VSS.n1346 VSS.t82 272.849
R3804 VSS.t2515 VSS.n40 272.846
R3805 VSS.t2379 VSS.n62 272.846
R3806 VSS.t826 VSS.n1413 272.846
R3807 VSS.t570 VSS.n1431 272.846
R3808 VSS.n1368 VSS.t525 272.846
R3809 VSS.n108 VSS.t703 272.846
R3810 VSS.n18 VSS.t65 272.846
R3811 VSS.t2264 VSS.t170 270.774
R3812 VSS.t2232 VSS.t2540 269.663
R3813 VSS.t355 VSS.t719 266.668
R3814 VSS.t2509 VSS.t1198 266.476
R3815 VSS.t728 VSS.t1221 266.476
R3816 VSS.t2371 VSS.t280 266.476
R3817 VSS.t2370 VSS.t1579 266.476
R3818 VSS.t1196 VSS.t2506 266.476
R3819 VSS.t1213 VSS.t2312 266.476
R3820 VSS.t764 VSS.t2601 266.476
R3821 VSS.t1216 VSS.t957 266.476
R3822 VSS.t1212 VSS.t801 266.476
R3823 VSS.t1363 VSS.t594 266.476
R3824 VSS.t592 VSS.t404 266.476
R3825 VSS.t1120 VSS.t1308 266.476
R3826 VSS.t793 VSS.t1146 266.476
R3827 VSS.t1139 VSS.t1152 266.476
R3828 VSS.t966 VSS.t933 266.476
R3829 VSS.t925 VSS.t1453 266.476
R3830 VSS.t1128 VSS.t1304 266.476
R3831 VSS.t1300 VSS.t1131 266.476
R3832 VSS.t1168 VSS.t1126 266.476
R3833 VSS.t1203 VSS.t257 265.714
R3834 VSS.t1217 VSS.t700 265.714
R3835 VSS.t2482 VSS.t1197 265.714
R3836 VSS.t2447 VSS.t2362 265.714
R3837 VSS.t604 VSS.t841 265.714
R3838 VSS.t212 VSS.t869 265.714
R3839 VSS.t371 VSS.t923 265.714
R3840 VSS.t338 VSS.t862 265.714
R3841 VSS.t2424 VSS.t1272 265.714
R3842 VSS.t1158 VSS.t2433 265.714
R3843 VSS.t556 VSS.n1139 265.692
R3844 VSS.t872 VSS.n1100 262.178
R3845 VSS.n561 VSS.t714 262.178
R3846 VSS.t913 VSS.t1580 261.43
R3847 VSS.n1334 VSS.t1383 261.43
R3848 VSS.t1457 VSS.t1236 261.43
R3849 VSS.n805 VSS.t1376 261.43
R3850 VSS.t834 VSS.n162 261.315
R3851 VSS.n172 VSS.t836 260.692
R3852 VSS.t2377 VSS.n458 259.99
R3853 VSS.t385 VSS.n117 259.99
R3854 VSS.n123 VSS.t838 259.99
R3855 VSS.t1293 VSS.n127 259.99
R3856 VSS.t832 VSS.n12 259.99
R3857 VSS.t2396 VSS.n1187 258.334
R3858 VSS.t1199 VSS.t1578 258.334
R3859 VSS.t711 VSS.t2372 258.334
R3860 VSS.t490 VSS.t12 258.334
R3861 VSS.t40 VSS.t861 258.334
R3862 VSS.n1246 VSS.t2340 258.334
R3863 VSS.t920 VSS.t2364 258.334
R3864 VSS.t33 VSS.t579 258.334
R3865 VSS.t878 VSS.n1296 258.334
R3866 VSS.t35 VSS.t2508 258.334
R3867 VSS.t251 VSS.n1278 258.334
R3868 VSS.t24 VSS.t2331 258.334
R3869 VSS.t902 VSS.n1324 258.334
R3870 VSS.t595 VSS.t753 258.334
R3871 VSS.t1207 VSS.t1485 258.334
R3872 VSS.t155 VSS.n567 258.334
R3873 VSS.t1537 VSS.t1121 258.334
R3874 VSS.n641 VSS.t1534 258.334
R3875 VSS.t1506 VSS.n648 258.334
R3876 VSS.t929 VSS.t1354 258.334
R3877 VSS.t567 VSS.t630 258.334
R3878 VSS.t581 VSS.t870 258.334
R3879 VSS.n713 VSS.t1540 258.334
R3880 VSS.t418 VSS.t955 258.334
R3881 VSS.t1019 VSS.t427 258.334
R3882 VSS.t866 VSS.t1335 258.334
R3883 VSS.t2279 VSS.t1176 258.334
R3884 VSS.n923 VSS.t2276 258.334
R3885 VSS.t425 VSS.t1162 258.334
R3886 VSS.t1159 VSS.n875 258.334
R3887 VSS.t806 VSS.t419 258.334
R3888 VSS.n871 VSS.t167 258.334
R3889 VSS.t2247 VSS.t1390 258.334
R3890 VSS.t2619 VSS.n989 258.334
R3891 VSS.n1211 VSS.t2393 257.88
R3892 VSS.n1223 VSS.t243 257.88
R3893 VSS.t2310 VSS.n1171 257.88
R3894 VSS.n1275 VSS.t2593 257.88
R3895 VSS.n1397 VSS.t1851 257.88
R3896 VSS.t2596 VSS.n1349 257.88
R3897 VSS.t1590 VSS.n1088 257.88
R3898 VSS.n1132 VSS.t2457 257.88
R3899 VSS.n1134 VSS.t827 257.88
R3900 VSS.n705 VSS.n656 257.88
R3901 VSS.n828 VSS.t952 257.88
R3902 VSS.t1558 VSS.n828 257.88
R3903 VSS.t2412 VSS.n821 257.88
R3904 VSS.n868 VSS.t410 257.88
R3905 VSS.n996 VSS.t356 257.88
R3906 VSS.t935 VSS.t2301 257.88
R3907 VSS.n986 VSS.t1416 257.88
R3908 VSS.t191 VSS.n435 257.144
R3909 VSS.t2380 VSS.n605 257.144
R3910 VSS.n1257 VSS.t2460 257.144
R3911 VSS.n1270 VSS.t283 257.144
R3912 VSS.n1312 VSS.t773 257.144
R3913 VSS.t552 VSS.n1420 257.144
R3914 VSS.t958 VSS.t795 257.144
R3915 VSS.t80 VSS.n1355 257.144
R3916 VSS.t501 VSS.n766 257.144
R3917 VSS.t1251 VSS.n796 257.144
R3918 VSS.n798 VSS.t2273 257.144
R3919 VSS.n799 VSS.t1503 257.144
R3920 VSS.n1181 VSS.t1222 253.583
R3921 VSS.t729 VSS.t742 253.583
R3922 VSS.t1202 VSS.t1596 253.583
R3923 VSS.n1108 VSS.t1214 253.583
R3924 VSS.n1438 VSS.t1195 253.583
R3925 VSS.t598 VSS.n540 253.583
R3926 VSS.t1361 VSS.t946 253.583
R3927 VSS.n964 VSS.t1136 253.583
R3928 VSS.t858 VSS.t1461 253.583
R3929 VSS.t675 VSS.t1359 253.583
R3930 VSS.t932 VSS.n833 253.583
R3931 VSS.n908 VSS.t1133 253.583
R3932 VSS.t1134 VSS.n888 253.583
R3933 VSS.n242 VSS.t1824 252.718
R3934 VSS.n238 VSS.t1806 252.096
R3935 VSS.n154 VSS.t1671 252.096
R3936 VSS.n153 VSS.t1673 252.096
R3937 VSS.t1675 VSS.n156 252.096
R3938 VSS.n187 VSS.t1603 252.096
R3939 VSS.n482 VSS.t1968 252.065
R3940 VSS.t1970 VSS.n485 252.065
R3941 VSS.n480 VSS.t1974 252.065
R3942 VSS.t1976 VSS.n487 252.065
R3943 VSS.n478 VSS.t1978 252.065
R3944 VSS.t1980 VSS.n489 252.065
R3945 VSS.n476 VSS.t1983 252.065
R3946 VSS.t1985 VSS.n491 252.065
R3947 VSS.n474 VSS.t1988 252.065
R3948 VSS.n499 VSS.t2044 252.065
R3949 VSS.t2051 VSS.n460 252.041
R3950 VSS.t2055 VSS.n456 252.041
R3951 VSS.n510 VSS.t2057 252.041
R3952 VSS.t2059 VSS.n452 252.041
R3953 VSS.n514 VSS.t2061 252.041
R3954 VSS.t2063 VSS.n448 252.041
R3955 VSS.t1965 VSS.n483 251.417
R3956 VSS.n458 VSS.t2053 251.417
R3957 VSS.t32 VSS.t359 251.351
R3958 VSS.t1008 VSS.n532 251.351
R3959 VSS.t963 VSS.t1141 251.351
R3960 VSS.t1122 VSS.t1459 251.351
R3961 VSS.t706 VSS.n715 251.351
R3962 VSS.t1273 VSS.t951 251.351
R3963 VSS.t1200 VSS.n611 250.952
R3964 VSS.n1330 VSS.t29 250.952
R3965 VSS.t1147 VSS.n635 250.952
R3966 VSS.n1029 VSS.t417 250.952
R3967 VSS.t1180 VSS.t623 250
R3968 VSS.n712 VSS.t717 250
R3969 VSS.t1183 VSS.n744 250
R3970 VSS.t1438 VSS.t1017 250
R3971 VSS.t851 VSS.n269 249.643
R3972 VSS.t2200 VSS.n57 249.642
R3973 VSS.t364 VSS.t549 249.285
R3974 VSS.t847 VSS.n1186 249.002
R3975 VSS.n1234 VSS.t451 249.002
R3976 VSS.t2275 VSS.n1172 249.002
R3977 VSS.t2595 VSS.n1323 249.002
R3978 VSS.n11 VSS.t224 249.002
R3979 VSS.n210 VSS.t2479 249.002
R3980 VSS.t1020 VSS.t1347 248.571
R3981 VSS.t1483 VSS.t431 248.571
R3982 VSS.t426 VSS.t2535 246.351
R3983 VSS.n1284 VSS.t34 245.43
R3984 VSS.t530 VSS.t1040 244.987
R3985 VSS.t983 VSS.n1105 244.987
R3986 VSS.n1148 VSS.n1093 244.987
R3987 VSS.t220 VSS.n1089 244.987
R3988 VSS.n1475 VSS.n534 244.987
R3989 VSS.t840 VSS.n958 244.987
R3990 VSS.n969 VSS.t985 244.987
R3991 VSS.t78 VSS.n669 244.987
R3992 VSS.t1477 VSS.t1508 244.987
R3993 VSS.n827 VSS.t1291 244.987
R3994 VSS.n920 VSS.n883 244.987
R3995 VSS.n925 VSS.t1292 244.987
R3996 VSS.t367 VSS.n593 244.286
R3997 VSS.n1426 VSS.t553 244.286
R3998 VSS.n1367 VSS.t96 244.286
R3999 VSS.t1246 VSS.t213 244.286
R4000 VSS.t1389 VSS.t1247 244.286
R4001 VSS.t1325 VSS.n769 244.286
R4002 VSS.t1357 VSS.n760 244.286
R4003 VSS.t1329 VSS.n757 244.286
R4004 VSS.n1021 VSS.t1327 244.286
R4005 VSS.n803 VSS.t2415 244.286
R4006 VSS.n242 VSS.t1809 244.123
R4007 VSS.n237 VSS.t1823 243.5
R4008 VSS.n240 VSS.t1825 243.5
R4009 VSS.n227 VSS.t605 243.5
R4010 VSS.n226 VSS.t1815 243.5
R4011 VSS.n155 VSS.t1659 243.5
R4012 VSS.t1666 VSS.n157 243.5
R4013 VSS.n175 VSS.t1680 243.5
R4014 VSS.n186 VSS.t1612 243.5
R4015 VSS.t1967 VSS.n482 243.494
R4016 VSS.n485 VSS.t1969 243.494
R4017 VSS.t1972 VSS.n480 243.494
R4018 VSS.n487 VSS.t1975 243.494
R4019 VSS.t1977 VSS.n478 243.494
R4020 VSS.n489 VSS.t1979 243.494
R4021 VSS.t1982 VSS.n476 243.494
R4022 VSS.n491 VSS.t1984 243.494
R4023 VSS.t1986 VSS.n474 243.494
R4024 VSS.n493 VSS.t1989 243.494
R4025 VSS.t2013 VSS.n448 243.47
R4026 VSS.n514 VSS.t2011 243.47
R4027 VSS.t2008 VSS.n452 243.47
R4028 VSS.n510 VSS.t2006 243.47
R4029 VSS.t2003 VSS.n456 243.47
R4030 VSS.n82 VSS.t2208 243.319
R4031 VSS.n140 VSS.t647 243.317
R4032 VSS.t2037 VSS.n472 242.846
R4033 VSS.n500 VSS.t2046 242.846
R4034 VSS.t2064 VSS.n446 242.846
R4035 VSS.t1277 VSS.t2281 240.689
R4036 VSS.t2334 VSS.t975 240
R4037 VSS.t2434 VSS.t1296 240
R4038 VSS.t2526 VSS.t830 237.5
R4039 VSS.n639 VSS.t215 237.5
R4040 VSS.t1290 VSS.n743 237.5
R4041 VSS.n247 VSS.t1783 252.096
R4042 VSS.t816 VSS.n250 0.00912099
R4043 VSS.t1798 VSS.n236 108.93
R4044 VSS.n370 VSS.t1822 252.096
R4045 VSS.n276 VSS.t1808 252.096
R4046 VSS.n1067 VSS.t1826 236.391
R4047 VSS.n282 VSS.t1811 252.096
R4048 VSS.n1150 VSS.t1814 236.391
R4049 VSS.n388 VSS.t1720 252.096
R4050 VSS.t2 VSS.n146 0.00912099
R4051 VSS.n262 VSS.t1730 109.29
R4052 VSS.t2 VSS.n265 0.0152948
R4053 VSS.t2 VSS.n107 0.00912099
R4054 VSS.n1437 VSS.t1759 236.391
R4055 VSS.n1454 VSS.t1779 236.391
R4056 VSS.n381 VSS.t1761 252.096
R4057 VSS.n409 VSS.t1668 252.718
R4058 VSS.n274 VSS.t1657 252.096
R4059 VSS.n304 VSS.t1661 252.096
R4060 VSS.n283 VSS.t1664 252.096
R4061 VSS.n681 VSS.t1679 236.391
R4062 VSS.n429 VSS.t1608 252.718
R4063 VSS.n904 VSS.t1611 236.391
R4064 VSS.n298 VSS.t1613 252.096
R4065 VSS.t1154 VSS.t2277 236.391
R4066 VSS.n495 VSS.t2038 235.714
R4067 VSS.t2040 VSS.n469 235.714
R4068 VSS.n498 VSS.t2042 235.714
R4069 VSS.t1996 VSS.n462 235.714
R4070 VSS.t2001 VSS.n457 235.714
R4071 VSS.n509 VSS.t2004 235.714
R4072 VSS.t2007 VSS.n453 235.714
R4073 VSS.n513 VSS.t2009 235.714
R4074 VSS.t2012 VSS.n449 235.714
R4075 VSS.t271 VSS.t1914 108.999
R4076 VSS.t271 VSS.t1919 109.001
R4077 VSS.t271 VSS.t1934 108.999
R4078 VSS.n347 VSS.t1959 251.417
R4079 VSS.n358 VSS.t1858 251.417
R4080 VSS.t253 VSS.t1878 108.999
R4081 VSS.t1001 VSS.t1589 235.714
R4082 VSS.t1853 VSS.n1430 235.714
R4083 VSS.n255 VSS.t1855 252.041
R4084 VSS.t1681 VSS.n399 251.417
R4085 VSS.n69 VSS.t1686 108.999
R4086 VSS.n70 VSS.t1696 108.999
R4087 VSS.t747 VSS.n610 233.333
R4088 VSS.n1305 VSS.t1061 233.333
R4089 VSS.t282 VSS.n1277 233.333
R4090 VSS.t2571 VSS.n1140 233.333
R4091 VSS.n1448 VSS.t638 233.333
R4092 VSS.t207 VSS.n647 233.333
R4093 VSS.n856 VSS.t324 233.333
R4094 VSS.t1102 VSS.n988 233.333
R4095 VSS.t197 VSS.t495 232.093
R4096 VSS.t1087 VSS.t564 231.429
R4097 VSS.t625 VSS.t1556 231.429
R4098 VSS.t43 VSS.t1252 231.429
R4099 VSS.n1245 VSS.t1899 229.167
R4100 VSS.t2383 VSS.t880 229.167
R4101 VSS.n1156 VSS.t1801 227.794
R4102 VSS.n1059 VSS.t1807 227.794
R4103 VSS.n1155 VSS.t1827 227.794
R4104 VSS.n1153 VSS.t1812 227.794
R4105 VSS.t765 VSS.t536 227.794
R4106 VSS.n107 VSS.t1748 110.284
R4107 VSS.n73 VSS.t1753 110.284
R4108 VSS.n89 VSS.t1762 244.121
R4109 VSS.n977 VSS.t1662 227.794
R4110 VSS.t1677 VSS.n164 244.121
R4111 VSS.n216 VSS.t1610 243.5
R4112 VSS.t1992 VSS.n469 227.143
R4113 VSS.n498 VSS.t1994 227.143
R4114 VSS.t2048 VSS.n462 227.143
R4115 VSS.n504 VSS.t2050 227.143
R4116 VSS.t2052 VSS.n459 227.143
R4117 VSS.n508 VSS.t2054 227.143
R4118 VSS.t2056 VSS.n454 227.143
R4119 VSS.n512 VSS.t2058 227.143
R4120 VSS.t2060 VSS.n450 227.143
R4121 VSS.n516 VSS.t2062 227.143
R4122 VSS.t271 VSS.t1907 109.986
R4123 VSS.n316 VSS.t1960 242.846
R4124 VSS.n65 VSS.t1866 109.992
R4125 VSS.t253 VSS.n66 0.00915176
R4126 VSS.n278 VSS.t1898 242.846
R4127 VSS.n1411 VSS.t482 227.143
R4128 VSS.n1433 VSS.t1854 227.143
R4129 VSS.t2592 VSS.n1394 227.143
R4130 VSS.t948 VSS.n71 0.00915177
R4131 VSS.n632 VSS.t1719 227.143
R4132 VSS.t406 VSS.t1456 227.143
R4133 VSS.t535 VSS.n772 227.028
R4134 VSS.n778 VSS.t454 227.028
R4135 VSS.t2390 VSS.n1377 225.703
R4136 VSS.n1317 VSS.t690 222.857
R4137 VSS.t299 VSS.t2361 222.857
R4138 VSS.n499 VSS.t1995 222.065
R4139 VSS.t1990 VSS.n493 222.065
R4140 VSS.t2000 VSS.n460 222.042
R4141 VSS.t1886 VSS.n64 222.042
R4142 VSS.n1392 VSS.t1857 222.041
R4143 VSS.n241 VSS.t1810 222.011
R4144 VSS.n159 VSS.t1678 222.011
R4145 VSS.n175 VSS.t1667 222.011
R4146 VSS.t2015 VSS.n447 221.417
R4147 VSS.n445 VSS.t2065 221.417
R4148 VSS.t145 VSS.n573 219.198
R4149 VSS.n1443 VSS.t1448 219.198
R4150 VSS.t146 VSS.t226 219.198
R4151 VSS.t2327 VSS.t162 219.198
R4152 VSS.t189 VSS.t1581 218.571
R4153 VSS.n38 VSS.t1901 215.692
R4154 VSS.t2047 VSS.t2337 214.286
R4155 VSS.t235 VSS.t2622 210.602
R4156 VSS.t2441 VSS.n1411 210
R4157 VSS.t108 VSS.t2453 209.627
R4158 VSS.t930 VSS.t2430 209.627
R4159 VSS.t25 VSS.t2233 209.206
R4160 VSS.n777 VSS.t1494 206.898
R4161 VSS.n1214 VSS.t1942 206.304
R4162 VSS.t1810 VSS.n1063 206.304
R4163 VSS.t2 VSS.t1778 222.656
R4164 VSS.t1559 VSS.t1553 206.304
R4165 VSS.n560 VSS.t1763 206.304
R4166 VSS.t1667 VSS.n679 206.304
R4167 VSS.n686 VSS.t1473 206.304
R4168 VSS.t1607 VSS.n897 206.304
R4169 VSS.n906 VSS.t1607 206.304
R4170 VSS.n504 VSS.t2000 205.714
R4171 VSS.n517 VSS.t2015 205.714
R4172 VSS.t2065 VSS.n444 205.714
R4173 VSS.t253 VSS.t1883 222.065
R4174 VSS.n1261 VSS.t1014 205.714
R4175 VSS.t1903 VSS.n595 205.714
R4176 VSS.t1706 VSS.t948 222.065
R4177 VSS.n30 VSS.t1631 15.0018
R4178 VSS.t165 VSS.t2530 204.167
R4179 VSS.t265 VSS.t489 202.006
R4180 VSS.t881 VSS.n601 201.429
R4181 VSS.t1013 VSS.t1903 201.429
R4182 VSS.n1266 VSS.t750 201.429
R4183 VSS.t2356 VSS.n1393 201.429
R4184 VSS.t1857 VSS.t943 201.429
R4185 VSS.n1378 VSS.t2390 201.429
R4186 VSS.t1368 VSS.t447 201.429
R4187 VSS.t1796 VSS.n250 110.285
R4188 VSS.t1723 VSS.n147 110.278
R4189 VSS.t1738 VSS.n263 110.284
R4190 VSS.t1758 VSS.n80 201.143
R4191 VSS.t1615 VSS.n931 201.143
R4192 VSS.n484 VSS.t1967 200.613
R4193 VSS.t1969 VSS.n481 200.613
R4194 VSS.n486 VSS.t1972 200.613
R4195 VSS.t1975 VSS.n479 200.613
R4196 VSS.n488 VSS.t1977 200.613
R4197 VSS.t1979 VSS.n477 200.613
R4198 VSS.n490 VSS.t1982 200.613
R4199 VSS.t1984 VSS.n475 200.613
R4200 VSS.n492 VSS.t1986 200.613
R4201 VSS.t1989 VSS.n473 200.613
R4202 VSS.n494 VSS.t2037 200.613
R4203 VSS.t2039 VSS.n470 200.613
R4204 VSS.n496 VSS.t1992 200.613
R4205 VSS.n497 VSS.t2041 200.613
R4206 VSS.t1994 VSS.n467 200.613
R4207 VSS.t2043 VSS.n466 200.613
R4208 VSS.n503 VSS.t1998 200.613
R4209 VSS.t2050 VSS.n461 200.613
R4210 VSS.t1958 VSS.n20 102.457
R4211 VSS.t1861 VSS.n267 109.986
R4212 VSS.t1876 VSS.n34 110.001
R4213 VSS.n35 VSS.t1898 200.613
R4214 VSS.t1684 VSS.n258 109.986
R4215 VSS.t1719 VSS.n631 200.613
R4216 VSS.t1619 VSS.t242 109.986
R4217 VSS.t1629 VSS.t242 109.993
R4218 VSS.n31 VSS.t1640 109.7
R4219 VSS.t1804 VSS.n239 200.52
R4220 VSS.t1807 VSS.n237 200.52
R4221 VSS.t1825 VSS.n241 200.52
R4222 VSS.n155 VSS.t1672 200.52
R4223 VSS.n157 VSS.t1677 200.52
R4224 VSS.t1606 VSS.n186 200.52
R4225 VSS.t2198 VSS.t2510 200
R4226 VSS.t1901 VSS.n610 200
R4227 VSS.n463 VSS.t2048 199.989
R4228 VSS.t2054 VSS.n507 199.989
R4229 VSS.n455 VSS.t2056 199.989
R4230 VSS.t2058 VSS.n511 199.989
R4231 VSS.n451 VSS.t2060 199.989
R4232 VSS.t2062 VSS.n515 199.989
R4233 VSS.n447 VSS.t2064 199.989
R4234 VSS.t1280 VSS.t6 197.708
R4235 VSS.t910 VSS.t586 197.143
R4236 VSS.t1486 VSS.t1549 197.143
R4237 VSS.t1530 VSS.t1125 197.143
R4238 VSS.t1942 VSS.t281 193.411
R4239 VSS.n1439 VSS.t145 193.411
R4240 VSS.t502 VSS.t1422 193.411
R4241 VSS.t1169 VSS.t2439 193.411
R4242 VSS.t1077 VSS.t2630 192.857
R4243 VSS.t788 VSS.t2196 192.857
R4244 VSS.t1081 VSS.t1525 192.857
R4245 VSS.t2423 VSS.t1282 192.857
R4246 VSS.t1793 VSS.n250 109.288
R4247 VSS.t1788 VSS.n249 109.29
R4248 VSS.t1783 VSS.n248 192.559
R4249 VSS.t1755 VSS.n80 192.548
R4250 VSS.t1750 VSS.n73 109.29
R4251 VSS.t1745 VSS.n107 109.29
R4252 VSS.t1740 VSS.n265 109.282
R4253 VSS.n262 VSS.t1733 110.284
R4254 VSS.t1725 VSS.n146 109.29
R4255 VSS.t1720 VSS.n147 192.559
R4256 VSS.n931 VSS.t1613 192.548
R4257 VSS.n505 VSS.t2051 192.042
R4258 VSS.t2049 VSS.n461 192.042
R4259 VSS.n503 VSS.t1996 192.042
R4260 VSS.t2042 VSS.n466 192.042
R4261 VSS.t1993 VSS.n467 192.042
R4262 VSS.n497 VSS.t2040 192.042
R4263 VSS.n496 VSS.t1991 192.042
R4264 VSS.t2038 VSS.n470 192.042
R4265 VSS.n494 VSS.t2036 192.042
R4266 VSS.t1988 VSS.n473 192.042
R4267 VSS.n492 VSS.t1985 192.042
R4268 VSS.t1983 VSS.n475 192.042
R4269 VSS.n490 VSS.t1980 192.042
R4270 VSS.t1978 VSS.n477 192.042
R4271 VSS.n488 VSS.t1976 192.042
R4272 VSS.t1974 VSS.n479 192.042
R4273 VSS.n486 VSS.t1970 192.042
R4274 VSS.t1968 VSS.n481 192.042
R4275 VSS.n484 VSS.t1965 192.042
R4276 VSS.t271 VSS.n21 96.0268
R4277 VSS.t271 VSS.t1937 109.993
R4278 VSS.t271 VSS.t1929 109.001
R4279 VSS.t271 VSS.t1924 109.001
R4280 VSS.t271 VSS.t1922 109.992
R4281 VSS.t271 VSS.t1917 109.993
R4282 VSS.t1909 VSS.t271 108.999
R4283 VSS.t1904 VSS.t271 108.722
R4284 VSS.t1897 VSS.n35 192.042
R4285 VSS.t253 VSS.t1881 109.993
R4286 VSS.t1873 VSS.n34 108.996
R4287 VSS.t1868 VSS.n66 109.001
R4288 VSS.t1863 VSS.n65 109.001
R4289 VSS.t1858 VSS.n267 192.054
R4290 VSS.n631 VSS.t1718 192.042
R4291 VSS.n71 VSS.t1701 109.001
R4292 VSS.n70 VSS.t1699 109.993
R4293 VSS.n259 VSS.t1691 109.001
R4294 VSS.n69 VSS.t1689 109.993
R4295 VSS.n258 VSS.t1681 192.054
R4296 VSS.n30 VSS.t242 96.0268
R4297 VSS.t242 VSS.t1626 108.999
R4298 VSS.t242 VSS.t1624 109.999
R4299 VSS.t242 VSS.t1616 108.722
R4300 VSS.n238 VSS.t1822 191.924
R4301 VSS.n227 VSS.t1814 191.924
R4302 VSS.n81 VSS.t1779 191.924
R4303 VSS.t1657 VSS.n154 191.924
R4304 VSS.t1661 VSS.n153 191.924
R4305 VSS.n156 VSS.t1664 191.924
R4306 VSS.t1611 VSS.n187 191.924
R4307 VSS.n507 VSS.t2001 191.417
R4308 VSS.t2004 VSS.n455 191.417
R4309 VSS.n511 VSS.t2007 191.417
R4310 VSS.t2009 VSS.n451 191.417
R4311 VSS.n515 VSS.t2012 191.417
R4312 VSS.n1431 VSS.t1853 191.417
R4313 VSS.t690 VSS.n588 188.571
R4314 VSS.t763 VSS.t485 188.571
R4315 VSS.n1193 VSS.n1185 184.815
R4316 VSS.n1221 VSS.n1220 184.815
R4317 VSS.t1801 VSS.n1055 184.815
R4318 VSS.t1823 VSS.n1058 184.815
R4319 VSS.t1809 VSS.n1064 184.815
R4320 VSS.t1827 VSS.n1060 184.815
R4321 VSS.t1812 VSS.n1079 184.815
R4322 VSS.t605 VSS.n1109 184.815
R4323 VSS.t1815 VSS.n1109 184.815
R4324 VSS.t475 VSS.t802 184.815
R4325 VSS.n1446 VSS.n1445 184.815
R4326 VSS.t1762 VSS.n1451 184.815
R4327 VSS.n1477 VSS.n1476 184.815
R4328 VSS.n945 VSS.t1670 184.815
R4329 VSS.t1659 VSS.n944 184.815
R4330 VSS.n943 VSS.t1662 184.815
R4331 VSS.t1674 VSS.n412 184.815
R4332 VSS.n950 VSS.t1666 184.815
R4333 VSS.t1680 VSS.n680 184.815
R4334 VSS.t135 VSS.n657 184.815
R4335 VSS.n850 VSS.n813 184.815
R4336 VSS.n900 VSS.t1610 184.815
R4337 VSS.t1612 VSS.n898 184.815
R4338 VSS.n508 VSS.t2003 184.286
R4339 VSS.t2006 VSS.n454 184.286
R4340 VSS.n512 VSS.t2008 184.286
R4341 VSS.t2011 VSS.n450 184.286
R4342 VSS.n516 VSS.t2013 184.286
R4343 VSS.t1960 VSS.n1162 184.286
R4344 VSS.t2224 VSS.t2280 184.286
R4345 VSS.t1854 VSS.n1432 184.286
R4346 VSS.n1395 VSS.t2592 184.286
R4347 VSS.n1394 VSS.t1856 184.286
R4348 VSS.t864 VSS.t233 184.286
R4349 VSS.t131 VSS.t961 184.286
R4350 VSS.t1110 VSS.t242 1.71413
R4351 VSS.t1256 VSS.t1504 184.286
R4352 VSS.t4 VSS.t2265 184.286
R4353 VSS.t577 VSS.t1096 184.286
R4354 VSS.t1137 VSS.t242 1.71456
R4355 VSS.n920 VSS.n208 183.328
R4356 VSS.t1582 VSS.t1026 180.517
R4357 VSS.t626 VSS.t1072 180.517
R4358 VSS.t1149 VSS.t1111 180
R4359 VSS.n1056 VSS.t1802 176.219
R4360 VSS.n1065 VSS.t1808 176.219
R4361 VSS.t1824 VSS.n1063 176.219
R4362 VSS.n1080 VSS.t1811 176.219
R4363 VSS.t1671 VSS.n944 176.219
R4364 VSS.t1673 VSS.n943 176.219
R4365 VSS.n950 VSS.t1675 176.219
R4366 VSS.t1603 VSS.n898 176.219
R4367 VSS.n502 VSS.t2047 175.714
R4368 VSS.t2053 VSS.n457 175.714
R4369 VSS.n509 VSS.t2055 175.714
R4370 VSS.t2057 VSS.n453 175.714
R4371 VSS.n513 VSS.t2059 175.714
R4372 VSS.t2061 VSS.n449 175.714
R4373 VSS.n517 VSS.t2063 175.714
R4374 VSS.n1163 VSS.t1959 175.714
R4375 VSS.t1855 VSS.n1396 175.714
R4376 VSS.t1184 VSS.t374 175.714
R4377 VSS.t2535 VSS.t1161 175.183
R4378 VSS.t1495 VSS.n780 174.325
R4379 VSS.t18 VSS.t893 171.921
R4380 VSS.t2228 VSS.t1782 171.921
R4381 VSS.t2630 VSS.n63 170.613
R4382 VSS.n27 VSS.t2375 104.954
R4383 VSS.n246 VSS.t2199 170.435
R4384 VSS.n233 VSS.t1590 170.435
R4385 VSS.t2457 VSS.n218 170.435
R4386 VSS.t827 VSS.n234 170.435
R4387 VSS.t229 VSS.n170 170.435
R4388 VSS.n822 VSS.t2412 170.435
R4389 VSS.t1285 VSS.n832 170.435
R4390 VSS.t1063 VSS.n185 170.435
R4391 VSS.n37 VSS.t2380 169.989
R4392 VSS.t773 VSS.n49 169.989
R4393 VSS.n1384 VSS.t2338 169.989
R4394 VSS.t2602 VSS.n1383 169.989
R4395 VSS.n120 VSS.t501 169.989
R4396 VSS.n121 VSS.t406 169.989
R4397 VSS.n15 VSS.t1251 169.989
R4398 VSS.n775 VSS.t2475 168.103
R4399 VSS.t1035 VSS.t698 167.623
R4400 VSS.n1112 VSS.t983 167.623
R4401 VSS.n1148 VSS.n1125 167.623
R4402 VSS.n1129 VSS.t220 167.623
R4403 VSS.n967 VSS.t840 167.623
R4404 VSS.t985 VSS.n955 167.623
R4405 VSS.t1473 VSS.t1532 167.623
R4406 VSS.n691 VSS.t78 167.623
R4407 VSS.t836 VSS.n667 167.623
R4408 VSS.n849 VSS.n816 167.623
R4409 VSS.t1292 VSS.n880 167.623
R4410 VSS.t2044 VSS.t2495 167.143
R4411 VSS.n506 VSS.t2377 167.143
R4412 VSS.t1014 VSS.t1015 167.143
R4413 VSS.n1265 VSS.t367 167.143
R4414 VSS.t975 VSS.n1316 167.143
R4415 VSS.t553 VSS.n1425 167.143
R4416 VSS.t1466 VSS.t2218 167.143
R4417 VSS.t2218 VSS.n1389 167.143
R4418 VSS.t96 VSS.n1366 167.143
R4419 VSS.n1009 VSS.t1325 167.143
R4420 VSS.n1016 VSS.t1357 167.143
R4421 VSS.t1327 VSS.n754 167.143
R4422 VSS.n1026 VSS.t1293 167.143
R4423 VSS.n938 VSS.t1149 167.143
R4424 VSS.n805 VSS.t832 167.143
R4425 VSS.n1187 VSS.t847 166.667
R4426 VSS.t451 VSS.n1233 166.667
R4427 VSS.n1173 VSS.t2275 166.667
R4428 VSS.n1246 VSS.t747 166.667
R4429 VSS.t1061 VSS.n1304 166.667
R4430 VSS.n1141 VSS.t2571 166.667
R4431 VSS.t158 VSS.n641 166.667
R4432 VSS.t735 VSS.n742 166.667
R4433 VSS.t324 VSS.n855 166.667
R4434 VSS.t224 VSS.n865 166.667
R4435 VSS.t2479 VSS.n923 166.667
R4436 VSS.t2534 VSS.n875 166.667
R4437 VSS.n871 VSS.t165 166.667
R4438 VSS.n1186 VSS.t1961 165.669
R4439 VSS.n1172 VSS.t2310 165.669
R4440 VSS.t410 VSS.n11 165.669
R4441 VSS.t305 VSS.n213 165.669
R4442 VSS.t215 VSS.n638 162.5
R4443 VSS.n1031 VSS.t1290 162.5
R4444 VSS.t2208 VSS.n532 162.162
R4445 VSS.n778 VSS.t535 162.162
R4446 VSS.t647 VSS.n715 162.162
R4447 VSS.n33 VSS.n7 0.155984
R4448 VSS.t304 VSS.t295 159.026
R4449 VSS.t1209 VSS.n1071 159.026
R4450 VSS.t1214 VSS.n1107 159.026
R4451 VSS.t1195 VSS.n1437 159.026
R4452 VSS.t977 VSS.t310 159.026
R4453 VSS.n834 VSS.t932 159.026
R4454 VSS.t2169 VSS.n7 43.5666
R4455 VSS.t2503 VSS.t813 158.571
R4456 VSS.t899 VSS.t2200 158.333
R4457 VSS.n1279 VSS.t251 157.335
R4458 VSS.n1142 VSS.t2383 157.335
R4459 VSS.n79 VSS.t155 157.335
R4460 VSS.n649 VSS.t1506 157.335
R4461 VSS.t1017 VSS.n854 157.335
R4462 VSS.t2276 VSS.n209 157.335
R4463 VSS.t167 VSS.n215 157.335
R4464 VSS.n990 VSS.t2619 157.335
R4465 VSS.t562 VSS.n33 15.0951
R4466 VSS.n1183 VSS.t2227 154.728
R4467 VSS.t2593 VSS.n1274 154.728
R4468 VSS.n1156 VSS.t780 154.728
R4469 VSS.t1602 VSS.n1095 154.728
R4470 VSS.t1597 VSS.n1094 154.728
R4471 VSS.n563 VSS.t235 154.728
R4472 VSS.t226 VSS.n551 154.728
R4473 VSS.n1473 VSS.t1280 154.728
R4474 VSS.n965 VSS.t1044 154.728
R4475 VSS.n970 VSS.t188 154.728
R4476 VSS.t310 VSS.n674 154.728
R4477 VSS.t2318 VSS.n665 154.728
R4478 VSS.n932 VSS.t409 154.728
R4479 VSS.n906 VSS.t1270 154.728
R4480 VSS.n910 VSS.t2464 154.728
R4481 VSS.t2439 VSS.n891 154.728
R4482 VSS.n915 VSS.t2467 154.728
R4483 VSS.t2532 VSS.n885 154.728
R4484 VSS.t1416 VSS.n985 154.728
R4485 VSS.n1254 VSS.t2515 154.286
R4486 VSS.n1255 VSS.t2224 154.286
R4487 VSS.n1259 VSS.t2225 154.286
R4488 VSS.n1268 VSS.t2379 154.286
R4489 VSS.t283 VSS.n588 154.286
R4490 VSS.n1403 VSS.t788 154.286
R4491 VSS.n1414 VSS.t826 154.286
R4492 VSS.n1417 VSS.t189 154.286
R4493 VSS.n1432 VSS.t570 154.286
R4494 VSS.t525 VSS.n1367 154.286
R4495 VSS.n1339 VSS.t910 154.286
R4496 VSS.t374 VSS.n764 154.286
R4497 VSS.t1525 VSS.n739 154.286
R4498 VSS.t961 VSS.n727 154.286
R4499 VSS.n1047 VSS.t1368 154.286
R4500 VSS.t2273 VSS.n794 154.286
R4501 VSS.t1503 VSS.n794 154.286
R4502 VSS.t1096 VSS.n785 154.286
R4503 VSS.t1282 VSS.n878 154.286
R4504 VSS.n927 VSS.t1297 154.286
R4505 VSS.t1220 VSS.n1192 154.167
R4506 VSS.n1227 VSS.t20 154.167
R4507 VSS.t41 VSS.n1178 154.167
R4508 VSS.n1245 VSS.t1200 154.167
R4509 VSS.t34 VSS.n1283 154.167
R4510 VSS.t601 VSS.n1146 154.167
R4511 VSS.t1201 VSS.n568 154.167
R4512 VSS.n636 VSS.t1147 154.167
R4513 VSS.t928 VSS.n652 154.167
R4514 VSS.n711 VSS.t871 154.167
R4515 VSS.t417 VSS.n744 154.167
R4516 VSS.t2520 VSS.t735 154.167
R4517 VSS.n851 VSS.t428 154.167
R4518 VSS.n26 VSS.t865 167.082
R4519 VSS.t424 VSS.n876 154.167
R4520 VSS.t2246 VSS.n994 154.167
R4521 VSS.n100 VSS.t1562 153.642
R4522 VSS.n139 VSS.t1564 153.642
R4523 VSS.n99 VSS.t1008 153.474
R4524 VSS.n141 VSS.t706 153.474
R4525 VSS.t268 VSS.n530 153.243
R4526 VSS.t1039 VSS.n1224 153.243
R4527 VSS.t1034 VSS.n53 153.243
R4528 VSS.n58 VSS.t1035 153.243
R4529 VSS.n1291 VSS.t267 153.243
R4530 VSS.n75 VSS.t218 153.243
R4531 VSS.n104 VSS.t1563 153.243
R4532 VSS.t1565 VSS.n271 153.243
R4533 VSS.n113 VSS.t673 153.243
R4534 VSS.t2308 VSS.t424 152.381
R4535 VSS.n1075 VSS.t1027 150.43
R4536 VSS.n1118 VSS.t872 150.43
R4537 VSS.t714 VSS.n557 150.43
R4538 VSS.t2611 VSS.n624 150.43
R4539 VSS.t660 VSS.t1285 150.43
R4540 VSS.t2610 VSS.n848 150.43
R4541 VSS.n942 VSS.t642 150.145
R4542 VSS.t1383 VSS.n1333 150
R4543 VSS.n1140 VSS.t556 150
R4544 VSS.n1457 VSS.n1456 150
R4545 VSS.t8 VSS.n533 150
R4546 VSS.t717 VSS.n709 150
R4547 VSS.t1380 VSS.n726 150
R4548 VSS.t1274 VSS.n1048 150
R4549 VSS.t1549 VSS.n116 149.185
R4550 VSS.t2453 VSS.t591 149.069
R4551 VSS.t2430 VSS.t2432 149.069
R4552 VSS.t1072 VSS.n182 148.945
R4553 VSS.t1210 VSS.t1760 146.132
R4554 VSS.t1678 VSS.t320 146.132
R4555 VSS.n779 VSS.n772 145.946
R4556 VSS.n1419 VSS.t1001 145.714
R4557 VSS.n1018 VSS.t864 145.714
R4558 VSS.n1159 VSS.n8 6015.66
R4559 VSS.t1170 VSS.n201 144.647
R4560 VSS.t1222 VSS.t566 141.834
R4561 VSS.n1440 VSS.t216 141.834
R4562 VSS.t2510 VSS.n1232 141.667
R4563 VSS.n1174 VSS.t1587 141.667
R4564 VSS.t1587 VSS.t737 141.667
R4565 VSS.t1900 VSS.t1218 141.667
R4566 VSS.n313 VSS.t2340 157.335
R4567 VSS.t830 VSS.n1303 141.667
R4568 VSS.n1297 VSS.t878 141.667
R4569 VSS.t1394 VSS.t207 141.667
R4570 VSS.t1540 VSS.n709 141.667
R4571 VSS.n1031 VSS.t1499 141.667
R4572 VSS.n867 VSS.t240 141.667
R4573 VSS.t240 VSS.t411 141.667
R4574 VSS.t2046 VSS.t2336 141.429
R4575 VSS.t1075 VSS.t987 141.429
R4576 VSS.t2475 VSS.n774 137.931
R4577 VSS.n776 VSS.t2476 137.931
R4578 VSS.t1446 VSS.n771 137.839
R4579 VSS.n781 VSS.t1495 137.839
R4580 VSS.t945 VSS.n1198 137.536
R4581 VSS.n1207 VSS.t2591 137.536
R4582 VSS.t1040 VSS.n1237 137.536
R4583 VSS.n1169 VSS.t270 137.536
R4584 VSS.t2552 VSS.n609 137.536
R4585 VSS.n1274 VSS.t262 137.536
R4586 VSS.t387 VSS.n1398 137.536
R4587 VSS.t2548 VSS.n1399 137.536
R4588 VSS.n1347 VSS.t1036 137.536
R4589 VSS.t2408 VSS.t1602 137.536
R4590 VSS.t2598 VSS.t1597 137.536
R4591 VSS.t610 VSS.n1092 137.536
R4592 VSS.n1137 VSS.t265 137.536
R4593 VSS.t2547 VSS.n573 137.536
R4594 VSS.t2254 VSS.n572 137.536
R4595 VSS.t430 VSS.n545 137.536
R4596 VSS.t946 VSS.n536 137.536
R4597 VSS.n966 VSS.t2549 137.536
R4598 VSS.t1337 VSS.n952 137.536
R4599 VSS.n707 VSS.t675 137.536
R4600 VSS.t2472 VSS.n934 137.536
R4601 VSS.t2300 VSS.n860 137.536
R4602 VSS.n869 VSS.t2298 137.536
R4603 VSS.n911 VSS.t2474 137.536
R4604 VSS.t2473 VSS.n884 137.536
R4605 VSS.n925 VSS.t2477 137.536
R4606 VSS.t2301 VSS.n998 137.536
R4607 VSS.n985 VSS.t2303 137.536
R4608 VSS.t71 VSS.t851 137.5
R4609 VSS.t1499 VSS.t991 137.5
R4610 VSS.t678 VSS.t191 137.143
R4611 VSS.t2536 VSS.t881 137.143
R4612 VSS.t750 VSS.t1012 137.143
R4613 VSS.t1475 VSS.t385 137.143
R4614 VSS.t271 VSS.n28 5.21124
R4615 VSS.n222 VSS.t2408 136.673
R4616 VSS.n206 VSS.t2533 136.673
R4617 VSS.t2465 VSS.n198 136.673
R4618 VSS.n24 VSS.t271 5.21121
R4619 VSS.n222 VSS.t2598 136.673
R4620 VSS.t1422 VSS.n97 136.673
R4621 VSS.t123 VSS.n162 136.673
R4622 VSS.t1119 VSS.n199 136.673
R4623 VSS.n1416 VSS.t913 136.327
R4624 VSS.n134 VSS.t1457 136.327
R4625 VSS.n122 VSS.t1306 136.327
R4626 VSS.n1338 VSS.t1585 136.327
R4627 VSS.t242 VSS.t185 136.327
R4628 VSS.t934 VSS.n1212 136.05
R4629 VSS.t476 VSS.t578 136.038
R4630 VSS.t452 VSS.n436 135.703
R4631 VSS.n36 VSS.t2503 135.703
R4632 VSS.t768 VSS.n48 135.703
R4633 VSS.t1504 VSS.n14 135.703
R4634 VSS.n16 VSS.t1392 135.703
R4635 VSS.n13 VSS.t4 135.703
R4636 VSS.n1487 VSS.t2499 134.441
R4637 VSS.t205 VSS.n1221 133.663
R4638 VSS.t216 VSS.t2547 133.238
R4639 VSS.t1448 VSS.t187 133.238
R4640 VSS.n560 VSS.t657 133.238
R4641 VSS.n561 VSS.t708 133.238
R4642 VSS.n642 VSS.t1229 132.976
R4643 VSS.n212 VSS.t805 132.976
R4644 VSS.t813 VSS.n601 132.857
R4645 VSS.t2460 VSS.t1050 132.857
R4646 VSS.n1266 VSS.t1047 132.857
R4647 VSS.t485 VSS.n1378 132.857
R4648 VSS.n1375 VSS.t656 132.857
R4649 VSS.t1546 VSS.n787 132.857
R4650 VSS.t55 VSS.n786 132.857
R4651 VSS.t731 VSS.n1276 132.359
R4652 VSS.t1417 VSS.n987 132.359
R4653 VSS.n270 VSS.t580 132.335
R4654 VSS.t1594 VSS.n1485 131.421
R4655 VSS.t539 VSS.n1484 131.421
R4656 VSS.t464 VSS.n1483 131.421
R4657 VSS.t121 VSS.n1482 131.421
R4658 VSS.t326 VSS.n1481 131.421
R4659 VSS.t340 VSS.n1480 131.421
R4660 VSS.t2262 VSS.n1479 131.421
R4661 VSS.t2389 VSS.n22 21.4527
R4662 VSS.t638 VSS.t49 129.167
R4663 VSS.t896 VSS.t263 128.94
R4664 VSS.n1058 VSS.t814 128.94
R4665 VSS.t491 VSS.n412 128.94
R4666 VSS.t1136 VSS.t2235 128.94
R4667 VSS.n685 VSS.t470 128.94
R4668 VSS.n1256 VSS.t2407 128.571
R4669 VSS.n1262 VSS.t2497 128.571
R4670 VSS.t288 VSS.n1412 128.571
R4671 VSS.n1393 VSS.t2330 128.571
R4672 VSS.t1033 VSS.n1409 127.132
R4673 VSS.n0 VSS.t889 125.49
R4674 VSS.n1 VSS.t1599 125.49
R4675 VSS.n2 VSS.t682 125.49
R4676 VSS.n3 VSS.t848 125.49
R4677 VSS.n4 VSS.t2543 125.49
R4678 VSS.n5 VSS.t761 125.49
R4679 VSS.n6 VSS.t209 125.49
R4680 VSS.t1026 VSS.n1072 124.642
R4681 VSS.t1341 VSS.n1104 124.642
R4682 VSS.t873 VSS.n1099 124.642
R4683 VSS.n1130 VSS.t429 124.642
R4684 VSS.n272 VSS.t662 137.258
R4685 VSS.t615 VSS.n570 124.642
R4686 VSS.n562 VSS.t715 124.642
R4687 VSS.t1563 VSS.t2611 124.642
R4688 VSS.n968 VSS.t584 124.642
R4689 VSS.t2514 VSS.n953 124.642
R4690 VSS.t1396 VSS.n668 124.642
R4691 VSS.t2609 VSS.n847 124.642
R4692 VSS.n924 VSS.t1154 124.642
R4693 VSS.n626 VSS.t2612 124.335
R4694 VSS.t2590 VSS.n459 124.287
R4695 VSS.t689 VSS.n589 124.287
R4696 VSS.t875 VSS.n1315 124.287
R4697 VSS.t796 VSS.n1424 124.287
R4698 VSS.t749 VSS.n1388 124.287
R4699 VSS.t795 VSS.n1365 124.287
R4700 VSS.t1384 VSS.n1332 124.287
R4701 VSS.t1187 VSS.n768 124.287
R4702 VSS.t1338 VSS.n764 124.287
R4703 VSS.t1531 VSS.n761 124.287
R4704 VSS.t1358 VSS.n756 124.287
R4705 VSS.n1020 VSS.t1186 124.287
R4706 VSS.t431 VSS.n747 124.287
R4707 VSS.n1043 VSS.t1381 124.287
R4708 VSS.t2414 VSS.n788 124.287
R4709 VSS.t1156 VSS.t1097 124.287
R4710 VSS.t65 VSS.t115 124.287
R4711 VSS.n33 VSS.t366 125.49
R4712 VSS.t782 VSS.n244 123.779
R4713 VSS.n838 VSS.t966 123.156
R4714 VSS.t84 VSS.n42 122.847
R4715 VSS.n1008 VSS.t809 121.496
R4716 VSS.t1326 VSS.n637 120.834
R4717 VSS.t991 VSS.n742 120.834
R4718 VSS.t544 VSS.n1347 120.344
R4719 VSS.t819 VSS.n275 136.673
R4720 VSS.t1826 VSS.t2400 120.344
R4721 VSS.n1133 VSS.t2456 120.344
R4722 VSS.n1133 VSS.t450 120.344
R4723 VSS.n1138 VSS.t784 120.344
R4724 VSS.t1760 VSS.t1545 120.344
R4725 VSS.n1463 VSS.t513 120.344
R4726 VSS.t718 VSS.n960 120.344
R4727 VSS.n695 VSS.t858 120.344
R4728 VSS.n819 VSS.t659 120.344
R4729 VSS.t725 VSS.n835 120.344
R4730 VSS.t2418 VSS.n889 120.344
R4731 VSS.t2525 VSS.n606 120.001
R4732 VSS.t2572 VSS.n1306 120.001
R4733 VSS.n1412 VSS.t1584 120.001
R4734 VSS.n1420 VSS.t776 120.001
R4735 VSS.n1430 VSS.t2556 120.001
R4736 VSS.t568 VSS.n1385 120.001
R4737 VSS.n1382 VSS.t2561 120.001
R4738 VSS.t1344 VSS.n767 120.001
R4739 VSS.t954 VSS.n766 120.001
R4740 VSS.t838 VSS.t1414 120.001
R4741 VSS.t2286 VSS.n757 120.001
R4742 VSS.t1248 VSS.n745 120.001
R4743 VSS.n1042 VSS.t1227 120.001
R4744 VSS.t186 VSS.n722 120.001
R4745 VSS.t2415 VSS.t2271 120.001
R4746 VSS.n808 VSS.t1356 120.001
R4747 VSS.t2508 VSS.n1279 119.835
R4748 VSS.t753 VSS.n1142 119.835
R4749 VSS.t1485 VSS.n79 119.835
R4750 VSS.n640 VSS.t1537 119.835
R4751 VSS.t1354 VSS.n649 119.835
R4752 VSS.n854 VSS.t1019 119.835
R4753 VSS.t1162 VSS.n189 119.835
R4754 VSS.t1390 VSS.n990 119.835
R4755 VSS.t359 VSS.n99 116.987
R4756 VSS.t951 VSS.n141 116.987
R4757 VSS.t737 VSS.n1173 116.668
R4758 VSS.t93 VSS.t1900 116.668
R4759 VSS.t1229 VSS.t158 116.668
R4760 VSS.t411 VSS.n865 116.668
R4761 VSS.t805 VSS.t2534 116.668
R4762 VSS.t1802 VSS.t819 116.046
R4763 VSS.t315 VSS.t2624 116.046
R4764 VSS.t1193 VSS.t598 116.046
R4765 VSS.t669 VSS.t1428 116.046
R4766 VSS.t323 VSS.n169 114.561
R4767 VSS.t2604 VSS.t885 112.019
R4768 VSS.t558 VSS.t2604 112.019
R4769 VSS.t1223 VSS.t854 112.019
R4770 VSS.t139 VSS.t1223 112.019
R4771 VSS.n1208 VSS.t2378 111.749
R4772 VSS.t549 VSS.n1397 111.749
R4773 VSS.t537 VSS.t2550 111.749
R4774 VSS.n1126 VSS.t765 111.749
R4775 VSS.t589 VSS.t2410 111.749
R4776 VSS.n1461 VSS.t318 111.749
R4777 VSS.t2413 VSS.t231 111.749
R4778 VSS.n973 VSS.t2614 111.749
R4779 VSS.t1679 VSS.t130 111.749
R4780 VSS.t2615 VSS.t389 111.749
R4781 VSS.t379 VSS.t1257 111.749
R4782 VSS.t2381 VSS.t21 111.43
R4783 VSS.t2223 VSS.t1016 111.43
R4784 VSS.t482 VSS.t2357 111.43
R4785 VSS.n1396 VSS.t1043 111.43
R4786 VSS.n1354 VSS.n1353 110.701
R4787 VSS.n1351 VSS.n1350 110.701
R4788 VSS.t325 VSS.t2365 108.334
R4789 VSS.t30 VSS.t334 108.334
R4790 VSS.t29 VSS.t348 108.334
R4791 VSS.n1196 VSS.t2509 107.451
R4792 VSS.t1387 VSS.t942 107.451
R4793 VSS.t1579 VSS.n1218 107.451
R4794 VSS.n1220 VSS.t1041 107.451
R4795 VSS.n1235 VSS.t527 107.451
R4796 VSS.t698 VSS.n1294 107.451
R4797 VSS.t2398 VSS.n1062 107.451
R4798 VSS.n1075 VSS.t1582 107.451
R4799 VSS.t363 VSS.n1108 107.451
R4800 VSS.t2312 VSS.n1105 107.451
R4801 VSS.n1122 VSS.t1095 107.451
R4802 VSS.t1586 VSS.t990 107.451
R4803 VSS.t2564 VSS.n1082 107.451
R4804 VSS.t1743 VSS.t0 107.451
R4805 VSS.t664 VSS.n1438 107.451
R4806 VSS.n1446 VSS.t1559 107.451
R4807 VSS.t609 VSS.n559 107.451
R4808 VSS.n553 VSS.t2628 107.451
R4809 VSS.t720 VSS.t2264 107.451
R4810 VSS.t2541 VSS.n540 107.451
R4811 VSS.n1468 VSS.t1363 107.451
R4812 VSS.n1477 VSS.t178 107.451
R4813 VSS.t2551 VSS.t1399 107.451
R4814 VSS.n964 VSS.t376 107.451
R4815 VSS.t1308 VSS.n960 107.451
R4816 VSS.n701 VSS.t144 107.451
R4817 VSS.t1316 VSS.n657 107.451
R4818 VSS.t671 VSS.t381 107.451
R4819 VSS.n831 VSS.n827 107.451
R4820 VSS.t1291 VSS.t1259 107.451
R4821 VSS.n833 VSS.t660 107.451
R4822 VSS.n839 VSS.t1423 107.451
R4823 VSS.t1413 VSS.n813 107.451
R4824 VSS.n908 VSS.t1117 107.451
R4825 VSS.t1304 VSS.n894 107.451
R4826 VSS.t1171 VSS.t2470 107.451
R4827 VSS.t2421 VSS.n888 107.451
R4828 VSS.n916 VSS.t1168 107.451
R4829 VSS.t2281 VSS.n882 107.451
R4830 VSS.t106 VSS.t670 107.451
R4831 VSS.n1489 VSS.t1054 107.144
R4832 VSS.n1241 VSS.t1961 107.144
R4833 VSS.t2538 VSS.n611 107.144
R4834 VSS.t564 VSS.n590 107.144
R4835 VSS.t2504 VSS.t2417 107.144
R4836 VSS.n1376 VSS.t709 107.144
R4837 VSS.n1355 VSS.t1007 107.144
R4838 VSS.n635 VSS.t1230 107.144
R4839 VSS.t1247 VSS.n619 107.144
R4840 VSS.t2575 VSS.n753 107.144
R4841 VSS.n1029 VSS.t346 107.144
R4842 VSS.t736 VSS.t2629 107.144
R4843 VSS.n936 VSS.t835 107.144
R4844 VSS.t242 VSS.t1256 122.564
R4845 VSS.t2265 VSS.n793 107.144
R4846 VSS.n807 VSS.t43 107.144
R4847 VSS.n19 VSS.t242 4.69534
R4848 VSS.t2480 VSS.t1157 107.144
R4849 VSS.n929 VSS.t1158 107.144
R4850 VSS.t798 VSS.n10 105.852
R4851 VSS.t1578 VSS.n1189 104.168
R4852 VSS.n1231 VSS.t490 104.168
R4853 VSS.t861 VSS.n1175 104.168
R4854 VSS.n1302 VSS.t920 104.168
R4855 VSS.t2234 VSS.n1301 104.168
R4856 VSS.n1299 VSS.t302 104.168
R4857 VSS.t2331 VSS.n1326 104.168
R4858 VSS.n1324 VSS.t354 104.168
R4859 VSS.n712 VSS.t581 104.168
R4860 VSS.t955 VSS.n743 104.168
R4861 VSS.t1335 VSS.n866 104.168
R4862 VSS.n1184 VSS.t292 103.153
R4863 VSS.t2600 VSS.t276 103.153
R4864 VSS.t1027 VSS.t1209 103.153
R4865 VSS.t1759 VSS.t59 103.153
R4866 VSS.n1444 VSS.t475 103.153
R4867 VSS.t1535 VSS.t2248 103.153
R4868 VSS.t2250 VSS.n676 103.153
R4869 VSS.t409 VSS.t68 103.153
R4870 VSS.t1258 VSS.t1558 103.153
R4871 VSS.t804 VSS.t1160 103.153
R4872 VSS.t2488 VSS.t2052 102.858
R4873 VSS.t1052 VSS.n603 102.858
R4874 VSS.t2496 VSS.n1258 102.858
R4875 VSS.n1260 VSS.t860 102.858
R4876 VSS.t2332 VSS.n597 102.858
R4877 VSS.n1422 VSS.t386 102.858
R4878 VSS.t2338 VSS.t2602 102.858
R4879 VSS.t1321 VSS.t1480 102.858
R4880 VSS.t2270 VSS.t1529 102.858
R4881 VSS.n23 VSS.t2436 114.157
R4882 VSS.n781 VSS.t963 101.352
R4883 VSS.t1459 VSS.n770 101.352
R4884 VSS.t2386 VSS.t2396 100.001
R4885 VSS.t1899 VSS.t541 100.001
R4886 VSS.t1275 VSS.t1177 100.001
R4887 VSS.t2522 VSS.t421 100.001
R4888 VSS.t295 VSS.n529 98.8544
R4889 VSS.t2317 VSS.n1057 98.8544
R4890 VSS.n1066 VSS.t2392 98.8544
R4891 VSS.n1074 VSS.t1025 98.8544
R4892 VSS.t1478 VSS.n1106 98.8544
R4893 VSS.n1113 VSS.t202 98.8544
R4894 VSS.n1127 VSS.t223 98.8544
R4895 VSS.t1553 VSS.n569 98.8544
R4896 VSS.t1482 VSS.t1761 98.8544
R4897 VSS.t1763 VSS.t609 98.8544
R4898 VSS.t999 VSS.n535 98.8544
R4899 VSS.n1474 VSS.t502 98.8544
R4900 VSS.n947 VSS.t311 98.8544
R4901 VSS.t1104 VSS.n677 98.8544
R4902 VSS.n686 VSS.t977 98.8544
R4903 VSS.t1115 VSS.n671 98.8544
R4904 VSS.n690 VSS.t2307 98.8544
R4905 VSS.n695 VSS.t360 98.8544
R4906 VSS.n696 VSS.t238 98.8544
R4907 VSS.n698 VSS.t2319 98.8544
R4908 VSS.t1508 VSS.n661 98.8544
R4909 VSS.n700 VSS.t626 98.8544
R4910 VSS.n702 VSS.t924 98.8544
R4911 VSS.t439 VSS.n658 98.8544
R4912 VSS.t2608 VSS.n846 98.8544
R4913 VSS.n902 VSS.t697 98.8544
R4914 VSS.t996 VSS.n899 98.8544
R4915 VSS.t1170 VSS.t1615 98.8544
R4916 VSS.n905 VSS.t467 98.8544
R4917 VSS.t572 VSS.n895 98.8544
R4918 VSS.t2367 VSS.n443 98.5719
R4919 VSS.t2366 VSS.n438 98.5719
R4920 VSS.t2545 VSS.n437 98.5719
R4921 VSS.t1385 VSS.n1331 98.5719
R4922 VSS.t2461 VSS.n633 98.5719
R4923 VSS.t1556 VSS.n747 98.5719
R4924 VSS.n1027 VSS.t203 98.5719
R4925 VSS.n1034 VSS.t1404 98.5719
R4926 VSS.t1382 VSS.n725 98.5719
R4927 VSS.t1374 VSS.n789 98.5719
R4928 VSS.n928 VSS.t2434 98.5719
R4929 VSS.n929 VSS.t2308 98.5719
R4930 VSS.n225 VSS.t548 97.9912
R4931 VSS.n166 VSS.t573 97.9902
R4932 VSS.t2449 VSS.n1364 97.756
R4933 VSS.n124 VSS.t297 97.756
R4934 VSS.t62 VSS.t242 97.756
R4935 VSS.n505 VSS.t2488 97.755
R4936 VSS.n122 VSS.t1184 97.755
R4937 VSS.t950 VSS.n77 97.3687
R4938 VSS.n89 VSS.t939 97.9912
R4939 VSS.t916 VSS.n824 97.3687
R4940 VSS.t2352 VSS.n1423 97.1319
R4941 VSS.t2376 VSS.n1387 97.1319
R4942 VSS.n1377 VSS.t2294 97.1319
R4943 VSS.n119 VSS.t1462 97.1319
R4944 VSS.n128 VSS.t625 97.1319
R4945 VSS.n940 VSS.t2419 97.1319
R4946 VSS.t480 VSS.t282 95.8338
R4947 VSS.n1448 VSS.t979 95.8338
R4948 VSS.t1031 VSS.t1102 95.8338
R4949 VSS.n130 VSS.t2520 95.4761
R4950 VSS.t2435 VSS.n210 94.8359
R4951 VSS.t2393 VSS.t2411 94.5564
R4952 VSS.t1782 VSS.t1205 94.5564
R4953 VSS.t1568 VSS.t2252 94.5564
R4954 VSS.t1266 VSS.t200 94.5564
R4955 VSS.n849 VSS.t2610 94.5564
R4956 VSS.n921 VSS.t1129 94.5564
R4957 VSS.t1406 VSS.t2542 94.2862
R4958 VSS.t2202 VSS.t80 94.2862
R4959 VSS.t82 VSS.t1577 94.2862
R4960 VSS.t911 VSS.n64 93.4693
R4961 VSS.n40 VSS.t746 92.8462
R4962 VSS.n1423 VSS.t2211 92.8462
R4963 VSS.n1081 VSS.t1196 90.2584
R4964 VSS.n1115 VSS.t1216 90.2584
R4965 VSS.n1442 VSS.t1212 90.2584
R4966 VSS.t1205 VSS.n1449 90.2584
R4967 VSS.n1472 VSS.t592 90.2584
R4968 VSS.t45 VSS.n681 90.2584
R4969 VSS.n823 VSS.t1139 90.2584
R4970 VSS.n815 VSS.t925 90.2584
R4971 VSS.t1131 VSS.n891 90.2584
R4972 VSS.t1129 VSS.n882 90.2584
R4973 VSS.n1164 VSS.t1203 90.0005
R4974 VSS.n1251 VSS.t1217 90.0005
R4975 VSS.t2222 VSS.n592 90.0005
R4976 VSS.t972 VSS.t1021 90.0005
R4977 VSS.t2333 VSS.t335 90.0005
R4978 VSS.t2361 VSS.n1309 90.0005
R4979 VSS.t1197 VSS.n1403 90.0005
R4980 VSS.n1379 VSS.t763 90.0005
R4981 VSS.t2362 VSS.n1359 90.0005
R4982 VSS.t754 VSS.t1329 90.0005
R4983 VSS.t923 VSS.n739 90.0005
R4984 VSS.t862 VSS.n717 90.0005
R4985 VSS.t1125 VSS.n938 90.0005
R4986 VSS.t1272 VSS.n878 90.0005
R4987 VSS.n277 VSS.t493 3.40963
R4988 VSS.t59 VSS.n1436 89.3952
R4989 VSS.t742 VSS.t271 89.3942
R4990 VSS.t242 VSS.t577 89.1846
R4991 VSS.t1296 VSS.n191 89.1846
R4992 VSS.n134 VSS.t131 89.1836
R4993 VSS.n239 VSS.t2214 88.7727
R4994 VSS.n245 VSS.t361 88.7727
R4995 VSS.t2481 VSS.n245 88.7727
R4996 VSS.n92 VSS.t614 88.7727
R4997 VSS.n174 VSS.t1548 88.7727
R4998 VSS.n179 VSS.t635 88.7727
R4999 VSS.n197 VSS.t2463 88.7727
R5000 VSS.t259 VSS.n1400 88.563
R5001 VSS.n112 VSS.t436 88.563
R5002 VSS.n194 VSS.t1163 88.563
R5003 VSS.t2280 VSS.n41 88.5605
R5004 VSS.n42 VSS.t2536 88.5605
R5005 VSS.t1012 VSS.n61 88.5605
R5006 VSS.n62 VSS.t1087 88.5605
R5007 VSS.n51 VSS.t2260 88.5605
R5008 VSS.n1387 VSS.t2201 88.5605
R5009 VSS.t440 VSS.n1380 88.5605
R5010 VSS.n1371 VSS.t2385 88.5605
R5011 VSS.t1355 VSS.n119 88.5605
R5012 VSS.n1285 VSS.t25 87.8666
R5013 VSS.t541 VSS.n46 87.1423
R5014 VSS.t242 VSS.n26 3.41984
R5015 VSS.t2195 VSS.n1191 86.5025
R5016 VSS.t499 VSS.n640 86.5025
R5017 VSS.n129 VSS.t783 86.5025
R5018 VSS.t2513 VSS.n195 86.5025
R5019 VSS.n189 VSS.t2295 86.5025
R5020 VSS.n214 VSS.t104 86.5025
R5021 VSS.n1205 VSS.t729 85.9604
R5022 VSS.t278 VSS.n1211 85.9604
R5023 VSS.t893 VSS.n1292 85.9604
R5024 VSS.n1151 VSS.t2507 85.9604
R5025 VSS.t738 VSS.t959 85.9604
R5026 VSS.t802 VSS.n1443 85.9604
R5027 VSS.n1450 VSS.t2229 85.9604
R5028 VSS.t405 VSS.n1473 85.9604
R5029 VSS.t794 VSS.n954 85.9604
R5030 VSS.t1153 VSS.n820 85.9604
R5031 VSS.t1301 VSS.n890 85.9604
R5032 VSS.t255 VSS.n1161 85.7148
R5033 VSS.n1252 VSS.t701 85.7148
R5034 VSS.n1311 VSS.t2212 85.7148
R5035 VSS.t208 VSS.t604 85.7148
R5036 VSS.t842 VSS.n1339 85.7148
R5037 VSS.t869 VSS.t1243 85.7148
R5038 VSS.t213 VSS.n619 85.7148
R5039 VSS.t337 VSS.n719 85.7148
R5040 VSS.n941 VSS.t1264 85.7148
R5041 VSS.n83 VSS.t177 85.2094
R5042 VSS.n142 VSS.t676 85.2084
R5043 VSS.t175 VSS.n118 84.5541
R5044 VSS.n1232 VSS.t712 83.3338
R5045 VSS.t2297 VSS.n1281 83.3338
R5046 VSS.t2445 VSS.n1144 83.3338
R5047 VSS.t1276 VSS.n881 83.3338
R5048 VSS.t2523 VSS.n870 83.3338
R5049 VSS.t2427 VSS.n992 83.3338
R5050 VSS.t2076 VSS.n7 43.2549
R5051 VSS.t2091 VSS.n7 43.2554
R5052 VSS.t2096 VSS.n7 43.2547
R5053 VSS.t2111 VSS.n7 43.2547
R5054 VSS.t2121 VSS.n7 43.2547
R5055 VSS.t2136 VSS.n7 43.2547
R5056 VSS.t2146 VSS.n7 43.2554
R5057 VSS.n7 VSS.t2161 43.2547
R5058 VSS.n7 VSS.t2171 43.2554
R5059 VSS.n7 VSS.t2181 43.2547
R5060 VSS.t1221 VSS.t319 81.6624
R5061 VSS.n1067 VSS.t2399 81.6624
R5062 VSS.n1115 VSS.t764 81.6624
R5063 VSS.n1117 VSS.t611 81.6624
R5064 VSS.n565 VSS.t2627 81.6624
R5065 VSS.n1475 VSS.t405 81.6624
R5066 VSS.n963 VSS.t1497 81.6624
R5067 VSS.t2631 VSS.n959 81.6624
R5068 VSS.t1307 VSS.n956 81.6624
R5069 VSS.n692 VSS.t622 81.6624
R5070 VSS.t1510 VSS.n666 81.6624
R5071 VSS.n697 VSS.t1069 81.6624
R5072 VSS.t1421 VSS.n659 81.6624
R5073 VSS.n840 VSS.t1424 81.6624
R5074 VSS.n918 VSS.t2282 81.6624
R5075 VSS.t2487 VSS.n471 81.4291
R5076 VSS.n1264 VSS.t250 81.4291
R5077 VSS.t1467 VSS.n1314 81.4291
R5078 VSS.t1584 VSS.t2441 81.4291
R5079 VSS.t741 VSS.n1369 81.4291
R5080 VSS.n630 VSS.t1246 81.4291
R5081 VSS.t998 VSS.n763 81.4291
R5082 VSS.n1015 VSS.t1340 81.4291
R5083 VSS.n1015 VSS.t808 81.4291
R5084 VSS.t2416 VSS.n759 81.4291
R5085 VSS.t233 VSS.n758 81.4291
R5086 VSS.t1289 VSS.n755 81.4291
R5087 VSS.n1021 VSS.t1411 81.4291
R5088 VSS.n752 VSS.t1486 81.4291
R5089 VSS.t1347 VSS.n750 81.4291
R5090 VSS.n1025 VSS.t1020 81.4291
R5091 VSS.t415 VSS.n748 81.4291
R5092 VSS.n1047 VSS.t448 81.4291
R5093 VSS.t63 VSS.n791 81.4291
R5094 VSS.n804 VSS.t2309 81.4291
R5095 VSS.t1295 VSS.t2428 81.4291
R5096 VSS.t1144 VSS.t1342 81.0816
R5097 VSS.n25 VSS.t824 63.0796
R5098 VSS.t73 VSS.n74 80.7982
R5099 VSS.n165 VSS.t1543 80.7982
R5100 VSS.n204 VSS.t1169 80.7982
R5101 VSS.n137 VSS.t1191 80.6131
R5102 VSS.t1111 VSS.t242 80.6131
R5103 VSS.t2196 VSS.n1402 80.6121
R5104 VSS.n131 VSS.t1081 80.6121
R5105 VSS.n211 VSS.t2423 80.6121
R5106 VSS.t2601 VSS.n224 80.1767
R5107 VSS.n81 VSS.t1514 80.1767
R5108 VSS.t130 VSS.n174 80.1767
R5109 VSS.n824 VSS.t1151 80.1767
R5110 VSS.n208 VSS.t1277 80.1767
R5111 VSS.t2079 VSS.n7 43.5664
R5112 VSS.t2109 VSS.n7 43.5666
R5113 VSS.t2134 VSS.n7 43.5666
R5114 VSS.t2159 VSS.n7 43.5666
R5115 VSS.t2179 VSS.n7 43.5666
R5116 VSS.n7 VSS.t2069 43.5286
R5117 VSS.n7 VSS.t2194 43.5664
R5118 VSS.n61 VSS.t100 79.9891
R5119 VSS.t883 VSS.n51 79.9891
R5120 VSS.n1380 VSS.t2347 79.9891
R5121 VSS.t2215 VSS.n1358 79.9891
R5122 VSS.n1343 VSS.t892 79.9891
R5123 VSS.n1325 VSS.t353 79.1672
R5124 VSS.t623 VSS.n636 79.1672
R5125 VSS.t783 VSS.t1183 79.1672
R5126 VSS.n1286 VSS.t686 78.4358
R5127 VSS.n1185 VSS.t2589 77.3644
R5128 VSS.n1078 VSS.t287 77.3644
R5129 VSS.t1094 VSS.t1350 77.3644
R5130 VSS.n1452 VSS.t1482 77.3644
R5131 VSS.t1452 VSS.n549 77.3644
R5132 VSS.n684 VSS.t617 77.3644
R5133 VSS.t2191 VSS.n7 43.2547
R5134 VSS.t2186 VSS.n7 43.2554
R5135 VSS.n7 VSS.t2184 43.5666
R5136 VSS.t2176 VSS.n7 43.2547
R5137 VSS.n7 VSS.t2174 43.5659
R5138 VSS.t2166 VSS.n7 43.2547
R5139 VSS.n7 VSS.t2164 43.5666
R5140 VSS.n7 VSS.t2156 43.2547
R5141 VSS.n7 VSS.t2151 43.2554
R5142 VSS.t2149 VSS.n7 43.5659
R5143 VSS.n7 VSS.t2141 43.2554
R5144 VSS.t2139 VSS.n7 43.5666
R5145 VSS.n7 VSS.t2131 43.2547
R5146 VSS.n7 VSS.t2126 43.2554
R5147 VSS.t2124 VSS.n7 43.5666
R5148 VSS.n7 VSS.t2116 43.2554
R5149 VSS.t2114 VSS.n7 43.5666
R5150 VSS.n7 VSS.t2106 43.2547
R5151 VSS.n7 VSS.t2101 43.2554
R5152 VSS.t2099 VSS.n7 43.5666
R5153 VSS.t2094 VSS.n7 43.5659
R5154 VSS.n7 VSS.t2086 43.2554
R5155 VSS.t2081 VSS.n7 43.2556
R5156 VSS.t2071 VSS.n7 43.2556
R5157 VSS.n8 VSS.t2066 42.5716
R5158 VSS.n600 VSS.t2489 77.1434
R5159 VSS.n1263 VSS.t687 77.1434
R5160 VSS.n1267 VSS.t772 77.1434
R5161 VSS.t2455 VSS.t552 77.1434
R5162 VSS.n1421 VSS.t2455 77.1434
R5163 VSS.n1390 VSS.t1466 77.1434
R5164 VSS.t2391 VSS.n1373 77.1434
R5165 VSS.n1019 VSS.t754 77.1434
R5166 VSS.t2288 VSS.t53 77.1434
R5167 VSS.t1550 VSS.t1188 77.1434
R5168 VSS.t449 VSS.t989 77.1434
R5169 VSS.n780 VSS.n771 77.0275
R5170 VSS.t271 VSS.t2570 76.5012
R5171 VSS.t6 VSS.n97 76.5012
R5172 VSS.n166 VSS.t1331 76.5012
R5173 VSS.t586 VSS.n1338 76.3274
R5174 VSS.n135 VSS.t1333 76.3264
R5175 VSS.t2411 VSS.n1210 75.8787
R5176 VSS.t187 VSS.n76 75.8787
R5177 VSS.t810 VSS.n39 75.7034
R5178 VSS.n103 VSS.t1389 75.7034
R5179 VSS.n31 VSS.t1107 76.0589
R5180 VSS.t332 VSS.t149 75.0005
R5181 VSS.n646 VSS.t332 75.0005
R5182 VSS.n853 VSS.t1239 74.0025
R5183 VSS.n209 VSS.t1164 74.0025
R5184 VSS.n215 VSS.t2516 74.0025
R5185 VSS.t559 VSS.n1196 73.0664
R5186 VSS.n1217 VSS.t377 73.0664
R5187 VSS.n1349 VSS.t724 73.0664
R5188 VSS.t2405 VSS.n1073 73.0664
R5189 VSS.n1110 VSS.t2527 73.0664
R5190 VSS.t247 VSS.t2501 73.0664
R5191 VSS.n1123 VSS.t666 73.0664
R5192 VSS.n1124 VSS.t2259 73.0664
R5193 VSS.t536 VSS.n1092 73.0664
R5194 VSS.t560 VSS.n1087 73.0664
R5195 VSS.n1132 VSS.t2494 73.0664
R5196 VSS.n1134 VSS.t555 73.0664
R5197 VSS.t2410 VSS.n1082 73.0664
R5198 VSS.t489 VSS.n1136 73.0664
R5199 VSS.n563 VSS.t2621 73.0664
R5200 VSS.t219 VSS.n554 73.0664
R5201 VSS.n566 VSS.t1029 73.0664
R5202 VSS.t621 VSS.n947 73.0664
R5203 VSS.n965 VSS.t1560 73.0664
R5204 VSS.n972 VSS.t1309 73.0664
R5205 VSS.t495 VSS.n714 73.0664
R5206 VSS.t1476 VSS.n817 73.0664
R5207 VSS.n835 VSS.t2236 73.0664
R5208 VSS.n837 VSS.t1431 73.0664
R5209 VSS.t1430 VSS.n845 73.0664
R5210 VSS.t399 VSS.n902 73.0664
R5211 VSS.t1118 VSS.n896 73.0664
R5212 VSS.t368 VSS.n894 73.0664
R5213 VSS.t2438 VSS.n890 73.0664
R5214 VSS.t1298 VSS.n887 73.0664
R5215 VSS.n916 VSS.t2466 73.0664
R5216 VSS.t2557 VSS.n437 72.8576
R5217 VSS.n1489 VSS.t2381 72.8576
R5218 VSS.t2263 VSS.n607 72.8576
R5219 VSS.n1314 VSS.t1028 72.8576
R5220 VSS.t2357 VSS.n1410 72.8576
R5221 VSS.t1084 VSS.n1414 72.8576
R5222 VSS.t743 VSS.n1428 72.8576
R5223 VSS.t2560 VSS.n1336 72.8576
R5224 VSS.t347 VSS.n1330 72.8576
R5225 VSS.t1323 VSS.n767 72.8576
R5226 VSS.n1012 VSS.t1311 72.8576
R5227 VSS.t1224 VSS.n746 72.8576
R5228 VSS.n1044 VSS.t442 72.8576
R5229 VSS.t1398 VSS.n723 72.8576
R5230 VSS.n797 VSS.t1393 72.8576
R5231 VSS.n800 VSS.t64 72.8576
R5232 VSS.n803 VSS.t2272 72.8576
R5233 VSS.t1252 VSS.n786 72.8576
R5234 VSS.n809 VSS.t184 72.8576
R5235 VSS.t493 VSS.t2292 72.2269
R5236 VSS.t271 VSS.t728 72.2032
R5237 VSS.t957 VSS.n229 72.2032
R5238 VSS.t674 VSS.t1320 72.0656
R5239 VSS.n126 VSS.t982 72.0407
R5240 VSS.n136 VSS.t338 72.0407
R5241 VSS.t404 VSS.n96 71.5807
R5242 VSS.t2287 VSS.n164 72.2032
R5243 VSS.t2290 VSS.n207 71.5807
R5244 VSS.t973 VSS.n1368 71.4177
R5245 VSS.n1360 VSS.t2447 71.4177
R5246 VSS.t841 VSS.n1341 71.4177
R5247 VSS.n114 VSS.t980 71.4177
R5248 VSS.n1228 VSS.t355 70.8338
R5249 VSS.t890 VSS.n1177 70.8338
R5250 VSS.n1175 VSS.t694 70.8338
R5251 VSS.n1301 VSS.t325 70.8338
R5252 VSS.t334 VSS.n1299 70.8338
R5253 VSS.t1573 VSS.n1282 70.8338
R5254 VSS.n1278 VSS.t480 70.8338
R5255 VSS.t823 VSS.n1145 70.8338
R5256 VSS.n637 VSS.t1180 70.8338
R5257 VSS.t1534 VSS.t499 70.8338
R5258 VSS.t857 VSS.n651 70.8338
R5259 VSS.n711 VSS.t567 70.8338
R5260 VSS.t630 VSS.n710 70.8338
R5261 VSS.n852 VSS.t1432 70.8338
R5262 VSS.t1287 VSS.n866 70.8338
R5263 VSS.n930 VSS.t1294 70.8338
R5264 VSS.t2295 VSS.t1159 70.8338
R5265 VSS.t1391 VSS.n993 70.8338
R5266 VSS.n989 VSS.t1031 70.8338
R5267 VSS.n1230 VSS.t711 69.8359
R5268 VSS.t1342 VSS.n1007 68.9194
R5269 VSS.t716 VSS.t152 68.7684
R5270 VSS.t2546 VSS.t469 68.7684
R5271 VSS.t1388 VSS.t968 68.7684
R5272 VSS.n699 VSS.t1477 68.7684
R5273 VSS.t2283 VSS.t1420 68.5719
R5274 VSS.t1265 VSS.t1530 68.5719
R5275 VSS.t1109 VSS.t466 68.5719
R5276 VSS.n1486 VSS.t798 68.1529
R5277 VSS.t1009 VSS.n100 67.4344
R5278 VSS.t705 VSS.n139 67.4344
R5279 VSS.t276 VSS.n1216 67.2827
R5280 VSS.n1224 VSS.t2539 67.2827
R5281 VSS.t879 VSS.n58 67.2827
R5282 VSS.t2344 VSS.n1291 67.2827
R5283 VSS.t815 VSS.n243 67.2827
R5284 VSS.n643 VSS.t1535 67.2827
R5285 VSS.t1364 VSS.n104 67.2827
R5286 VSS.n271 VSS.t1541 67.2827
R5287 VSS.n829 VSS.t1258 67.2827
R5288 VSS.t1160 VSS.n188 67.2827
R5289 VSS.n1193 VSS.t1220 66.6672
R5290 VSS.t20 VSS.n1226 66.6672
R5291 VSS.t38 VSS.t41 66.6672
R5292 VSS.n1445 VSS.t1201 66.6672
R5293 VSS.t128 VSS.t928 66.6672
R5294 VSS.t392 VSS.t871 66.6672
R5295 VSS.t428 VSS.n850 66.6672
R5296 VSS.t92 VSS.t865 66.6672
R5297 VSS.t1177 VSS.n921 66.6672
R5298 VSS.n1003 VSS.t421 66.6672
R5299 VSS.t597 VSS.t603 66.5534
R5300 VSS.t2360 VSS.t2363 66.5534
R5301 VSS.n1476 VSS.t8 64.8654
R5302 VSS.t1142 VSS.t1144 64.8654
R5303 VSS.t588 VSS.t1274 64.8654
R5304 VSS.t2594 VSS.t792 64.4704
R5305 VSS.t818 VSS.n1203 64.4704
R5306 VSS.t844 VSS.n1080 64.4704
R5307 VSS.n566 VSS.t655 64.4704
R5308 VSS.t1073 VSS.n551 64.4704
R5309 VSS.t1046 VSS.n535 64.4704
R5310 VSS.t1005 VSS.t494 64.4704
R5311 VSS.n816 VSS.t112 64.4704
R5312 VSS.t2209 VSS.n1162 64.2862
R5313 VSS.t2505 VSS.n606 64.2862
R5314 VSS.n1261 VSS.t1077 64.2862
R5315 VSS.t2388 VSS.n1417 64.2862
R5316 VSS.n1361 VSS.t992 64.2862
R5317 VSS.n628 VSS.t769 64.2862
R5318 VSS.t1113 VSS.t1148 64.2862
R5319 VSS.t719 VSS.n1227 62.5005
R5320 VSS.t579 VSS.t314 62.5005
R5321 VSS.t353 VSS.t902 62.5005
R5322 VSS.t354 VSS.t2595 62.5005
R5323 VSS.n1200 VSS.t771 60.1724
R5324 VSS.t2570 VSS.t2382 60.1724
R5325 VSS.t275 VSS.n1214 60.1724
R5326 VSS.t817 VSS.n1069 60.1724
R5327 VSS.t739 VSS.n1150 60.1724
R5328 VSS.n1114 VSS.t607 60.1724
R5329 VSS.t800 VSS.n1101 60.1724
R5330 VSS.n1441 VSS.t3 60.1724
R5331 VSS.n1455 VSS.t157 60.1724
R5332 VSS.n1471 VSS.t965 60.1724
R5333 VSS.t494 VSS.n957 60.1724
R5334 VSS.t320 VSS.n951 60.1724
R5335 VSS.t1259 VSS.n826 60.1724
R5336 VSS.t1286 VSS.n819 60.1724
R5337 VSS.n846 VSS.t629 60.1724
R5338 VSS.t1133 VSS.t572 60.1724
R5339 VSS.t1303 VSS.n892 60.1724
R5340 VSS.n913 VSS.t1299 60.1724
R5341 VSS.n918 VSS.t1167 60.1724
R5342 VSS.t540 VSS.t561 60.0005
R5343 VSS.t2452 VSS.n20 68.6832
R5344 VSS.n1242 VSS.t2394 60.0005
R5345 VSS.n1249 VSS.t2342 60.0005
R5346 VSS.n1306 VSS.t828 60.0005
R5347 VSS.n1401 VSS.t365 60.0005
R5348 VSS.n1363 VSS.t877 60.0005
R5349 VSS.n1356 VSS.t2202 60.0005
R5350 VSS.t1577 VSS.n1345 60.0005
R5351 VSS.t1366 VSS.n623 60.0005
R5352 VSS.t1515 VSS.t1240 60.0005
R5353 VSS.t1501 VSS.n741 60.0005
R5354 VSS.t704 VSS.n716 60.0005
R5355 VSS.n937 VSS.t1113 60.0005
R5356 VSS.t2278 VSS.n879 60.0005
R5357 VSS.n927 VSS.t2429 60.0005
R5358 VSS.t1470 VSS.n168 58.6867
R5359 VSS.t1071 VSS.n180 58.6867
R5360 VSS.t2372 VSS.n1229 58.3338
R5361 VSS.n1233 VSS.t2198 58.3338
R5362 VSS.t2343 VSS.n1280 58.3338
R5363 VSS.t886 VSS.n1143 58.3338
R5364 VSS.t1032 VSS.n991 58.3338
R5365 VSS.t2436 VSS.n10 57.5142
R5366 VSS.t94 VSS.t921 55.8744
R5367 VSS.t280 VSS.n1213 55.8744
R5368 VSS.n1237 VSS.t529 55.8744
R5369 VSS.t2400 VSS.n1061 55.8744
R5370 VSS.t2506 VSS.n1079 55.8744
R5371 VSS.t85 VSS.n1100 55.8744
R5372 VSS.n1121 VSS.t1093 55.8744
R5373 VSS.t223 VSS.t557 55.8744
R5374 VSS.n150 VSS.t2228 72.2022
R5375 VSS.t2626 VSS.n554 55.8744
R5376 VSS.t2205 VSS.t1490 55.8744
R5377 VSS.n968 VSS.t793 55.8744
R5378 VSS.t981 VSS.n663 55.8744
R5379 VSS.n841 VSS.t1425 55.8744
R5380 VSS.t1453 VSS.n814 55.8744
R5381 VSS.n912 VSS.t1300 55.8744
R5382 VSS.n495 VSS.t290 55.7148
R5383 VSS.t257 VSS.n1163 55.7148
R5384 VSS.t700 VSS.n605 55.7148
R5385 VSS.n1270 VSS.t2335 55.7148
R5386 VSS.n1310 VSS.t2213 55.7148
R5387 VSS.n1404 VSS.t2482 55.7148
R5388 VSS.t775 VSS.t2483 55.7148
R5389 VSS.t1000 VSS.t2231 55.7148
R5390 VSS.t612 VSS.t2391 55.7148
R5391 VSS.n629 VSS.t212 55.7148
R5392 VSS.t1245 VSS.n620 55.7148
R5393 VSS.t397 VSS.n761 55.7148
R5394 VSS.n143 VSS.t2289 69.9663
R5395 VSS.n1022 VSS.t2288 55.7148
R5396 VSS.t986 VSS.n751 55.7148
R5397 VSS.t77 VSS.n749 55.7148
R5398 VSS.n1032 VSS.t371 55.7148
R5399 VSS.t372 VSS.t1231 55.7148
R5400 VSS.t414 VSS.t1524 55.7148
R5401 VSS.t447 VSS.n721 55.7148
R5402 VSS.n939 VSS.t1265 55.7148
R5403 VSS.t2267 VSS.n792 55.7148
R5404 VSS.n926 VSS.t2424 55.7148
R5405 VSS.t2425 VSS.t1281 55.7148
R5406 VSS.t61 VSS.n98 55.0112
R5407 VSS.n183 VSS.t1249 55.0112
R5408 VSS.n203 VSS.t370 55.0112
R5409 VSS.n1436 VSS.t1210 55.0102
R5410 VSS.n87 VSS.t146 55.0102
R5411 VSS.n183 VSS.t1513 55.0102
R5412 VSS.n203 VSS.t1128 55.0102
R5413 VSS.n143 VSS.t674 2.10019
R5414 VSS.n525 VSS.t2339 54.8988
R5415 VSS.n518 VSS.t891 54.8979
R5416 VSS.t1581 VSS.n1416 54.8979
R5417 VSS.t2428 VSS.n192 54.8979
R5418 VSS.t2433 VSS.n191 54.8979
R5419 VSS.t2296 VSS.n1284 54.3938
R5420 VSS.n530 VSS.t2329 54.3887
R5421 VSS.t1198 VSS.n1195 54.3887
R5422 VSS.n77 VSS.t2316 54.3887
R5423 VSS.n163 VSS.t1120 54.3887
R5424 VSS.t1447 VSS.n172 54.3887
R5425 VSS.n180 VSS.t1386 54.3887
R5426 VSS.t995 VSS.n201 54.3887
R5427 VSS.n202 VSS.t574 54.3887
R5428 VSS.t1126 VSS.n205 54.3887
R5429 VSS.n442 VSS.t2358 54.2748
R5430 VSS.n50 VSS.t298 54.2748
R5431 VSS.n1326 VSS.t352 54.1672
R5432 VSS.n922 VSS.t1275 54.1672
R5433 VSS.n1001 VSS.t2522 54.1672
R5434 VSS.t1218 VSS.n46 53.8079
R5435 VSS.t242 VSS.t866 53.8079
R5436 VSS.t12 VSS.n1230 53.1692
R5437 VSS.n1176 VSS.t40 53.1692
R5438 VSS.t2364 VSS.n55 53.1692
R5439 VSS.n56 VSS.t33 53.1692
R5440 VSS.t870 VSS.n270 53.1692
R5441 VSS.t427 VSS.n853 53.1692
R5442 VSS.n190 VSS.t425 53.1692
R5443 VSS.n142 VSS.t1273 52.777
R5444 VSS.n83 VSS.t32 52.776
R5445 VSS.n118 VSS.t1122 52.1217
R5446 VSS.n776 VSS.t1445 51.7246
R5447 VSS.t1494 VSS.n773 51.7246
R5448 VSS.n1197 VSS.t770 51.5764
R5449 VSS.n1236 VSS.t2511 51.5764
R5450 VSS.t1588 VSS.n1170 51.5764
R5451 VSS.n1247 VSS.t2341 51.5764
R5452 VSS.t252 VSS.n1275 51.5764
R5453 VSS.n1398 VSS.t364 51.5764
R5454 VSS.t1576 VSS.n1348 51.5764
R5455 VSS.t2563 VSS.n1070 51.5764
R5456 VSS.t606 VSS.n1103 51.5764
R5457 VSS.t550 VSS.t874 51.5764
R5458 VSS.t1088 VSS.t1479 51.5764
R5459 VSS.t888 VSS.t2346 51.5764
R5460 VSS.t2384 VSS.n1138 51.5764
R5461 VSS.n1439 VSS.t1 51.5764
R5462 VSS.n1453 VSS.t496 51.5764
R5463 VSS.t721 VSS.n547 51.5764
R5464 VSS.t296 VSS.t1349 51.5764
R5465 VSS.t971 VSS.n546 51.5764
R5466 VSS.n1470 VSS.t964 51.5764
R5467 VSS.t492 VSS.n959 51.5764
R5468 VSS.t2632 VSS.n655 51.5764
R5469 VSS.n933 VSS.t1114 51.5764
R5470 VSS.n859 VSS.t1018 51.5764
R5471 VSS.t241 VSS.n864 51.5764
R5472 VSS.t1302 VSS.n893 51.5764
R5473 VSS.n917 VSS.t1166 51.5764
R5474 VSS.t2277 VSS.n880 51.5764
R5475 VSS.n997 VSS.t2431 51.5764
R5476 VSS.t2620 VSS.n986 51.5764
R5477 VSS.t1991 VSS.t2039 51.4291
R5478 VSS.t2041 VSS.t1993 51.4291
R5479 VSS.t1998 VSS.t2049 51.4291
R5480 VSS.t2225 VSS.t1886 51.4291
R5481 VSS.n1391 VSS.t2448 51.4291
R5482 VSS.t486 VSS.n1372 51.4291
R5483 VSS.t505 VSS.t787 51.4291
R5484 VSS.n1352 VSS.n1351 51.195
R5485 VSS.n1353 VSS.n1352 51.195
R5486 VSS.t959 VSS.n232 50.7132
R5487 VSS.t221 VSS.n91 50.7122
R5488 VSS.t2233 VSS.t2296 50.2097
R5489 VSS.n1209 VSS.t688 50.0907
R5490 VSS.n168 VSS.t322 50.0907
R5491 VSS.t732 VSS.t349 50.0005
R5492 VSS.n1149 VSS.n1147 50.0005
R5493 VSS.n647 VSS.t244 50.0005
R5494 VSS.n1000 VSS.n995 50.0005
R5495 VSS.t1806 VSS.t814 47.2784
R5496 VSS.n1154 VSS.t2404 47.2784
R5497 VSS.n1119 VSS.t550 47.2784
R5498 VSS.n1120 VSS.t1089 47.2784
R5499 VSS.t551 VSS.n1097 47.2784
R5500 VSS.t151 VSS.t110 47.2784
R5501 VSS.t2622 VSS.n555 47.2784
R5502 VSS.t517 VSS.n538 47.2784
R5503 VSS.t522 VSS.n536 47.2784
R5504 VSS.t1474 VSS.n678 47.2784
R5505 VSS.t459 VSS.n672 47.2784
R5506 VSS.t506 VSS.n658 47.2784
R5507 VSS.n707 VSS.t785 47.2784
R5508 VSS.t1500 VSS.t672 47.2784
R5509 VSS.t1427 VSS.t628 47.2784
R5510 VSS.t1429 VSS.n844 47.2784
R5511 VSS.n502 VSS.t2498 47.1434
R5512 VSS.n1257 VSS.t2484 47.1434
R5513 VSS.t758 VSS.n596 47.1434
R5514 VSS.t2485 VSS.n1408 47.1434
R5515 VSS.t329 VSS.t2446 47.1434
R5516 VSS.t1241 VSS.n622 47.1434
R5517 VSS.t1414 VSS.n762 47.1434
R5518 VSS.n1024 VSS.t401 47.1434
R5519 VSS.n1033 VSS.t510 47.1434
R5520 VSS.n1035 VSS.t505 47.1434
R5521 VSS.t509 VSS.n733 47.1434
R5522 VSS.t507 VSS.n730 47.1434
R5523 VSS.t508 VSS.n729 47.1434
R5524 VSS.n1041 VSS.t511 47.1434
R5525 VSS.t443 VSS.n723 47.1434
R5526 VSS.t2271 VSS.n790 47.1434
R5527 VSS.t57 VSS.n782 47.1434
R5528 VSS.n1303 VSS.t993 45.8338
R5529 VSS.t348 VSS.n1329 45.8338
R5530 VSS.t1164 VSS.t2279 45.8338
R5531 VSS.t2516 VSS.t806 45.8338
R5532 VSS.n1222 VSS.t205 45.802
R5533 VSS.t2568 VSS.n27 46.0411
R5534 VSS.n1210 VSS.t988 45.7928
R5535 VSS.n1216 VSS.t1387 45.7928
R5536 VSS.n53 VSS.t859 45.7928
R5537 VSS.t1601 VSS.n246 45.7928
R5538 VSS.t2346 VSS.n233 45.7928
R5539 VSS.n218 VSS.t173 45.7928
R5540 VSS.n234 VSS.t822 45.7928
R5541 VSS.t1399 VSS.n643 45.7928
R5542 VSS.n170 VSS.t608 45.7928
R5543 VSS.t381 VSS.n829 45.7928
R5544 VSS.t665 VSS.n822 45.7928
R5545 VSS.n832 VSS.t727 45.7928
R5546 VSS.n185 VSS.t852 45.7928
R5547 VSS.n188 VSS.t106 45.7928
R5548 VSS.t843 VSS.n37 45.7034
R5549 VSS.n49 VSS.t2311 45.7034
R5550 VSS.t876 VSS.n1384 45.7034
R5551 VSS.n1383 VSS.t2531 45.7034
R5552 VSS.t1456 VSS.n120 45.7034
R5553 VSS.t1318 VSS.n121 45.7034
R5554 VSS.t1250 VSS.n15 45.7034
R5555 VSS.n17 VSS.t1156 45.7034
R5556 VSS.t115 VSS.n17 45.7034
R5557 VSS.t1516 VSS.n129 44.8359
R5558 VSS.t2530 VSS.n213 44.8359
R5559 VSS.t792 VSS.n1181 42.9804
R5560 VSS.n1202 VSS.t2226 42.9804
R5561 VSS.t994 VSS.n1322 42.9804
R5562 VSS.n1128 VSS.t1070 42.9804
R5563 VSS.n1461 VSS.t1024 42.9804
R5564 VSS.t231 VSS.n543 42.9804
R5565 VSS.n1467 VSS.t1193 42.9804
R5566 VSS.n974 VSS.t321 42.9804
R5567 VSS.n703 VSS.t137 42.9804
R5568 VSS.n998 VSS.t1442 42.9804
R5569 VSS.t2336 VSS.n464 42.8576
R5570 VSS.n522 VSS.t1332 42.8576
R5571 VSS.t679 VSS.n435 42.8576
R5572 VSS.t100 VSS.t974 42.8576
R5573 VSS.t2213 VSS.t299 42.8576
R5574 VSS.t1225 VSS.n1335 42.8576
R5575 VSS.t133 VSS.n734 42.8576
R5576 VSS.t2309 VSS.t1375 42.8576
R5577 VSS.t2326 VSS.n91 42.1172
R5578 VSS.t1182 VSS.n1289 41.8415
R5579 VSS.t2345 VSS.t87 41.8415
R5580 VSS.n1188 VSS.t2386 41.6672
R5581 VSS.t314 VSS.n1298 41.6672
R5582 VSS.n1447 VSS.t328 41.6672
R5583 VSS.t1314 VSS.n857 41.6672
R5584 VSS.n243 VSS.t537 41.4948
R5585 VSS.n181 VSS.t1267 41.4948
R5586 VSS.t733 VSS.n1371 41.4177
R5587 VSS.t1048 VSS.n23 27.6106
R5588 VSS.t23 VSS.n1293 39.8075
R5589 VSS.n1219 VSS.t2370 38.6824
R5590 VSS.t1057 VSS.n1064 38.6824
R5591 VSS.n1076 VSS.t1202 38.6824
R5592 VSS.n1110 VSS.t1593 38.6824
R5593 VSS.n1111 VSS.t1213 38.6824
R5594 VSS.t102 VSS.n1103 38.6824
R5595 VSS.t202 VSS.t944 38.6824
R5596 VSS.t1571 VSS.n1091 38.6824
R5597 VSS.t801 VSS.t217 38.6824
R5598 VSS.n1444 VSS.n571 38.6824
R5599 VSS.t1450 VSS.n552 38.6824
R5600 VSS.t594 VSS.n539 38.6824
R5601 VSS.n1472 VSS.t2618 38.6824
R5602 VSS.n625 VSS.t2327 38.6824
R5603 VSS.n948 VSS.t734 38.6824
R5604 VSS.n684 VSS.t1310 38.6824
R5605 VSS.t1532 VSS.n675 38.6824
R5606 VSS.n704 VSS.n674 38.6824
R5607 VSS.n688 VSS.t976 38.6824
R5608 VSS.t198 VSS.n670 38.6824
R5609 VSS.t1554 VSS.n669 38.6824
R5610 VSS.t1460 VSS.n665 38.6824
R5611 VSS.t1461 VSS.n664 38.6824
R5612 VSS.t2219 VSS.n663 38.6824
R5613 VSS.t200 VSS.n660 38.6824
R5614 VSS.t933 VSS.n837 38.6824
R5615 VSS.n903 VSS.t1269 38.6824
R5616 VSS.n216 VSS.t1062 54.3887
R5617 VSS.n524 VSS.t540 38.5719
R5618 VSS.n526 VSS.t752 38.5719
R5619 VSS.t1015 VSS.n598 38.5719
R5620 VSS.t2450 VSS.t2222 38.5719
R5621 VSS.t2373 VSS.t741 38.5719
R5622 VSS.n1362 VSS.t329 38.5719
R5623 VSS.t644 VSS.n632 38.5719
R5624 VSS.t2613 VSS.t1366 38.5719
R5625 VSS.n1026 VSS.t1483 38.5719
R5626 VSS.t1455 VSS.n746 38.5719
R5627 VSS.t643 VSS.n737 38.5719
R5628 VSS.t1253 VSS.t62 38.5719
R5629 VSS.n1190 VSS.t1199 37.5005
R5630 VSS.n1280 VSS.t35 37.5005
R5631 VSS.n1143 VSS.t595 37.5005
R5632 VSS.t49 VSS.n567 37.5005
R5633 VSS.t1121 VSS.n639 37.5005
R5634 VSS.n1030 VSS.t418 37.5005
R5635 VSS.t1176 VSS.n881 37.5005
R5636 VSS.t419 VSS.n870 37.5005
R5637 VSS.n991 VSS.t2247 37.5005
R5638 VSS.t1090 VSS.n230 37.1968
R5639 VSS.n88 VSS.t2623 37.1968
R5640 VSS.n85 VSS.t1228 37.1968
R5641 VSS.n84 VSS.t1361 37.1968
R5642 VSS.n184 VSS.t1418 37.1968
R5643 VSS.t1428 VSS.n843 37.1968
R5644 VSS.t2337 VSS.n501 37.1319
R5645 VSS.t1050 VSS.n43 37.1319
R5646 VSS.t1003 VSS.n1407 37.1319
R5647 VSS.t2581 VSS.n132 37.1319
R5648 VSS.t2582 VSS.n133 37.1319
R5649 VSS.t2586 VSS.n109 37.1319
R5650 VSS.t349 VSS.n1328 36.5025
R5651 VSS.t1141 VSS.n770 36.487
R5652 VSS.t366 VSS.n1485 34.7437
R5653 VSS.t889 VSS.n1484 34.7437
R5654 VSS.t1599 VSS.n1483 34.7437
R5655 VSS.t682 VSS.n1482 34.7437
R5656 VSS.t848 VSS.n1481 34.7437
R5657 VSS.t2543 VSS.n1480 34.7437
R5658 VSS.t761 VSS.n1479 34.7437
R5659 VSS.t209 VSS.n22 47.3399
R5660 VSS.t903 VSS.t339 34.3845
R5661 VSS.t1045 VSS.t61 34.3845
R5662 VSS.t370 VSS.t1305 34.3845
R5663 VSS.t2354 VSS.t347 34.2862
R5664 VSS.t339 VSS.n1321 32.8988
R5665 VSS.t217 VSS.n75 32.8988
R5666 VSS.t1490 VSS.n94 32.8988
R5667 VSS.t1464 VSS.n171 32.8988
R5668 VSS.n465 VSS.t692 32.8462
R5669 VSS.n527 VSS.t678 32.8462
R5670 VSS.t908 VSS.n78 32.3359
R5671 VSS.n942 VSS.n775 31.2505
R5672 VSS.t453 VSS.t1493 30.9982
R5673 VSS.t2589 VSS.t138 30.0865
R5674 VSS.t484 VSS.n1197 30.0865
R5675 VSS.t2511 VSS.t528 30.0865
R5676 VSS.n1238 VSS.t530 30.0865
R5677 VSS.n1170 VSS.t526 30.0865
R5678 VSS.n1273 VSS.t286 30.0865
R5679 VSS.t2274 VSS.n1055 30.0865
R5680 VSS.n1068 VSS.t2401 30.0865
R5681 VSS.t1092 VSS.n1097 30.0865
R5682 VSS.n1123 VSS.t1023 30.0865
R5683 VSS.n1124 VSS.t766 30.0865
R5684 VSS.t119 VSS.n1091 30.0865
R5685 VSS.t1778 VSS.t1755 30.0865
R5686 VSS.t152 VSS.n556 30.0865
R5687 VSS.n564 VSS.t2625 30.0865
R5688 VSS.n1458 VSS.t956 30.0865
R5689 VSS.n1464 VSS.t1336 30.0865
R5690 VSS.n1469 VSS.t1352 30.0865
R5691 VSS.n1471 VSS.t1324 30.0865
R5692 VSS.t2324 VSS.n534 30.0865
R5693 VSS.t2235 VSS.n961 30.0865
R5694 VSS.t616 VSS.n953 30.0865
R5695 VSS.n682 VSS.t652 30.0865
R5696 VSS.n687 VSS.t651 30.0865
R5697 VSS.n694 VSS.t1388 30.0865
R5698 VSS.n703 VSS.t127 30.0865
R5699 VSS.t383 VSS.n933 30.0865
R5700 VSS.n842 VSS.t1426 30.0865
R5701 VSS.t116 VSS.n864 30.0865
R5702 VSS.t1271 VSS.n897 30.0865
R5703 VSS.t2471 VSS.n893 30.0865
R5704 VSS.n912 VSS.t2420 30.0865
R5705 VSS.t2422 VSS.n887 30.0865
R5706 VSS.n917 VSS.t2469 30.0865
R5707 VSS.n984 VSS.t1488 30.0865
R5708 VSS.t2036 VSS.t1990 30.0005
R5709 VSS.t1957 VSS.n21 12.9737
R5710 VSS.t1883 VSS.t1897 30.0005
R5711 VSS.t1002 VSS.n604 30.0005
R5712 VSS.t2567 VSS.n595 30.0005
R5713 VSS.n1269 VSS.t2333 30.0005
R5714 VSS.n1317 VSS.t2605 30.0005
R5715 VSS.t2311 VSS.t98 30.0005
R5716 VSS.t699 VSS.n1404 30.0005
R5717 VSS.n1406 VSS.t775 30.0005
R5718 VSS.t1580 VSS.n1415 30.0005
R5719 VSS.t1589 VSS.n1418 30.0005
R5720 VSS.t2387 VSS.n1433 30.0005
R5721 VSS.n1366 VSS.t958 30.0005
R5722 VSS.t789 VSS.n1357 30.0005
R5723 VSS.n1344 VSS.t301 30.0005
R5724 VSS.t543 VSS.n1340 30.0005
R5725 VSS.t1718 VSS.t1706 30.0005
R5726 VSS.n629 VSS.t1244 30.0005
R5727 VSS.n1013 VSS.t1475 30.0005
R5728 VSS.n1032 VSS.t1181 30.0005
R5729 VSS.t1231 VSS.n738 30.0005
R5730 VSS.t1232 VSS.n736 30.0005
R5731 VSS.n1036 VSS.t1233 30.0005
R5732 VSS.n1038 VSS.t1235 30.0005
R5733 VSS.n1039 VSS.t1234 30.0005
R5734 VSS.t1236 VSS.n728 30.0005
R5735 VSS.n1042 VSS.t575 30.0005
R5736 VSS.n1043 VSS.t2634 30.0005
R5737 VSS.n1046 VSS.t446 30.0005
R5738 VSS.t989 VSS.n720 30.0005
R5739 VSS.n30 VSS.t1639 12.9737
R5740 VSS.n798 VSS.t1268 30.0005
R5741 VSS.n799 VSS.t1415 30.0005
R5742 VSS.n801 VSS.t2268 30.0005
R5743 VSS.n808 VSS.t114 30.0005
R5744 VSS.n926 VSS.t936 30.0005
R5745 VSS.t1281 VSS.n877 30.0005
R5746 VSS.n87 VSS.t720 29.2233
R5747 VSS.t681 VSS.n74 29.2233
R5748 VSS.n165 VSS.t2546 29.2233
R5749 VSS.n204 VSS.t1171 29.2233
R5750 VSS.t281 VSS.t271 29.2223
R5751 VSS.n1402 VSS.t2504 29.1846
R5752 VSS.n131 VSS.t736 29.1846
R5753 VSS.n211 VSS.t2480 29.1846
R5754 VSS.n137 VSS.t646 29.1836
R5755 VSS.t242 VSS.t1109 29.1836
R5756 VSS.n1229 VSS.n1228 29.1672
R5757 VSS.n1177 VSS.t2197 29.1672
R5758 VSS.n1327 VSS.t351 29.1672
R5759 VSS.t880 VSS.n1141 29.1672
R5760 VSS.t328 VSS.t1407 29.1672
R5761 VSS.t2291 VSS.t1207 29.1672
R5762 VSS.n713 VSS.t71 29.1672
R5763 VSS.n922 VSS.n919 29.1672
R5764 VSS.n1002 VSS.n1001 29.1672
R5765 VSS.n7 VSS.n22 2.77592
R5766 VSS.n6 VSS.t2262 28.8133
R5767 VSS.n5 VSS.t340 28.8133
R5768 VSS.n4 VSS.t326 28.8133
R5769 VSS.n3 VSS.t121 28.8133
R5770 VSS.n2 VSS.t464 28.8133
R5771 VSS.n1 VSS.t539 28.8133
R5772 VSS.n0 VSS.t1594 28.8133
R5773 VSS.t1351 VSS.n220 28.6008
R5774 VSS.n219 VSS.t2348 28.6008
R5775 VSS.t990 VSS.n219 28.6008
R5776 VSS.n72 VSS.t151 28.6008
R5777 VSS.t497 VSS.n72 28.6008
R5778 VSS.n86 VSS.t1451 28.6008
R5779 VSS.t722 VSS.n86 28.6008
R5780 VSS.t171 VSS.n95 28.6008
R5781 VSS.t142 VSS.n161 28.6008
R5782 VSS.n161 VSS.t1319 28.6008
R5783 VSS.t837 VSS.n167 28.6008
R5784 VSS.t797 VSS.n45 28.5605
R5785 VSS.n45 VSS.t2490 28.5605
R5786 VSS.n125 VSS.t1362 28.5605
R5787 VSS.t1519 VSS.n125 28.5605
R5788 VSS.n650 VSS.t1395 28.1692
R5789 VSS.t246 VSS.n650 28.1692
R5790 VSS.t343 VSS.n1451 25.7885
R5791 VSS.n1460 VSS.t296 25.7885
R5792 VSS.t1152 VSS.t665 25.7885
R5793 VSS.t465 VSS.t1118 25.7885
R5794 VSS.t777 VSS.t778 25.7148
R5795 VSS.t1856 VSS.t2356 25.7148
R5796 VSS.t2294 VSS.t767 25.7148
R5797 VSS.t1376 VSS.t2414 25.7148
R5798 VSS.n648 VSS.t1394 25.0005
R5799 VSS.t1395 VSS.t929 25.0005
R5800 VSS.n1486 VSS.t2499 24.3462
R5801 VSS.t454 VSS.t1446 24.3248
R5802 VSS.n1321 VSS.t896 24.3028
R5803 VSS.n220 VSS.t303 24.3028
R5804 VSS.n94 VSS.t897 24.3028
R5805 VSS.n167 VSS.t154 24.3028
R5806 VSS.n171 VSS.t1435 24.3028
R5807 VSS.t2495 VSS.n465 24.2748
R5808 VSS.t894 VSS.n527 24.2748
R5809 VSS.n78 VSS.t2291 24.0025
R5810 VSS.t859 VSS.t829 21.4905
R5811 VSS.n1155 VSS.t2403 21.4905
R5812 VSS.t1479 VSS.n1098 21.4905
R5813 VSS.n1121 VSS.t1465 21.4905
R5814 VSS.t170 VSS.n552 21.4905
R5815 VSS.t1668 VSS.t229 21.4905
R5816 VSS.t2285 VSS.t142 21.4905
R5817 VSS.n688 VSS.t2577 21.4905
R5818 VSS.t1359 VSS.n654 21.4905
R5819 VSS.t627 VSS.n817 21.4905
R5820 VSS.t1608 VSS.t1063 21.4905
R5821 VSS.t1165 VSS.n889 21.4905
R5822 VSS.t1995 VSS.t2043 21.4291
R5823 VSS.t2512 VSS.t894 21.4291
R5824 VSS.t613 VSS.t882 21.4291
R5825 VSS.t709 VSS.t1022 21.4291
R5826 VSS.n628 VSS.t1242 21.4291
R5827 VSS.n1014 VSS.t1321 21.4291
R5828 VSS.t2576 VSS.n751 21.4291
R5829 VSS.n1037 VSS.t2583 21.4291
R5830 VSS.n1039 VSS.t2585 21.4291
R5831 VSS.n1040 VSS.t2584 21.4291
R5832 VSS.n1045 VSS.t444 21.4291
R5833 VSS.n802 VSS.t2270 21.4291
R5834 VSS.n809 VSS.t44 21.4291
R5835 VSS.n1304 VSS.t2526 20.8338
R5836 VSS.t264 VSS.t613 20.637
R5837 VSS.t943 VSS.t264 20.637
R5838 VSS.t632 VSS.n90 20.6273
R5839 VSS.n57 VSS.t1105 20.6193
R5840 VSS.t2299 VSS.n269 20.6183
R5841 VSS.n47 VSS.t2334 20.6121
R5842 VSS.n230 VSS.t1091 20.0048
R5843 VSS.t2624 VSS.n88 20.0048
R5844 VSS.t2284 VSS.n85 20.0048
R5845 VSS.t1190 VSS.n84 20.0048
R5846 VSS.t1552 VSS.n173 20.0048
R5847 VSS.n173 VSS.t967 20.0048
R5848 VSS.t1487 VSS.n184 20.0048
R5849 VSS.t672 VSS.n113 20.0048
R5850 VSS.n843 VSS.t1427 20.0048
R5851 VSS.n501 VSS.t693 19.9891
R5852 VSS.n446 VSS.t1600 19.9891
R5853 VSS.n43 VSS.t777 19.9891
R5854 VSS.n48 VSS.t760 19.9891
R5855 VSS.n1407 VSS.t1000 19.9891
R5856 VSS.t1004 VSS.n1427 19.9891
R5857 VSS.t51 VSS.n114 19.9891
R5858 VSS.n132 VSS.t414 19.9891
R5859 VSS.n133 VSS.t1348 19.9891
R5860 VSS.n109 VSS.t2283 19.9891
R5861 VSS.n12 VSS.t1569 19.9891
R5862 VSS.n1328 VSS.t350 19.8359
R5863 VSS.t2306 VSS.n190 19.8359
R5864 VSS.t566 VSS.n1180 17.1925
R5865 VSS.n1194 VSS.t94 17.1925
R5866 VSS.n1203 VSS.t691 17.1925
R5867 VSS.t884 VSS.t2371 17.1925
R5868 VSS.t1042 VSS.t1034 17.1925
R5869 VSS.n1441 VSS.t2256 17.1925
R5870 VSS.t147 VSS.n545 17.1925
R5871 VSS.n1464 VSS.t1512 17.1925
R5872 VSS.t967 VSS.t2578 17.1925
R5873 VSS.t622 VSS.t1106 17.1925
R5874 VSS.t1313 VSS.n861 17.1925
R5875 VSS.n999 VSS.t935 17.1925
R5876 VSS.t2616 VSS.n440 17.1434
R5877 VSS.t2350 VSS.t1052 17.1434
R5878 VSS.n1262 VSS.t2580 17.1434
R5879 VSS.t2397 VSS.n1363 17.1434
R5880 VSS.t1598 VSS.n1334 17.1434
R5881 VSS.t1518 VSS.t2582 17.1434
R5882 VSS.n1036 VSS.t2323 17.1434
R5883 VSS.n8 VSS.n7 0.710822
R5884 VSS.n358 VSS.t253 0.649832
R5885 VSS.t816 VSS.n247 0.648119
R5886 VSS.n388 VSS.t2 0.648119
R5887 VSS.n399 VSS.t948 0.649832
R5888 VSS.n1487 VSS.n7 17.0005
R5889 VSS.n7 VSS.n23 3.93415
R5890 VSS.n7 VSS.n1479 17.0005
R5891 VSS.n7 VSS.n1480 17.0005
R5892 VSS.n7 VSS.n1481 17.0005
R5893 VSS.n7 VSS.n1482 17.0005
R5894 VSS.n7 VSS.n1483 17.0005
R5895 VSS.n7 VSS.n1484 17.0005
R5896 VSS.n7 VSS.n1485 17.0005
R5897 VSS.t269 VSS.n1489 17.0005
R5898 VSS.t269 VSS.n435 17.0005
R5899 VSS.t269 VSS.n526 17.0005
R5900 VSS.t269 VSS.n437 17.0005
R5901 VSS.t269 VSS.n524 17.0005
R5902 VSS.t269 VSS.n438 17.0005
R5903 VSS.t269 VSS.n523 17.0005
R5904 VSS.t269 VSS.n439 17.0005
R5905 VSS.t269 VSS.n522 17.0005
R5906 VSS.t269 VSS.n440 17.0005
R5907 VSS.t269 VSS.n521 17.0005
R5908 VSS.t269 VSS.n441 17.0005
R5909 VSS.t269 VSS.n519 17.0005
R5910 VSS.t269 VSS.n443 17.0005
R5911 VSS.t269 VSS.n444 17.0005
R5912 VSS.t269 VSS.n517 17.0005
R5913 VSS.t269 VSS.n516 17.0005
R5914 VSS.t269 VSS.n449 17.0005
R5915 VSS.t269 VSS.n450 17.0005
R5916 VSS.t269 VSS.n513 17.0005
R5917 VSS.t269 VSS.n512 17.0005
R5918 VSS.t269 VSS.n453 17.0005
R5919 VSS.t269 VSS.n454 17.0005
R5920 VSS.t269 VSS.n509 17.0005
R5921 VSS.t269 VSS.n508 17.0005
R5922 VSS.t269 VSS.n457 17.0005
R5923 VSS.t269 VSS.n506 17.0005
R5924 VSS.t269 VSS.n459 17.0005
R5925 VSS.t269 VSS.n504 17.0005
R5926 VSS.t269 VSS.n462 17.0005
R5927 VSS.t269 VSS.n502 17.0005
R5928 VSS.t269 VSS.n464 17.0005
R5929 VSS.t269 VSS.n498 17.0005
R5930 VSS.t269 VSS.n469 17.0005
R5931 VSS.t269 VSS.n495 17.0005
R5932 VSS.t269 VSS.n471 17.0005
R5933 VSS.t269 VSS.n1488 17.0005
R5934 VSS.t269 VSS.n529 17.0005
R5935 VSS.n1168 VSS.t271 17.0005
R5936 VSS.n1169 VSS.t271 17.0005
R5937 VSS.n1170 VSS.t271 17.0005
R5938 VSS.n1171 VSS.t271 17.0005
R5939 VSS.n1173 VSS.t271 17.0005
R5940 VSS.n1174 VSS.t271 17.0005
R5941 VSS.n1175 VSS.t271 17.0005
R5942 VSS.n1177 VSS.t271 17.0005
R5943 VSS.n1178 VSS.t271 17.0005
R5944 VSS.n1238 VSS.t271 17.0005
R5945 VSS.n1237 VSS.t271 17.0005
R5946 VSS.n1236 VSS.t271 17.0005
R5947 VSS.n1235 VSS.t271 17.0005
R5948 VSS.n1233 VSS.t271 17.0005
R5949 VSS.n1232 VSS.t271 17.0005
R5950 VSS.n1231 VSS.t271 17.0005
R5951 VSS.n1228 VSS.t271 17.0005
R5952 VSS.n1227 VSS.t271 17.0005
R5953 VSS.n1225 VSS.t271 17.0005
R5954 VSS.n1223 VSS.t271 17.0005
R5955 VSS.n1220 VSS.t271 17.0005
R5956 VSS.n1219 VSS.t271 17.0005
R5957 VSS.n1218 VSS.t271 17.0005
R5958 VSS.n1217 VSS.t271 17.0005
R5959 VSS.n1214 VSS.t271 17.0005
R5960 VSS.n25 VSS.t271 3.08121
R5961 VSS.n1213 VSS.t271 17.0005
R5962 VSS.n1211 VSS.t271 17.0005
R5963 VSS.n1208 VSS.t271 17.0005
R5964 VSS.n1207 VSS.t271 17.0005
R5965 VSS.n1206 VSS.t271 17.0005
R5966 VSS.n1205 VSS.t271 17.0005
R5967 VSS.n1204 VSS.t271 17.0005
R5968 VSS.n1203 VSS.t271 17.0005
R5969 VSS.n1202 VSS.t271 17.0005
R5970 VSS.n1201 VSS.t271 17.0005
R5971 VSS.n1200 VSS.t271 17.0005
R5972 VSS.n1198 VSS.t271 17.0005
R5973 VSS.n1197 VSS.t271 17.0005
R5974 VSS.n29 VSS.t271 10.4544
R5975 VSS.n1196 VSS.t271 17.0005
R5976 VSS.n1194 VSS.t271 17.0005
R5977 VSS.n1180 VSS.t271 17.0005
R5978 VSS.n1181 VSS.t271 17.0005
R5979 VSS.n1183 VSS.t271 17.0005
R5980 VSS.n1184 VSS.t271 17.0005
R5981 VSS.n1185 VSS.t271 17.0005
R5982 VSS.n1192 VSS.t271 17.0005
R5983 VSS.n1190 VSS.t271 17.0005
R5984 VSS.n1189 VSS.t271 17.0005
R5985 VSS.n1188 VSS.t271 17.0005
R5986 VSS.n1187 VSS.t271 17.0005
R5987 VSS.n1241 VSS.t271 17.0005
R5988 VSS.t271 VSS.n1242 17.0005
R5989 VSS.n316 VSS.t271 0.649813
R5990 VSS.t271 VSS.n1162 17.0005
R5991 VSS.t271 VSS.n1164 17.0005
R5992 VSS.t271 VSS.n1163 17.0005
R5993 VSS.t271 VSS.n347 0.649813
R5994 VSS.t271 VSS.n1161 17.0005
R5995 VSS.n20 VSS.t271 7.66905
R5996 VSS.t253 VSS.n1317 17.0005
R5997 VSS.t253 VSS.n588 17.0005
R5998 VSS.t253 VSS.n1270 17.0005
R5999 VSS.t253 VSS.n589 17.0005
R6000 VSS.t253 VSS.n1269 17.0005
R6001 VSS.t253 VSS.n590 17.0005
R6002 VSS.t253 VSS.n1268 17.0005
R6003 VSS.t253 VSS.n591 17.0005
R6004 VSS.t253 VSS.n1267 17.0005
R6005 VSS.t253 VSS.n592 17.0005
R6006 VSS.t253 VSS.n1266 17.0005
R6007 VSS.t253 VSS.n593 17.0005
R6008 VSS.t253 VSS.n1265 17.0005
R6009 VSS.t253 VSS.n594 17.0005
R6010 VSS.t253 VSS.n1264 17.0005
R6011 VSS.t253 VSS.n595 17.0005
R6012 VSS.n1273 VSS.t253 17.0005
R6013 VSS.n1274 VSS.t253 17.0005
R6014 VSS.n1275 VSS.t253 17.0005
R6015 VSS.n1277 VSS.t253 17.0005
R6016 VSS.n1278 VSS.t253 17.0005
R6017 VSS.n1280 VSS.t253 17.0005
R6018 VSS.n1281 VSS.t253 17.0005
R6019 VSS.n1282 VSS.t253 17.0005
R6020 VSS.n1283 VSS.t253 17.0005
R6021 VSS.n1284 VSS.t253 17.0005
R6022 VSS.n1285 VSS.t253 17.0005
R6023 VSS.n1287 VSS.t253 17.0005
R6024 VSS.n1288 VSS.t253 17.0005
R6025 VSS.n1289 VSS.t253 17.0005
R6026 VSS.n1290 VSS.t253 17.0005
R6027 VSS.n1292 VSS.t253 17.0005
R6028 VSS.t253 VSS.n1294 17.0005
R6029 VSS.t253 VSS.n1296 17.0005
R6030 VSS.t253 VSS.n1297 17.0005
R6031 VSS.t253 VSS.n1298 17.0005
R6032 VSS.t253 VSS.n1299 17.0005
R6033 VSS.t253 VSS.n1300 17.0005
R6034 VSS.t253 VSS.n1301 17.0005
R6035 VSS.t253 VSS.n1302 17.0005
R6036 VSS.t253 VSS.n1303 17.0005
R6037 VSS.t253 VSS.n1304 17.0005
R6038 VSS.t253 VSS.n1305 17.0005
R6039 VSS.t253 VSS.n1306 17.0005
R6040 VSS.t253 VSS.n1307 17.0005
R6041 VSS.t253 VSS.n1309 17.0005
R6042 VSS.t253 VSS.n1310 17.0005
R6043 VSS.t253 VSS.n1311 17.0005
R6044 VSS.t253 VSS.n1312 17.0005
R6045 VSS.t253 VSS.n1313 17.0005
R6046 VSS.t253 VSS.n1314 17.0005
R6047 VSS.t253 VSS.n1315 17.0005
R6048 VSS.t253 VSS.n1316 17.0005
R6049 VSS.n296 VSS.t253 0.649813
R6050 VSS.t253 VSS.n596 17.0005
R6051 VSS.t253 VSS.n1263 17.0005
R6052 VSS.t253 VSS.n597 17.0005
R6053 VSS.t253 VSS.n1262 17.0005
R6054 VSS.t253 VSS.n598 17.0005
R6055 VSS.t253 VSS.n1261 17.0005
R6056 VSS.t253 VSS.n599 17.0005
R6057 VSS.t253 VSS.n1260 17.0005
R6058 VSS.t253 VSS.n1259 17.0005
R6059 VSS.n1258 VSS.t253 17.0005
R6060 VSS.t253 VSS.n600 17.0005
R6061 VSS.t253 VSS.n1257 17.0005
R6062 VSS.t253 VSS.n601 17.0005
R6063 VSS.t253 VSS.n1256 17.0005
R6064 VSS.t253 VSS.n602 17.0005
R6065 VSS.t253 VSS.n1255 17.0005
R6066 VSS.t253 VSS.n603 17.0005
R6067 VSS.t253 VSS.n1254 17.0005
R6068 VSS.t253 VSS.n604 17.0005
R6069 VSS.t253 VSS.n1253 17.0005
R6070 VSS.t253 VSS.n1252 17.0005
R6071 VSS.t253 VSS.n605 17.0005
R6072 VSS.t253 VSS.n1251 17.0005
R6073 VSS.t253 VSS.n606 17.0005
R6074 VSS.t253 VSS.n1250 17.0005
R6075 VSS.t253 VSS.n607 17.0005
R6076 VSS.t253 VSS.n1249 17.0005
R6077 VSS.t253 VSS.n608 17.0005
R6078 VSS.t253 VSS.n1248 17.0005
R6079 VSS.t253 VSS.n609 17.0005
R6080 VSS.t253 VSS.n1247 17.0005
R6081 VSS.t253 VSS.n610 17.0005
R6082 VSS.t253 VSS.n1246 17.0005
R6083 VSS.t253 VSS.n313 0.666899
R6084 VSS.t253 VSS.n1245 17.0005
R6085 VSS.t253 VSS.n611 17.0005
R6086 VSS.t253 VSS.n278 0.649813
R6087 VSS.n1320 VSS.t264 17.0005
R6088 VSS.n1322 VSS.t264 17.0005
R6089 VSS.n1324 VSS.t264 17.0005
R6090 VSS.n1325 VSS.t264 17.0005
R6091 VSS.n1326 VSS.t264 17.0005
R6092 VSS.n1327 VSS.t264 17.0005
R6093 VSS.n1329 VSS.t264 17.0005
R6094 VSS.n1330 VSS.t264 17.0005
R6095 VSS.n1331 VSS.t264 17.0005
R6096 VSS.n1332 VSS.t264 17.0005
R6097 VSS.n1333 VSS.t264 17.0005
R6098 VSS.n1334 VSS.t264 17.0005
R6099 VSS.n1335 VSS.t264 17.0005
R6100 VSS.n1336 VSS.t264 17.0005
R6101 VSS.n1337 VSS.t264 17.0005
R6102 VSS.n1339 VSS.t264 17.0005
R6103 VSS.n1340 VSS.t264 17.0005
R6104 VSS.n1342 VSS.t264 17.0005
R6105 VSS.n1344 VSS.t264 17.0005
R6106 VSS.n1345 VSS.t264 17.0005
R6107 VSS.n1347 VSS.t264 17.0005
R6108 VSS.n1348 VSS.t264 17.0005
R6109 VSS.n1349 VSS.t264 17.0005
R6110 VSS.n1355 VSS.t264 17.0005
R6111 VSS.n1356 VSS.t264 17.0005
R6112 VSS.n1357 VSS.t264 17.0005
R6113 VSS.n1359 VSS.t264 17.0005
R6114 VSS.n1361 VSS.t264 17.0005
R6115 VSS.n1362 VSS.t264 17.0005
R6116 VSS.n1363 VSS.t264 17.0005
R6117 VSS.n1365 VSS.t264 17.0005
R6118 VSS.n1366 VSS.t264 17.0005
R6119 VSS.n1367 VSS.t264 17.0005
R6120 VSS.n1369 VSS.t264 17.0005
R6121 VSS.n1370 VSS.t264 17.0005
R6122 VSS.n1372 VSS.t264 17.0005
R6123 VSS.n1373 VSS.t264 17.0005
R6124 VSS.n1374 VSS.t264 17.0005
R6125 VSS.n1375 VSS.t264 17.0005
R6126 VSS.n1376 VSS.t264 17.0005
R6127 VSS.n1378 VSS.t264 17.0005
R6128 VSS.n1379 VSS.t264 17.0005
R6129 VSS.n1381 VSS.t264 17.0005
R6130 VSS.n1382 VSS.t264 17.0005
R6131 VSS.n1385 VSS.t264 17.0005
R6132 VSS.n1386 VSS.t264 17.0005
R6133 VSS.n1388 VSS.t264 17.0005
R6134 VSS.n1389 VSS.t264 17.0005
R6135 VSS.n1390 VSS.t264 17.0005
R6136 VSS.n1391 VSS.t264 17.0005
R6137 VSS.n1393 VSS.t264 17.0005
R6138 VSS.n1394 VSS.t264 17.0005
R6139 VSS.n1395 VSS.t264 17.0005
R6140 VSS.n1396 VSS.t264 17.0005
R6141 VSS.n1433 VSS.t264 17.0005
R6142 VSS.n1432 VSS.t264 17.0005
R6143 VSS.n1430 VSS.t264 17.0005
R6144 VSS.n1429 VSS.t264 17.0005
R6145 VSS.n1428 VSS.t264 17.0005
R6146 VSS.n1426 VSS.t264 17.0005
R6147 VSS.n1425 VSS.t264 17.0005
R6148 VSS.n1424 VSS.t264 17.0005
R6149 VSS.n1422 VSS.t264 17.0005
R6150 VSS.n1421 VSS.t264 17.0005
R6151 VSS.n1420 VSS.t264 17.0005
R6152 VSS.n1419 VSS.t264 17.0005
R6153 VSS.n1418 VSS.t264 17.0005
R6154 VSS.n1417 VSS.t264 17.0005
R6155 VSS.n1415 VSS.t264 17.0005
R6156 VSS.n1414 VSS.t264 17.0005
R6157 VSS.n1412 VSS.t264 17.0005
R6158 VSS.n1411 VSS.t264 17.0005
R6159 VSS.n1410 VSS.t264 17.0005
R6160 VSS.n1408 VSS.t264 17.0005
R6161 VSS.n1406 VSS.t264 17.0005
R6162 VSS.n1404 VSS.t264 17.0005
R6163 VSS.n1403 VSS.t264 17.0005
R6164 VSS.n1401 VSS.t264 17.0005
R6165 VSS.n1399 VSS.t264 17.0005
R6166 VSS.n1398 VSS.t264 17.0005
R6167 VSS.n1397 VSS.t264 17.0005
R6168 VSS.n268 VSS.n578 17.0005
R6169 VSS.t1834 VSS.n268 17.0005
R6170 VSS.n67 VSS.n367 5.6463
R6171 VSS.n1136 VSS.t266 17.0005
R6172 VSS.n1137 VSS.t266 17.0005
R6173 VSS.n1138 VSS.t266 17.0005
R6174 VSS.n1140 VSS.t266 17.0005
R6175 VSS.n1141 VSS.t266 17.0005
R6176 VSS.n1143 VSS.t266 17.0005
R6177 VSS.n1144 VSS.t266 17.0005
R6178 VSS.n1145 VSS.t266 17.0005
R6179 VSS.n1146 VSS.t266 17.0005
R6180 VSS.t266 VSS.n1082 17.0005
R6181 VSS.t266 VSS.n1084 17.0005
R6182 VSS.t266 VSS.n1134 17.0005
R6183 VSS.t266 VSS.n1085 17.0005
R6184 VSS.t266 VSS.n1133 17.0005
R6185 VSS.t266 VSS.n1086 17.0005
R6186 VSS.t266 VSS.n1132 17.0005
R6187 VSS.t266 VSS.n1087 17.0005
R6188 VSS.t266 VSS.n1131 17.0005
R6189 VSS.t266 VSS.n1088 17.0005
R6190 VSS.t266 VSS.n1130 17.0005
R6191 VSS.t266 VSS.n1129 17.0005
R6192 VSS.t266 VSS.n1089 17.0005
R6193 VSS.t266 VSS.n1128 17.0005
R6194 VSS.t266 VSS.n1091 17.0005
R6195 VSS.t266 VSS.n1127 17.0005
R6196 VSS.t266 VSS.n1126 17.0005
R6197 VSS.t266 VSS.n1092 17.0005
R6198 VSS.t266 VSS.n1125 17.0005
R6199 VSS.t266 VSS.n1093 17.0005
R6200 VSS.t266 VSS.n1124 17.0005
R6201 VSS.t266 VSS.n1094 17.0005
R6202 VSS.t266 VSS.n1095 17.0005
R6203 VSS.t266 VSS.n1123 17.0005
R6204 VSS.t266 VSS.n1122 17.0005
R6205 VSS.t266 VSS.n1096 17.0005
R6206 VSS.t266 VSS.n1121 17.0005
R6207 VSS.t266 VSS.n1097 17.0005
R6208 VSS.t266 VSS.n1120 17.0005
R6209 VSS.t266 VSS.n1098 17.0005
R6210 VSS.t266 VSS.n1119 17.0005
R6211 VSS.t266 VSS.n1099 17.0005
R6212 VSS.t266 VSS.n1118 17.0005
R6213 VSS.t266 VSS.n1100 17.0005
R6214 VSS.t266 VSS.n1117 17.0005
R6215 VSS.t266 VSS.n1101 17.0005
R6216 VSS.t266 VSS.n1116 17.0005
R6217 VSS.t266 VSS.n1115 17.0005
R6218 VSS.t266 VSS.n1102 17.0005
R6219 VSS.t266 VSS.n1114 17.0005
R6220 VSS.t266 VSS.n1113 17.0005
R6221 VSS.t266 VSS.n1103 17.0005
R6222 VSS.t266 VSS.n1104 17.0005
R6223 VSS.t266 VSS.n1112 17.0005
R6224 VSS.t266 VSS.n1105 17.0005
R6225 VSS.t266 VSS.n1111 17.0005
R6226 VSS.t266 VSS.n1106 17.0005
R6227 VSS.t266 VSS.n1110 17.0005
R6228 VSS.t266 VSS.n1107 17.0005
R6229 VSS.t266 VSS.n1108 17.0005
R6230 VSS.t266 VSS.n1109 17.0005
R6231 VSS.n1150 VSS.t266 17.0005
R6232 VSS.t266 VSS.n1151 17.0005
R6233 VSS.n1152 VSS.t266 17.0005
R6234 VSS.t816 VSS.n1153 17.0005
R6235 VSS.t816 VSS.n1079 17.0005
R6236 VSS.t816 VSS.n1081 17.0005
R6237 VSS.t816 VSS.n1080 17.0005
R6238 VSS.t816 VSS.n282 0.648101
R6239 VSS.t816 VSS.n1069 17.0005
R6240 VSS.t816 VSS.n1078 17.0005
R6241 VSS.t816 VSS.n1070 17.0005
R6242 VSS.t816 VSS.n1077 17.0005
R6243 VSS.t816 VSS.n1076 17.0005
R6244 VSS.t816 VSS.n1071 17.0005
R6245 VSS.t816 VSS.n1075 17.0005
R6246 VSS.t816 VSS.n1072 17.0005
R6247 VSS.t816 VSS.n1074 17.0005
R6248 VSS.t816 VSS.n1073 17.0005
R6249 VSS.n1154 VSS.t816 17.0005
R6250 VSS.t816 VSS.n1155 17.0005
R6251 VSS.t816 VSS.n1060 17.0005
R6252 VSS.t816 VSS.n1068 17.0005
R6253 VSS.t816 VSS.n1061 17.0005
R6254 VSS.t816 VSS.n1067 17.0005
R6255 VSS.t816 VSS.n1062 17.0005
R6256 VSS.t816 VSS.n1063 17.0005
R6257 VSS.t816 VSS.n1064 17.0005
R6258 VSS.t816 VSS.n1066 17.0005
R6259 VSS.t816 VSS.n1065 17.0005
R6260 VSS.t816 VSS.n276 0.648101
R6261 VSS.t816 VSS.n1057 17.0005
R6262 VSS.t816 VSS.n1059 17.0005
R6263 VSS.t816 VSS.n1058 17.0005
R6264 VSS.t816 VSS.n370 0.648101
R6265 VSS.t816 VSS.n1056 17.0005
R6266 VSS.t816 VSS.n1156 17.0005
R6267 VSS.t816 VSS.n1055 17.0005
R6268 VSS.n102 VSS.t2 0.148826
R6269 VSS.t2 VSS.n532 17.0005
R6270 VSS.t2 VSS.n533 17.0005
R6271 VSS.t2 VSS.n1477 17.0005
R6272 VSS.t2 VSS.n1474 17.0005
R6273 VSS.t2 VSS.n1473 17.0005
R6274 VSS.t2 VSS.n534 17.0005
R6275 VSS.t2 VSS.n1472 17.0005
R6276 VSS.t2 VSS.n535 17.0005
R6277 VSS.t2 VSS.n1471 17.0005
R6278 VSS.t2 VSS.n536 17.0005
R6279 VSS.t2 VSS.n1470 17.0005
R6280 VSS.t2 VSS.n537 17.0005
R6281 VSS.t2 VSS.n1469 17.0005
R6282 VSS.t2 VSS.n538 17.0005
R6283 VSS.t2 VSS.n1468 17.0005
R6284 VSS.t2 VSS.n539 17.0005
R6285 VSS.t2 VSS.n1467 17.0005
R6286 VSS.t2 VSS.n540 17.0005
R6287 VSS.t2 VSS.n1465 17.0005
R6288 VSS.t2 VSS.n541 17.0005
R6289 VSS.t2 VSS.n1464 17.0005
R6290 VSS.t2 VSS.n543 17.0005
R6291 VSS.t2 VSS.n1463 17.0005
R6292 VSS.t2 VSS.n544 17.0005
R6293 VSS.t2 VSS.n1462 17.0005
R6294 VSS.t2 VSS.n545 17.0005
R6295 VSS.t2 VSS.n1461 17.0005
R6296 VSS.t2 VSS.n546 17.0005
R6297 VSS.t2 VSS.n1460 17.0005
R6298 VSS.t2 VSS.n547 17.0005
R6299 VSS.t2 VSS.n549 17.0005
R6300 VSS.t2 VSS.n1459 17.0005
R6301 VSS.t2 VSS.n550 17.0005
R6302 VSS.t2 VSS.n1458 17.0005
R6303 VSS.t2 VSS.n551 17.0005
R6304 VSS.t2 VSS.n552 17.0005
R6305 VSS.t2 VSS.n566 17.0005
R6306 VSS.t2 VSS.n553 17.0005
R6307 VSS.t2 VSS.n565 17.0005
R6308 VSS.t2 VSS.n554 17.0005
R6309 VSS.t2 VSS.n564 17.0005
R6310 VSS.t2 VSS.n555 17.0005
R6311 VSS.t2 VSS.n563 17.0005
R6312 VSS.t2 VSS.n556 17.0005
R6313 VSS.t2 VSS.n562 17.0005
R6314 VSS.t2 VSS.n557 17.0005
R6315 VSS.t2 VSS.n561 17.0005
R6316 VSS.t2 VSS.n558 17.0005
R6317 VSS.t2 VSS.n560 17.0005
R6318 VSS.t2 VSS.n559 17.0005
R6319 VSS.t2 VSS.n1451 17.0005
R6320 VSS.t2 VSS.n1453 17.0005
R6321 VSS.t2 VSS.n1452 17.0005
R6322 VSS.n381 VSS.t2 0.648101
R6323 VSS.t2 VSS.n1450 17.0005
R6324 VSS.t2 VSS.n1449 17.0005
R6325 VSS.n1454 VSS.t2 17.0005
R6326 VSS.t2 VSS.n1455 17.0005
R6327 VSS.t2 VSS.n380 0.562448
R6328 VSS.n1456 VSS.t2 17.0005
R6329 VSS.t2 VSS.n1448 17.0005
R6330 VSS.t2 VSS.n567 17.0005
R6331 VSS.t2 VSS.n1447 17.0005
R6332 VSS.t2 VSS.n568 17.0005
R6333 VSS.t2 VSS.n1446 17.0005
R6334 VSS.t2 VSS.n569 17.0005
R6335 VSS.t2 VSS.n570 17.0005
R6336 VSS.t2 VSS.n1443 17.0005
R6337 VSS.t2 VSS.n571 17.0005
R6338 VSS.t2 VSS.n1442 17.0005
R6339 VSS.t2 VSS.n1441 17.0005
R6340 VSS.t2 VSS.n572 17.0005
R6341 VSS.t2 VSS.n1440 17.0005
R6342 VSS.t2 VSS.n573 17.0005
R6343 VSS.t2 VSS.n1439 17.0005
R6344 VSS.t2 VSS.n574 17.0005
R6345 VSS.n1437 VSS.t2 17.0005
R6346 VSS.n1438 VSS.t2 17.0005
R6347 VSS.t2 VSS.n311 0.648101
R6348 VSS.t1365 VSS.n619 17.0005
R6349 VSS.t1365 VSS.n630 17.0005
R6350 VSS.t1365 VSS.n620 17.0005
R6351 VSS.t1365 VSS.n629 17.0005
R6352 VSS.t1365 VSS.n621 17.0005
R6353 VSS.t1365 VSS.n628 17.0005
R6354 VSS.t1365 VSS.n622 17.0005
R6355 VSS.t1365 VSS.n627 17.0005
R6356 VSS.t1365 VSS.n623 17.0005
R6357 VSS.t1365 VSS.n626 17.0005
R6358 VSS.t1365 VSS.n624 17.0005
R6359 VSS.t1365 VSS.n625 17.0005
R6360 VSS.n652 VSS.t948 17.0005
R6361 VSS.n651 VSS.t948 17.0005
R6362 VSS.n648 VSS.t948 17.0005
R6363 VSS.n647 VSS.t948 17.0005
R6364 VSS.n646 VSS.t948 17.0005
R6365 VSS.n644 VSS.t948 17.0005
R6366 VSS.n641 VSS.t948 17.0005
R6367 VSS.n639 VSS.t948 17.0005
R6368 VSS.n638 VSS.t948 17.0005
R6369 VSS.n637 VSS.t948 17.0005
R6370 VSS.n636 VSS.t948 17.0005
R6371 VSS.n635 VSS.t948 17.0005
R6372 VSS.n633 VSS.t948 17.0005
R6373 VSS.n632 VSS.t948 17.0005
R6374 VSS.t1542 VSS.n714 17.0005
R6375 VSS.t1542 VSS.n713 17.0005
R6376 VSS.t1542 VSS.n709 17.0005
R6377 VSS.t1542 VSS.n712 17.0005
R6378 VSS.t1542 VSS.n710 17.0005
R6379 VSS.t1542 VSS.n711 17.0005
R6380 VSS.t493 VSS.n654 17.0005
R6381 VSS.t493 VSS.n707 17.0005
R6382 VSS.t493 VSS.n655 17.0005
R6383 VSS.t493 VSS.n656 17.0005
R6384 VSS.t493 VSS.n657 17.0005
R6385 VSS.t493 VSS.n703 17.0005
R6386 VSS.t493 VSS.n658 17.0005
R6387 VSS.t493 VSS.n702 17.0005
R6388 VSS.t493 VSS.n659 17.0005
R6389 VSS.t493 VSS.n701 17.0005
R6390 VSS.t493 VSS.n660 17.0005
R6391 VSS.t493 VSS.n700 17.0005
R6392 VSS.t493 VSS.n661 17.0005
R6393 VSS.t493 VSS.n699 17.0005
R6394 VSS.t493 VSS.n698 17.0005
R6395 VSS.t493 VSS.n662 17.0005
R6396 VSS.t493 VSS.n697 17.0005
R6397 VSS.t493 VSS.n663 17.0005
R6398 VSS.t493 VSS.n696 17.0005
R6399 VSS.t493 VSS.n664 17.0005
R6400 VSS.t493 VSS.n695 17.0005
R6401 VSS.t493 VSS.n665 17.0005
R6402 VSS.t493 VSS.n694 17.0005
R6403 VSS.t493 VSS.n666 17.0005
R6404 VSS.t493 VSS.n693 17.0005
R6405 VSS.t493 VSS.n667 17.0005
R6406 VSS.t493 VSS.n692 17.0005
R6407 VSS.t493 VSS.n668 17.0005
R6408 VSS.t493 VSS.n691 17.0005
R6409 VSS.t493 VSS.n669 17.0005
R6410 VSS.t493 VSS.n690 17.0005
R6411 VSS.t493 VSS.n670 17.0005
R6412 VSS.t493 VSS.n671 17.0005
R6413 VSS.t493 VSS.n689 17.0005
R6414 VSS.t493 VSS.n672 17.0005
R6415 VSS.t493 VSS.n688 17.0005
R6416 VSS.t493 VSS.n673 17.0005
R6417 VSS.t493 VSS.n687 17.0005
R6418 VSS.t493 VSS.n674 17.0005
R6419 VSS.t493 VSS.n686 17.0005
R6420 VSS.t493 VSS.n675 17.0005
R6421 VSS.t493 VSS.n685 17.0005
R6422 VSS.t493 VSS.n676 17.0005
R6423 VSS.t493 VSS.n684 17.0005
R6424 VSS.t493 VSS.n677 17.0005
R6425 VSS.t493 VSS.n683 17.0005
R6426 VSS.t493 VSS.n678 17.0005
R6427 VSS.t493 VSS.n682 17.0005
R6428 VSS.t493 VSS.n679 17.0005
R6429 VSS.t493 VSS.n680 17.0005
R6430 VSS.t493 VSS.n681 17.0005
R6431 VSS.t493 VSS.n975 17.0005
R6432 VSS.t493 VSS.n951 17.0005
R6433 VSS.t493 VSS.n974 17.0005
R6434 VSS.t493 VSS.n973 17.0005
R6435 VSS.t493 VSS.n952 17.0005
R6436 VSS.t493 VSS.n972 17.0005
R6437 VSS.t493 VSS.n971 17.0005
R6438 VSS.t493 VSS.n970 17.0005
R6439 VSS.t493 VSS.n953 17.0005
R6440 VSS.t493 VSS.n954 17.0005
R6441 VSS.t493 VSS.n969 17.0005
R6442 VSS.t493 VSS.n955 17.0005
R6443 VSS.t493 VSS.n968 17.0005
R6444 VSS.t493 VSS.n956 17.0005
R6445 VSS.t493 VSS.n957 17.0005
R6446 VSS.t493 VSS.n967 17.0005
R6447 VSS.t493 VSS.n958 17.0005
R6448 VSS.t493 VSS.n966 17.0005
R6449 VSS.t493 VSS.n959 17.0005
R6450 VSS.t493 VSS.n960 17.0005
R6451 VSS.t493 VSS.n965 17.0005
R6452 VSS.t493 VSS.n961 17.0005
R6453 VSS.t493 VSS.n964 17.0005
R6454 VSS.t493 VSS.n962 17.0005
R6455 VSS.t493 VSS.n963 17.0005
R6456 VSS.t493 VSS.n950 17.0005
R6457 VSS.t493 VSS.n283 0.648101
R6458 VSS.t493 VSS.n412 17.0005
R6459 VSS.n977 VSS.t493 17.0005
R6460 VSS.t493 VSS.n943 17.0005
R6461 VSS.n304 VSS.t493 0.648101
R6462 VSS.t493 VSS.n944 17.0005
R6463 VSS.n274 VSS.t493 0.648101
R6464 VSS.t493 VSS.n945 17.0005
R6465 VSS.n948 VSS.t493 17.0005
R6466 VSS.n947 VSS.t493 17.0005
R6467 VSS.t493 VSS.n408 17.0005
R6468 VSS.n1048 VSS.t674 17.0005
R6469 VSS.t674 VSS.n715 17.0005
R6470 VSS.t674 VSS.n716 17.0005
R6471 VSS.t674 VSS.n717 17.0005
R6472 VSS.t674 VSS.n719 17.0005
R6473 VSS.t674 VSS.n720 17.0005
R6474 VSS.t674 VSS.n1047 17.0005
R6475 VSS.t674 VSS.n721 17.0005
R6476 VSS.t674 VSS.n1046 17.0005
R6477 VSS.t674 VSS.n722 17.0005
R6478 VSS.t674 VSS.n1045 17.0005
R6479 VSS.t674 VSS.n723 17.0005
R6480 VSS.t674 VSS.n1044 17.0005
R6481 VSS.t674 VSS.n725 17.0005
R6482 VSS.t674 VSS.n1043 17.0005
R6483 VSS.t674 VSS.n726 17.0005
R6484 VSS.t674 VSS.n1042 17.0005
R6485 VSS.t674 VSS.n727 17.0005
R6486 VSS.t674 VSS.n728 17.0005
R6487 VSS.t674 VSS.n1041 17.0005
R6488 VSS.t674 VSS.n729 17.0005
R6489 VSS.t674 VSS.n1040 17.0005
R6490 VSS.t674 VSS.n730 17.0005
R6491 VSS.t674 VSS.n1039 17.0005
R6492 VSS.t674 VSS.n732 17.0005
R6493 VSS.t674 VSS.n1038 17.0005
R6494 VSS.t674 VSS.n733 17.0005
R6495 VSS.t674 VSS.n1037 17.0005
R6496 VSS.t674 VSS.n734 17.0005
R6497 VSS.t674 VSS.n1036 17.0005
R6498 VSS.t674 VSS.n735 17.0005
R6499 VSS.t674 VSS.n1035 17.0005
R6500 VSS.t674 VSS.n736 17.0005
R6501 VSS.t674 VSS.n1034 17.0005
R6502 VSS.t674 VSS.n737 17.0005
R6503 VSS.t674 VSS.n1033 17.0005
R6504 VSS.t674 VSS.n738 17.0005
R6505 VSS.t674 VSS.n1032 17.0005
R6506 VSS.t674 VSS.n739 17.0005
R6507 VSS.t674 VSS.n741 17.0005
R6508 VSS.t674 VSS.n742 17.0005
R6509 VSS.t674 VSS.n1031 17.0005
R6510 VSS.t674 VSS.n743 17.0005
R6511 VSS.t674 VSS.n1030 17.0005
R6512 VSS.t674 VSS.n744 17.0005
R6513 VSS.t674 VSS.n1029 17.0005
R6514 VSS.t674 VSS.n745 17.0005
R6515 VSS.t674 VSS.n1028 17.0005
R6516 VSS.t674 VSS.n746 17.0005
R6517 VSS.t674 VSS.n1027 17.0005
R6518 VSS.t674 VSS.n747 17.0005
R6519 VSS.t674 VSS.n1026 17.0005
R6520 VSS.t674 VSS.n748 17.0005
R6521 VSS.t674 VSS.n749 17.0005
R6522 VSS.t674 VSS.n1025 17.0005
R6523 VSS.t674 VSS.n750 17.0005
R6524 VSS.t674 VSS.n1024 17.0005
R6525 VSS.t674 VSS.n751 17.0005
R6526 VSS.t674 VSS.n1023 17.0005
R6527 VSS.t674 VSS.n752 17.0005
R6528 VSS.t674 VSS.n1022 17.0005
R6529 VSS.t674 VSS.n753 17.0005
R6530 VSS.t674 VSS.n1021 17.0005
R6531 VSS.t674 VSS.n754 17.0005
R6532 VSS.t674 VSS.n1020 17.0005
R6533 VSS.t674 VSS.n755 17.0005
R6534 VSS.t674 VSS.n756 17.0005
R6535 VSS.t674 VSS.n1019 17.0005
R6536 VSS.t674 VSS.n757 17.0005
R6537 VSS.t674 VSS.n1018 17.0005
R6538 VSS.t674 VSS.n758 17.0005
R6539 VSS.t674 VSS.n759 17.0005
R6540 VSS.t674 VSS.n1017 17.0005
R6541 VSS.t674 VSS.n760 17.0005
R6542 VSS.t674 VSS.n1016 17.0005
R6543 VSS.t674 VSS.n761 17.0005
R6544 VSS.t674 VSS.n1015 17.0005
R6545 VSS.t674 VSS.n762 17.0005
R6546 VSS.t674 VSS.n1014 17.0005
R6547 VSS.t674 VSS.n763 17.0005
R6548 VSS.t674 VSS.n1013 17.0005
R6549 VSS.t674 VSS.n764 17.0005
R6550 VSS.t674 VSS.n765 17.0005
R6551 VSS.t674 VSS.n1012 17.0005
R6552 VSS.t674 VSS.n766 17.0005
R6553 VSS.t674 VSS.n1011 17.0005
R6554 VSS.t674 VSS.n767 17.0005
R6555 VSS.t674 VSS.n1010 17.0005
R6556 VSS.t674 VSS.n768 17.0005
R6557 VSS.t674 VSS.n1009 17.0005
R6558 VSS.t674 VSS.n769 17.0005
R6559 VSS.t674 VSS.n1007 17.0005
R6560 VSS.t674 VSS.n770 17.0005
R6561 VSS.t674 VSS.n781 17.0005
R6562 VSS.t674 VSS.n771 17.0005
R6563 VSS.t674 VSS.n778 17.0005
R6564 VSS.t674 VSS.n772 17.0005
R6565 VSS.t674 VSS.n777 17.0005
R6566 VSS.t674 VSS.n773 17.0005
R6567 VSS.t674 VSS.n776 17.0005
R6568 VSS.t674 VSS.n774 17.0005
R6569 VSS.t674 VSS.n775 17.0005
R6570 VSS.n144 VSS.n416 5.6463
R6571 VSS.t242 VSS.n863 17.0005
R6572 VSS.t242 VSS.n869 17.0005
R6573 VSS.t242 VSS.n864 17.0005
R6574 VSS.t242 VSS.n868 17.0005
R6575 VSS.t242 VSS.n865 17.0005
R6576 VSS.t242 VSS.n867 17.0005
R6577 VSS.t242 VSS.n866 17.0005
R6578 VSS.n861 VSS.t242 17.0005
R6579 VSS.n860 VSS.t242 17.0005
R6580 VSS.n859 VSS.t242 17.0005
R6581 VSS.n858 VSS.t242 17.0005
R6582 VSS.n857 VSS.t242 17.0005
R6583 VSS.n856 VSS.t242 17.0005
R6584 VSS.n855 VSS.t242 17.0005
R6585 VSS.n852 VSS.t242 17.0005
R6586 VSS.n851 VSS.t242 17.0005
R6587 VSS.n813 VSS.t242 17.0005
R6588 VSS.n814 VSS.t242 17.0005
R6589 VSS.n815 VSS.t242 17.0005
R6590 VSS.n816 VSS.t242 17.0005
R6591 VSS.n848 VSS.t242 17.0005
R6592 VSS.n847 VSS.t242 17.0005
R6593 VSS.n846 VSS.t242 17.0005
R6594 VSS.n845 VSS.t242 17.0005
R6595 VSS.n844 VSS.t242 17.0005
R6596 VSS.n842 VSS.t242 17.0005
R6597 VSS.n841 VSS.t242 17.0005
R6598 VSS.n840 VSS.t242 17.0005
R6599 VSS.n839 VSS.t242 17.0005
R6600 VSS.n837 VSS.t242 17.0005
R6601 VSS.n836 VSS.t242 17.0005
R6602 VSS.n835 VSS.t242 17.0005
R6603 VSS.n834 VSS.t242 17.0005
R6604 VSS.n833 VSS.t242 17.0005
R6605 VSS.n817 VSS.t242 17.0005
R6606 VSS.n818 VSS.t242 17.0005
R6607 VSS.n819 VSS.t242 17.0005
R6608 VSS.n820 VSS.t242 17.0005
R6609 VSS.n821 VSS.t242 17.0005
R6610 VSS.n823 VSS.t242 17.0005
R6611 VSS.n825 VSS.t242 17.0005
R6612 VSS.n826 VSS.t242 17.0005
R6613 VSS.n827 VSS.t242 17.0005
R6614 VSS.n830 VSS.t242 17.0005
R6615 VSS.n828 VSS.t242 17.0005
R6616 VSS.t242 VSS.n782 17.0005
R6617 VSS.t242 VSS.n809 17.0005
R6618 VSS.t242 VSS.n783 17.0005
R6619 VSS.t242 VSS.n785 17.0005
R6620 VSS.t242 VSS.n808 17.0005
R6621 VSS.t242 VSS.n807 17.0005
R6622 VSS.t242 VSS.n786 17.0005
R6623 VSS.t242 VSS.n806 17.0005
R6624 VSS.t242 VSS.n787 17.0005
R6625 VSS.t242 VSS.n805 17.0005
R6626 VSS.t242 VSS.n788 17.0005
R6627 VSS.t242 VSS.n804 17.0005
R6628 VSS.t242 VSS.n789 17.0005
R6629 VSS.t242 VSS.n803 17.0005
R6630 VSS.t242 VSS.n790 17.0005
R6631 VSS.t242 VSS.n802 17.0005
R6632 VSS.t242 VSS.n791 17.0005
R6633 VSS.t242 VSS.n801 17.0005
R6634 VSS.t242 VSS.n792 17.0005
R6635 VSS.t242 VSS.n800 17.0005
R6636 VSS.t242 VSS.n793 17.0005
R6637 VSS.t242 VSS.n799 17.0005
R6638 VSS.t242 VSS.n794 17.0005
R6639 VSS.t242 VSS.n798 17.0005
R6640 VSS.t242 VSS.n795 17.0005
R6641 VSS.t242 VSS.n797 17.0005
R6642 VSS.t242 VSS.n796 17.0005
R6643 VSS.n254 VSS.t242 5.61485
R6644 VSS.n932 VSS.t242 17.0005
R6645 VSS.n933 VSS.t242 17.0005
R6646 VSS.n934 VSS.t242 17.0005
R6647 VSS.n935 VSS.t242 17.0005
R6648 VSS.n936 VSS.t242 17.0005
R6649 VSS.n937 VSS.t242 17.0005
R6650 VSS.n938 VSS.t242 17.0005
R6651 VSS.n939 VSS.t242 17.0005
R6652 VSS.n941 VSS.t242 17.0005
R6653 VSS.n984 VSS.t2302 17.0005
R6654 VSS.n985 VSS.t2302 17.0005
R6655 VSS.n986 VSS.t2302 17.0005
R6656 VSS.n988 VSS.t2302 17.0005
R6657 VSS.n989 VSS.t2302 17.0005
R6658 VSS.n991 VSS.t2302 17.0005
R6659 VSS.n992 VSS.t2302 17.0005
R6660 VSS.n993 VSS.t2302 17.0005
R6661 VSS.n994 VSS.t2302 17.0005
R6662 VSS.n999 VSS.t2302 17.0005
R6663 VSS.n998 VSS.t2302 17.0005
R6664 VSS.n997 VSS.t2302 17.0005
R6665 VSS.n996 VSS.t2302 17.0005
R6666 VSS.t169 VSS.n871 17.0005
R6667 VSS.t169 VSS.n870 17.0005
R6668 VSS.n1001 VSS.t169 17.0005
R6669 VSS.t169 VSS.n427 17.0005
R6670 VSS.n286 VSS.t169 0.275272
R6671 VSS.t169 VSS.n874 17.0005
R6672 VSS.t169 VSS.n875 17.0005
R6673 VSS.t169 VSS.n930 17.0005
R6674 VSS.t169 VSS.n876 17.0005
R6675 VSS.t169 VSS.n929 17.0005
R6676 VSS.t169 VSS.n928 17.0005
R6677 VSS.t169 VSS.n927 17.0005
R6678 VSS.t169 VSS.n877 17.0005
R6679 VSS.t169 VSS.n926 17.0005
R6680 VSS.t169 VSS.n878 17.0005
R6681 VSS.t169 VSS.n879 17.0005
R6682 VSS.t169 VSS.n925 17.0005
R6683 VSS.t169 VSS.n880 17.0005
R6684 VSS.t169 VSS.n924 17.0005
R6685 VSS.t169 VSS.n923 17.0005
R6686 VSS.t169 VSS.n881 17.0005
R6687 VSS.t169 VSS.n922 17.0005
R6688 VSS.t169 VSS.n882 17.0005
R6689 VSS.t169 VSS.n883 17.0005
R6690 VSS.t169 VSS.n918 17.0005
R6691 VSS.t169 VSS.n884 17.0005
R6692 VSS.t169 VSS.n917 17.0005
R6693 VSS.t169 VSS.n885 17.0005
R6694 VSS.t169 VSS.n886 17.0005
R6695 VSS.t169 VSS.n916 17.0005
R6696 VSS.t169 VSS.n887 17.0005
R6697 VSS.t169 VSS.n915 17.0005
R6698 VSS.t169 VSS.n888 17.0005
R6699 VSS.t169 VSS.n914 17.0005
R6700 VSS.t169 VSS.n889 17.0005
R6701 VSS.t169 VSS.n913 17.0005
R6702 VSS.t169 VSS.n890 17.0005
R6703 VSS.t169 VSS.n912 17.0005
R6704 VSS.t169 VSS.n891 17.0005
R6705 VSS.t169 VSS.n892 17.0005
R6706 VSS.t169 VSS.n911 17.0005
R6707 VSS.t169 VSS.n893 17.0005
R6708 VSS.t169 VSS.n910 17.0005
R6709 VSS.t169 VSS.n909 17.0005
R6710 VSS.t169 VSS.n894 17.0005
R6711 VSS.t169 VSS.n895 17.0005
R6712 VSS.t169 VSS.n908 17.0005
R6713 VSS.t169 VSS.n896 17.0005
R6714 VSS.t169 VSS.n907 17.0005
R6715 VSS.t169 VSS.n906 17.0005
R6716 VSS.t169 VSS.n897 17.0005
R6717 VSS.t169 VSS.n905 17.0005
R6718 VSS.t169 VSS.n298 0.648101
R6719 VSS.t169 VSS.n898 17.0005
R6720 VSS.t169 VSS.n904 17.0005
R6721 VSS.t169 VSS.n899 17.0005
R6722 VSS.t169 VSS.n216 0.648101
R6723 VSS.t169 VSS.n900 17.0005
R6724 VSS.t169 VSS.n429 0.0256865
R6725 VSS.n903 VSS.t169 17.0005
R6726 VSS.n902 VSS.t169 17.0005
R6727 VSS.t169 VSS.n428 17.0005
R6728 VSS.t87 VSS.n1288 16.7369
R6729 VSS.n1189 VSS.t2293 16.6672
R6730 VSS.t126 VSS.n1297 16.6672
R6731 VSS.n1147 VSS.t601 16.6672
R6732 VSS.t183 VSS.n856 16.6672
R6733 VSS.n995 VSS.t2246 16.6672
R6734 VSS.t1074 VSS.n181 15.7068
R6735 VSS.t642 VSS.t1641 15.4994
R6736 VSS.t1641 VSS.t403 15.4994
R6737 VSS.n1221 VSS.n1179 14.852
R6738 VSS.n1008 VSS.t524 14.3531
R6739 VSS.n1005 VSS.t468 14.1658
R6740 VSS.n1491 VSS.n1490 14.1658
R6741 VSS.n1004 VSS.t915 14.1658
R6742 VSS.n1005 VSS.t1108 13.5005
R6743 VSS.t228 VSS.n1006 13.5005
R6744 VSS.n949 VSS.n612 13.5005
R6745 VSS.n1053 VSS.t1700 13.5005
R6746 VSS.n1054 VSS.t1739 13.5005
R6747 VSS.n1157 VSS.t781 13.5005
R6748 VSS.n1158 VSS.n577 13.5005
R6749 VSS.t1877 VSS.n1244 13.5005
R6750 VSS.n1243 VSS.t1923 13.5005
R6751 VSS.t1973 VSS.n433 13.5005
R6752 VSS.n1492 VSS.t2085 13.5005
R6753 VSS.n1490 VSS.t2002 13.5005
R6754 VSS.t825 VSS.n434 13.5005
R6755 VSS.n1318 VSS.t284 13.5005
R6756 VSS.t441 VSS.n1319 13.5005
R6757 VSS.t86 VSS.n587 13.5005
R6758 VSS.n1051 VSS.t153 13.5005
R6759 VSS.t150 VSS.n1052 13.5005
R6760 VSS.n1050 VSS.t969 13.5005
R6761 VSS.t204 VSS.n653 13.5005
R6762 VSS.t726 VSS.n1004 13.5005
R6763 VSS.t2329 VSS.t274 12.8945
R6764 VSS.n1201 VSS.t95 12.8945
R6765 VSS.t277 VSS.n1217 12.8945
R6766 VSS.t2486 VSS.n609 12.8945
R6767 VSS.n1248 VSS.t289 12.8945
R6768 VSS.t1596 VSS.t782 12.8945
R6769 VSS.t2459 VSS.n1102 12.8945
R6770 VSS.n1116 VSS.t247 12.8945
R6771 VSS.t333 VSS.n1101 12.8945
R6772 VSS.t639 VSS.n1454 12.8945
R6773 VSS.t904 VSS.n544 12.8945
R6774 VSS.n1463 VSS.t723 12.8945
R6775 VSS.t188 VSS.t834 12.8945
R6776 VSS.n693 VSS.t2615 12.8945
R6777 VSS.t143 VSS.n666 12.8945
R6778 VSS.t1267 VSS.t330 12.8945
R6779 VSS.t1257 VSS.n825 12.8945
R6780 VSS.n847 VSS.t658 12.8945
R6781 VSS.t1288 VSS.n883 12.8945
R6782 VSS.n316 VSS.t846 28.5605
R6783 VSS.t748 VSS.n607 12.8576
R6784 VSS.n1253 VSS.t811 12.8576
R6785 VSS.t2492 VSS.n604 12.8576
R6786 VSS.n1260 VSS.t2491 12.8576
R6787 VSS.n599 VSS.t1075 12.8576
R6788 VSS.n1264 VSS.t1076 12.8576
R6789 VSS.t1016 VSS.n594 12.8576
R6790 VSS.n1267 VSS.t710 12.8576
R6791 VSS.t1021 VSS.n591 12.8576
R6792 VSS.n1307 VSS.t1060 12.8576
R6793 VSS.n1425 VSS.t2606 12.8576
R6794 VSS.t2221 VSS.n1426 12.8576
R6795 VSS.n1357 VSS.t2314 12.8576
R6796 VSS.t488 VSS.n1344 12.8576
R6797 VSS.n627 VSS.t1515 12.8576
R6798 VSS.n1017 VSS.t181 12.8576
R6799 VSS.t1185 VSS.n759 12.8576
R6800 VSS.t403 VSS.t453 12.5933
R6801 VSS.t336 VSS.n1287 12.5528
R6802 VSS.t1432 VSS.t1454 12.5005
R6803 VSS.t1007 VSS.n1354 11.0706
R6804 VSS.n1350 VSS.t2596 11.0706
R6805 VSS.t2258 VSS.n1194 8.59649
R6806 VSS.t319 VSS.n1204 8.59649
R6807 VSS.t2374 VSS.t2344 8.59649
R6808 VSS.n1462 VSS.t317 8.59649
R6809 VSS.t898 VSS.n541 8.59649
R6810 VSS.t1146 VSS.t1307 8.59649
R6811 VSS.n860 VSS.t1439 8.59649
R6812 VSS.n521 VSS.t895 8.57193
R6813 VSS.n1333 VSS.t1402 8.57193
R6814 VSS.t2289 VSS.t1322 8.57193
R6815 VSS.t1405 VSS.n735 8.57193
R6816 VSS.t64 VSS.t2266 8.57193
R6817 VSS.t588 VSS.t674 8.50184
R6818 VSS.t563 VSS.n346 0.991435
R6819 VSS.t2192 VSS.n345 0.130189
R6820 VSS.t2190 VSS.n7 8.501
R6821 VSS.t2187 VSS.n344 0.130189
R6822 VSS.t2185 VSS.n7 8.501
R6823 VSS.t2182 VSS.n343 0.130189
R6824 VSS.t2180 VSS.n7 8.501
R6825 VSS.t2177 VSS.n342 0.130189
R6826 VSS.t2175 VSS.n7 8.501
R6827 VSS.t2172 VSS.n341 0.130189
R6828 VSS.t2170 VSS.n7 8.501
R6829 VSS.t2167 VSS.n340 0.130189
R6830 VSS.t2165 VSS.n7 8.501
R6831 VSS.t2162 VSS.n339 0.130189
R6832 VSS.n7 VSS.t2160 8.501
R6833 VSS.t2157 VSS.n338 0.130189
R6834 VSS.t2155 VSS.n7 8.501
R6835 VSS.t2152 VSS.n337 0.130189
R6836 VSS.t2150 VSS.n7 8.501
R6837 VSS.t2147 VSS.n336 0.130189
R6838 VSS.t2145 VSS.n7 8.501
R6839 VSS.t2142 VSS.n335 0.130189
R6840 VSS.t2140 VSS.n7 8.501
R6841 VSS.t2137 VSS.n334 0.130189
R6842 VSS.t2135 VSS.n7 8.501
R6843 VSS.t2132 VSS.n333 0.130189
R6844 VSS.t2130 VSS.n7 8.501
R6845 VSS.t2127 VSS.n332 0.130189
R6846 VSS.t2125 VSS.n7 8.501
R6847 VSS.t2122 VSS.n331 0.130189
R6848 VSS.t2120 VSS.n7 8.501
R6849 VSS.t2117 VSS.n330 0.130189
R6850 VSS.t2115 VSS.n7 8.501
R6851 VSS.t2112 VSS.n329 0.130189
R6852 VSS.t2110 VSS.n7 8.501
R6853 VSS.t2107 VSS.n328 0.130189
R6854 VSS.t2105 VSS.n7 8.501
R6855 VSS.t2102 VSS.n327 0.130189
R6856 VSS.t2100 VSS.n7 8.501
R6857 VSS.t2097 VSS.n326 0.130189
R6858 VSS.t2095 VSS.n7 8.501
R6859 VSS.n325 VSS.t2092 0.130189
R6860 VSS.t2090 VSS.n7 8.501
R6861 VSS.n324 VSS.t2087 0.130189
R6862 VSS.t2082 VSS.n323 0.215686
R6863 VSS.t2080 VSS.n7 8.501
R6864 VSS.n322 VSS.t2077 0.130189
R6865 VSS.t2075 VSS.n7 8.501
R6866 VSS.n321 VSS.t2072 0.130189
R6867 VSS.t2070 VSS.n7 8.501
R6868 VSS.n7 VSS.n320 3.33079
R6869 VSS.n1226 VSS.t271 4.251
R6870 VSS.t271 VSS.t1964 0.971135
R6871 VSS.n356 VSS.t271 3.33079
R6872 VSS.t1204 VSS.n317 0.282695
R6873 VSS.t271 VSS.n317 1.78144
R6874 VSS.n355 VSS.t1940 0.123414
R6875 VSS.t1938 VSS.t271 8.501
R6876 VSS.n354 VSS.t1935 0.130189
R6877 VSS.t1933 VSS.t271 8.501
R6878 VSS.n353 VSS.t1930 0.130189
R6879 VSS.t1928 VSS.t271 8.501
R6880 VSS.n352 VSS.t1925 0.130189
R6881 VSS.t1923 VSS.t271 8.501
R6882 VSS.t1920 VSS.n351 0.130189
R6883 VSS.t1918 VSS.t271 8.501
R6884 VSS.t1915 VSS.n350 0.130189
R6885 VSS.t1913 VSS.t271 8.501
R6886 VSS.t1910 VSS.n349 0.130189
R6887 VSS.t1908 VSS.t271 8.501
R6888 VSS.n348 VSS.t271 3.33079
R6889 VSS.n315 VSS.t253 0.675731
R6890 VSS.t1902 VSS.n357 0.76304
R6891 VSS.n314 VSS.t253 1.74963
R6892 VSS.n364 VSS.t253 3.33348
R6893 VSS.t253 VSS.t1882 8.501
R6894 VSS.t1879 VSS.n363 0.130189
R6895 VSS.t1877 VSS.t253 8.501
R6896 VSS.t1874 VSS.n362 0.130189
R6897 VSS.t1872 VSS.t253 8.501
R6898 VSS.t1869 VSS.n361 0.130189
R6899 VSS.t1867 VSS.t253 8.501
R6900 VSS.t1864 VSS.n360 0.130189
R6901 VSS.t1862 VSS.t253 8.501
R6902 VSS.n359 VSS.t253 3.33079
R6903 VSS.t264 VSS.n256 0.350616
R6904 VSS.t571 VSS.n256 0.8103
R6905 VSS.t88 VSS.t264 1.54523
R6906 VSS.t1215 VSS.n295 0.135098
R6907 VSS.t1836 VSS.n297 0.0823774
R6908 VSS.t1833 VSS.n367 0.0333775
R6909 VSS.t1830 VSS.n294 0.13364
R6910 VSS.n68 VSS.n67 0.00318484
R6911 VSS.n293 VSS.n67 4.20315
R6912 VSS.n366 VSS.n67 5.6463
R6913 VSS.t88 VSS.n68 0.444316
R6914 VSS.n1149 VSS.t266 2.42911
R6915 VSS.n369 VSS.t266 0.404809
R6916 VSS.t1813 VSS.t266 8.501
R6917 VSS.n368 VSS.t816 3.33087
R6918 VSS.t362 VSS.n374 0.838455
R6919 VSS.n373 VSS.t816 0.668775
R6920 VSS.n372 VSS.t816 1.73735
R6921 VSS.n371 VSS.t820 0.129991
R6922 VSS.t781 VSS.t816 8.501
R6923 VSS.n375 VSS.t816 3.33079
R6924 VSS.t1797 VSS.t816 8.501
R6925 VSS.n379 VSS.t816 3.33079
R6926 VSS.t1792 VSS.t816 8.501
R6927 VSS.n378 VSS.t816 3.33079
R6928 VSS.t1787 VSS.t816 8.501
R6929 VSS.n377 VSS.t816 3.33079
R6930 VSS.t344 VSS.n385 0.459772
R6931 VSS.t498 VSS.n384 0.130189
R6932 VSS.t1206 VSS.n383 0.185108
R6933 VSS.t1780 VSS.n382 0.130189
R6934 VSS.n380 VSS.t156 3.54967
R6935 VSS.n387 VSS.t663 0.775278
R6936 VSS.n386 VSS.t2 2.31523
R6937 VSS.n396 VSS.t2 3.33348
R6938 VSS.t2 VSS.t1754 8.501
R6939 VSS.t1751 VSS.n395 0.130189
R6940 VSS.t1749 VSS.t2 8.501
R6941 VSS.t1746 VSS.n394 0.130189
R6942 VSS.t1744 VSS.t2 8.501
R6943 VSS.t1741 VSS.n393 0.130189
R6944 VSS.t1739 VSS.t2 8.501
R6945 VSS.t1736 VSS.n392 0.130189
R6946 VSS.t1734 VSS.t2 8.501
R6947 VSS.t1731 VSS.n391 0.130189
R6948 VSS.t1729 VSS.t2 8.501
R6949 VSS.t1726 VSS.n390 0.130189
R6950 VSS.t1724 VSS.t2 8.501
R6951 VSS.n389 VSS.t2 3.33079
R6952 VSS.t128 VSS.t1365 0.653205
R6953 VSS.n405 VSS.n406 0.0017399
R6954 VSS.t128 VSS.n149 0.445501
R6955 VSS.t948 VSS.n149 0.0129987
R6956 VSS.t948 VSS.n310 4.23289
R6957 VSS.t1705 VSS.n310 0.0377157
R6958 VSS.n404 VSS.t1702 0.130189
R6959 VSS.t1700 VSS.t948 8.501
R6960 VSS.t1697 VSS.n403 0.130189
R6961 VSS.t1695 VSS.t948 8.501
R6962 VSS.n402 VSS.t1692 0.130189
R6963 VSS.t1690 VSS.t948 8.501
R6964 VSS.n401 VSS.t1687 0.130189
R6965 VSS.t1685 VSS.t948 8.501
R6966 VSS.t948 VSS.n400 3.33079
R6967 VSS.n253 VSS.n252 0.00434813
R6968 VSS.t46 VSS.n284 0.58242
R6969 VSS.t1498 VSS.n415 0.923223
R6970 VSS.n414 VSS.t493 4.20468
R6971 VSS.n413 VSS.t493 2.31585
R6972 VSS.n411 VSS.t493 2.31585
R6973 VSS.t493 VSS.n410 3.33087
R6974 VSS.n417 VSS.n144 5.64879
R6975 VSS.n273 VSS.n144 4.20253
R6976 VSS.t1645 VSS.n416 0.0333775
R6977 VSS.n280 VSS.n144 3.32884
R6978 VSS.n145 VSS.n144 0.0129139
R6979 VSS.t242 VSS.t140 1.54546
R6980 VSS.t92 VSS.t242 0.943855
R6981 VSS.n424 VSS.t1632 0.207922
R6982 VSS.t1630 VSS.t242 8.501
R6983 VSS.n423 VSS.t1627 0.130189
R6984 VSS.t1625 VSS.t242 8.501
R6985 VSS.n422 VSS.t1622 0.130189
R6986 VSS.t1620 VSS.t242 8.501
R6987 VSS.t242 VSS.n421 3.33079
R6988 VSS.n1000 VSS.t2302 2.4294
R6989 VSS.t169 VSS.n1003 2.83428
R6990 VSS.n432 VSS.t169 1.7672
R6991 VSS.n431 VSS.t169 1.73679
R6992 VSS.t169 VSS.n430 3.33087
R6993 VSS.n1179 VSS.t271 8.5005
R6994 VSS.n289 VSS.t39 0.17801
R6995 VSS.n257 VSS.t264 0.391435
R6996 VSS.t264 VSS.t1208 8.47111
R6997 VSS.n268 VSS.t1837 8.47111
R6998 VSS.n268 VSS.n297 4.20315
R6999 VSS.n264 VSS.t1832 0.17801
R7000 VSS.n67 VSS.t1829 8.47111
R7001 VSS.t89 VSS.n293 0.0820912
R7002 VSS.n365 VSS.t1839 0.232971
R7003 VSS.n312 VSS.t109 0.179894
R7004 VSS.n312 VSS.t266 4.177
R7005 VSS.n251 VSS.t477 0.897647
R7006 VSS.n397 VSS.t1365 4.177
R7007 VSS.n397 VSS.t396 0.119605
R7008 VSS.n306 VSS.t1365 3.30696
R7009 VSS.n307 VSS.t1365 3.30696
R7010 VSS.n308 VSS.t520 0.235242
R7011 VSS.n308 VSS.t1365 2.72093
R7012 VSS.t1365 VSS.n260 2.72093
R7013 VSS.t164 VSS.n260 0.235242
R7014 VSS.n152 VSS.t1365 4.177
R7015 VSS.n152 VSS.t129 0.119605
R7016 VSS.t481 VSS.n406 8.47111
R7017 VSS.t948 VSS.t172 8.47111
R7018 VSS.t1360 VSS.n309 0.235242
R7019 VSS.n309 VSS.t948 2.72093
R7020 VSS.t516 VSS.n151 0.418588
R7021 VSS.t948 VSS.n617 8.47111
R7022 VSS.t576 VSS.n398 0.119605
R7023 VSS.t948 VSS.n398 4.177
R7024 VSS.t1542 VSS.n299 2.72093
R7025 VSS.n299 VSS.t514 0.235242
R7026 VSS.n708 VSS.t1542 8.47111
R7027 VSS.n252 VSS.n305 4.177
R7028 VSS.t500 VSS.n305 0.119605
R7029 VSS.n261 VSS.n252 2.29766
R7030 VSS.n407 VSS.t493 0.42355
R7031 VSS.n414 VSS.t1665 0.07903
R7032 VSS.t674 VSS.n266 3.30688
R7033 VSS.n303 VSS.t674 3.34093
R7034 VSS.t1646 VSS.n273 0.083315
R7035 VSS.n281 VSS.t831 0.0633807
R7036 VSS.t242 VSS.n418 4.177
R7037 VSS.n418 VSS.t587 0.119605
R7038 VSS.t435 VSS.n32 0.761646
R7039 VSS.t1433 VSS.n301 0.17801
R7040 VSS.n302 VSS.t242 4.177
R7041 VSS.n302 VSS.t922 0.119605
R7042 VSS.n419 VSS.t242 4.177
R7043 VSS.n810 VSS.t242 8.47111
R7044 VSS.n420 VSS.t242 2.29758
R7045 VSS.t1124 VSS.n254 0.0605362
R7046 VSS.t384 VSS.n285 0.761641
R7047 VSS.n292 VSS.t931 0.833505
R7048 VSS.t2302 VSS.n425 4.177
R7049 VSS.t306 VSS.n425 0.119605
R7050 VSS.t2302 VSS.n426 4.177
R7051 VSS.t307 VSS.n426 0.119605
R7052 VSS.n872 VSS.t2302 8.47111
R7053 VSS.t169 VSS.n300 4.177
R7054 VSS.t2518 VSS.n300 0.119605
R7055 VSS.t105 VSS.n290 0.799055
R7056 VSS.n1226 VSS.t416 8.42747
R7057 VSS.n1287 VSS.t900 8.3687
R7058 VSS.t2500 VSS.n1190 8.33383
R7059 VSS.n1296 VSS.t899 8.33383
R7060 VSS.t351 VSS.t24 8.33383
R7061 VSS.n855 VSS.t1438 8.33383
R7062 VSS.t2395 VSS.t1961 7.1604
R7063 VSS.t1007 VSS.t1037 7.1604
R7064 VSS.t1082 VSS.t590 7.1604
R7065 VSS.n1457 VSS.t156 7.1604
R7066 VSS.t149 VSS.t947 7.1604
R7067 VSS.t225 VSS.t1372 7.1604
R7068 VSS.t305 VSS.t168 7.1604
R7069 VSS.t677 VSS.t674 5.75337
R7070 VSS.t38 VSS.t271 1.21374
R7071 VSS.t16 VSS.n319 2.83414
R7072 VSS.n319 VSS.n318 0.00199982
R7073 VSS.t16 VSS.n102 2.66217
R7074 VSS.n149 VSS.n405 0.00908321
R7075 VSS.n253 VSS.t1542 0.00963267
R7076 VSS.t392 VSS.n253 0.708233
R7077 VSS.t227 VSS.n145 0.529184
R7078 VSS.n281 VSS.t242 4.23342
R7079 VSS.t166 VSS.t169 0.737739
R7080 VSS.n1350 VSS.t264 5.66717
R7081 VSS.n1354 VSS.t264 5.66717
R7082 VSS.t1651 VSS.n303 0.0801178
R7083 VSS.n7 VSS.n345 3.33079
R7084 VSS.n344 VSS.n7 3.33079
R7085 VSS.n343 VSS.n7 3.33079
R7086 VSS.n342 VSS.n7 3.33079
R7087 VSS.n341 VSS.n7 3.33079
R7088 VSS.n340 VSS.n7 3.33079
R7089 VSS.n339 VSS.n7 3.33079
R7090 VSS.n338 VSS.n7 3.33079
R7091 VSS.n337 VSS.n7 3.33079
R7092 VSS.n336 VSS.n7 3.33079
R7093 VSS.n335 VSS.n7 3.33079
R7094 VSS.n334 VSS.n7 3.33079
R7095 VSS.n333 VSS.n7 3.33079
R7096 VSS.n332 VSS.n7 3.33079
R7097 VSS.n331 VSS.n7 3.33079
R7098 VSS.n330 VSS.n7 3.33079
R7099 VSS.n329 VSS.n7 3.33079
R7100 VSS.n328 VSS.n7 3.33079
R7101 VSS.n327 VSS.n7 3.33079
R7102 VSS.n326 VSS.n7 3.33079
R7103 VSS.n325 VSS.n7 3.33079
R7104 VSS.n7 VSS.n324 3.33079
R7105 VSS.n322 VSS.n7 3.33079
R7106 VSS.n7 VSS.n321 3.33079
R7107 VSS.t2068 VSS.n320 0.0863258
R7108 VSS.n287 VSS.t316 0.895582
R7109 VSS.n1167 VSS.t271 5.61485
R7110 VSS.t271 VSS.n289 3.30688
R7111 VSS.n356 VSS.t1963 0.0863258
R7112 VSS.n355 VSS.t271 3.33348
R7113 VSS.t271 VSS.n354 3.33079
R7114 VSS.n353 VSS.t271 3.33079
R7115 VSS.t271 VSS.n352 3.33079
R7116 VSS.n351 VSS.t271 3.33079
R7117 VSS.n350 VSS.t271 3.33079
R7118 VSS.n349 VSS.t271 3.33079
R7119 VSS.t1906 VSS.n348 0.0863258
R7120 VSS.n364 VSS.t1885 0.0818513
R7121 VSS.t253 VSS.n363 3.33079
R7122 VSS.n362 VSS.t253 3.33079
R7123 VSS.n361 VSS.t253 3.33079
R7124 VSS.n360 VSS.t253 3.33079
R7125 VSS.t1860 VSS.n359 0.0863258
R7126 VSS.n268 VSS.n579 5.61485
R7127 VSS.n295 VSS.n268 3.32884
R7128 VSS.n67 VSS.n264 3.30688
R7129 VSS.n294 VSS.n67 3.32942
R7130 VSS.n368 VSS.t845 0.0861948
R7131 VSS.t816 VSS.n371 3.33087
R7132 VSS.t1800 VSS.n375 0.0863258
R7133 VSS.t1795 VSS.n379 0.0863258
R7134 VSS.t1790 VSS.n378 0.0863258
R7135 VSS.t1785 VSS.n377 0.0863258
R7136 VSS.n1478 VSS.n318 5.61485
R7137 VSS.n101 VSS.t17 5.61485
R7138 VSS.n106 VSS.t2 0.232037
R7139 VSS.t2 VSS.n384 3.33079
R7140 VSS.t2 VSS.n382 3.33079
R7141 VSS.n396 VSS.t1757 0.0818513
R7142 VSS.t2 VSS.n395 3.33079
R7143 VSS.n394 VSS.t2 3.33079
R7144 VSS.n393 VSS.t2 3.33079
R7145 VSS.n392 VSS.t2 3.33079
R7146 VSS.n391 VSS.t2 3.33079
R7147 VSS.n390 VSS.t2 3.33079
R7148 VSS.t1722 VSS.n389 0.0863258
R7149 VSS.n105 VSS.t1365 0.959642
R7150 VSS.t1365 VSS.t1059 5.61485
R7151 VSS.t521 VSS.n307 0.118193
R7152 VSS.n618 VSS.n405 5.61485
R7153 VSS.t948 VSS.n151 3.30688
R7154 VSS.t948 VSS.n404 3.33079
R7155 VSS.n403 VSS.t948 3.33079
R7156 VSS.n402 VSS.t948 3.33079
R7157 VSS.t948 VSS.n401 3.33079
R7158 VSS.t1683 VSS.n400 0.0863258
R7159 VSS.t493 VSS.t1676 5.61485
R7160 VSS.n410 VSS.t230 0.0861948
R7161 VSS.n148 VSS.t674 0.35626
R7162 VSS.n280 VSS.t1643 0.0895683
R7163 VSS.n279 VSS.t242 0.423819
R7164 VSS.t242 VSS.n301 3.30688
R7165 VSS.t242 VSS.n288 0.356213
R7166 VSS.t242 VSS.t70 5.61485
R7167 VSS.n423 VSS.t242 3.33079
R7168 VSS.t242 VSS.n422 3.33079
R7169 VSS.t1618 VSS.n421 0.0863258
R7170 VSS.t1436 VSS.t2302 5.61485
R7171 VSS.t2302 VSS.n235 1.20423
R7172 VSS.n430 VSS.t853 0.0861948
R7173 VSS.n1003 VSS.t914 5.47495
R7174 VSS.n1149 VSS.t1082 4.65889
R7175 VSS.n1000 VSS.t1103 4.65889
R7176 VSS.t243 VSS.n1222 4.58065
R7177 VSS.t2402 VSS.n1060 4.29849
R7178 VSS.t195 VSS.n1102 4.29849
R7179 VSS.n1120 VSS.t249 4.29849
R7180 VSS.t1350 VSS.n1096 4.29849
R7181 VSS.t303 VSS.t970 4.29849
R7182 VSS.t148 VSS.t1351 4.29849
R7183 VSS.t160 VSS.n1084 4.29849
R7184 VSS.t154 VSS.t125 4.29849
R7185 VSS.t1468 VSS.t837 4.29849
R7186 VSS.n975 VSS.t460 4.29849
R7187 VSS.t460 VSS.t1471 4.29849
R7188 VSS.t2252 VSS.n673 4.29849
R7189 VSS.t2467 VSS.t1134 4.29849
R7190 VSS.t849 VSS.n444 4.28621
R7191 VSS.n519 VSS.t2544 4.28621
R7192 VSS.t2542 VSS.n441 4.28621
R7193 VSS.n521 VSS.t683 4.28621
R7194 VSS.t272 VSS.n439 4.28621
R7195 VSS.t1051 VSS.n602 4.28621
R7196 VSS.n296 VSS.t1013 19.9891
R7197 VSS.n1359 VSS.t294 4.28621
R7198 VSS.n1342 VSS.t208 4.28621
R7199 VSS.t1243 VSS.n621 4.28621
R7200 VSS.t141 VSS.n763 4.28621
R7201 VSS.t47 VSS.n755 4.28621
R7202 VSS.n1023 VSS.t1550 4.28621
R7203 VSS.t1279 VSS.n734 4.28621
R7204 VSS.t234 VSS.n732 4.28621
R7205 VSS.t1189 VSS.n730 4.28621
R7206 VSS.t703 VSS.t1380 4.28621
R7207 VSS.t445 VSS.n722 4.28621
R7208 VSS.t2478 VSS.n796 4.28621
R7209 VSS.t2269 VSS.n791 4.28621
R7210 VSS.t1547 VSS.n783 4.28621
R7211 VSS.n144 VSS.t1642 8.5055
R7212 VSS.t271 VSS.t2395 4.2505
R7213 VSS.t1037 VSS.t264 4.2505
R7214 VSS.t266 VSS.t590 4.2505
R7215 VSS.t947 VSS.t948 4.2505
R7216 VSS.t242 VSS.t1372 4.2505
R7217 VSS.t169 VSS.t168 4.2505
R7218 VSS.t547 VSS.t266 4.24653
R7219 VSS.n1240 VSS.t271 4.23297
R7220 VSS.t493 VSS.n946 4.22743
R7221 VSS.t169 VSS.n901 4.22743
R7222 VSS.t2 VSS.n383 2.74088
R7223 VSS.t2451 VSS.n1305 4.16717
R7224 VSS.n1293 VSS.t18 3.61932
R7225 VSS.t21 VSS.t304 3.50108
R7226 VSS.t88 VSS.t1851 3.50108
R7227 VSS.t1082 VSS.n1135 3.50108
R7228 VSS.n1135 VSS.t589 3.50108
R7229 VSS.t128 VSS.t162 3.50108
R7230 VSS.n706 VSS.n705 3.50108
R7231 VSS.n706 VSS.t135 3.50108
R7232 VSS.t68 VSS.t1110 3.50108
R7233 VSS.t952 VSS.t1137 3.50108
R7234 VSS.t225 VSS.t140 3.50108
R7235 VSS.t166 VSS.t356 3.50108
R7236 VSS.n424 VSS.t242 2.33461
R7237 VSS.n323 VSS.n7 2.33238
R7238 VSS.t1211 VSS.n386 0.0931939
R7239 VSS.n420 VSS.t1140 0.114356
R7240 VSS.n1352 VSS.t264 2.83383
R7241 VSS.n581 VSS.t264 2.72109
R7242 VSS.t357 VSS.n235 0.315714
R7243 VSS.t193 VSS.t42 2.54935
R7244 VSS.t36 VSS.t667 2.54935
R7245 VSS.t14 VSS.t341 2.54935
R7246 VSS.t546 VSS.t75 2.54935
R7247 VSS.t394 VSS.t197 2.54935
R7248 VSS.n1222 VSS.t271 2.42907
R7249 VSS.n432 VSS.t1614 0.0817382
R7250 VSS.t636 VSS.t1542 2.30357
R7251 VSS.n431 VSS.t1604 0.0934511
R7252 VSS.t38 VSS.t285 2.28014
R7253 VSS.t166 VSS.t305 2.28014
R7254 VSS.n862 VSS.t225 2.01392
R7255 VSS.t118 VSS.n862 2.01392
R7256 VSS.n582 VSS.t264 1.97636
R7257 VSS.n616 VSS.t948 1.97631
R7258 VSS.n1293 VSS.t253 1.88989
R7259 VSS.t269 VSS.t21 1.88939
R7260 VSS.t266 VSS.n1135 1.88939
R7261 VSS.t493 VSS.n706 1.88939
R7262 VSS.t92 VSS.t179 1.76521
R7263 VSS.n7 VSS.n1486 1.61539
R7264 VSS.t2302 VSS.t1173 1.54026
R7265 VSS.t269 VSS.t42 1.41717
R7266 VSS.t36 VSS.t253 1.41717
R7267 VSS.t14 VSS.t264 1.41717
R7268 VSS.t546 VSS.t266 1.41717
R7269 VSS.t1542 VSS.t394 1.41717
R7270 VSS.n586 VSS.t264 1.36595
R7271 VSS.t17 VSS.n106 1.40351
R7272 VSS.t136 VSS.t201 1.32939
R7273 VSS.t674 VSS.n1008 1.32495
R7274 VSS.t392 VSS.t432 1.3186
R7275 VSS.n288 VSS.t953 0.946262
R7276 VSS.n286 VSS.t107 1.12828
R7277 VSS.t2 VSS.n385 1.00713
R7278 VSS.t369 VSS.t468 1.215
R7279 VSS.t937 VSS.t1155 1.20982
R7280 VSS.n284 VSS.t493 0.983655
R7281 VSS.n812 VSS.t242 1.20433
R7282 VSS.t120 VSS.n1090 1.19869
R7283 VSS.t56 VSS.t5 1.18628
R7284 VSS.t437 VSS.t373 1.18546
R7285 VSS.t839 VSS.t48 1.17126
R7286 VSS.t91 VSS.n279 0.895757
R7287 VSS.t176 VSS.t407 1.1675
R7288 VSS.t369 VSS.t1132 1.16504
R7289 VSS.t192 VSS.t22 1.1454
R7290 VSS.n407 VSS.t393 1.25582
R7291 VSS.n784 VSS.t58 1.1384
R7292 VSS.t2014 VSS.t850 1.1344
R7293 VSS.t779 VSS.t1053 1.13329
R7294 VSS.t48 VSS.t54 1.12989
R7295 VSS.t645 VSS.t182 1.1244
R7296 VSS.t132 VSS.n718 1.12031
R7297 VSS.t1852 VSS.n257 0.92272
R7298 VSS.n1083 VSS.t1083 1.10965
R7299 VSS.t109 VSS.t596 1.10958
R7300 VSS.t291 VSS.t2045 1.10931
R7301 VSS.t161 VSS.t174 1.10845
R7302 VSS.n548 VSS.t222 1.1075
R7303 VSS.n346 VSS.t122 1.14842
R7304 VSS.n1272 VSS.t26 1.10601
R7305 VSS.n9 VSS.t293 0.453017
R7306 VSS.t5 VSS.t69 1.10048
R7307 VSS.t37 VSS.t253 1.09637
R7308 VSS.t204 VSS.t437 1.09498
R7309 VSS.t2010 VSS.t2014 1.08817
R7310 VSS.t677 VSS.t863 1.08755
R7311 VSS.t169 VSS.t1127 1.08152
R7312 VSS.n1166 VSS.t206 1.07918
R7313 VSS.n580 VSS.t190 1.07885
R7314 VSS.n1308 VSS.t99 1.07099
R7315 VSS.n415 VSS.t585 1.11959
R7316 VSS.t10 VSS.t258 1.0685
R7317 VSS.t242 VSS.n862 1.063
R7318 VSS.n387 VSS.t74 1.12966
R7319 VSS.n1271 VSS.t19 1.05848
R7320 VSS.t596 VSS.t76 1.05274
R7321 VSS.n1295 VSS.t31 1.05212
R7322 VSS.t2045 VSS.t1997 1.04935
R7323 VSS.n1049 VSS.t634 1.0489
R7324 VSS.t291 VSS.n468 1.04819
R7325 VSS.t101 VSS.t284 1.04797
R7326 VSS.n1166 VSS.t825 1.04729
R7327 VSS.n585 VSS.t83 1.04634
R7328 VSS.t759 VSS.t101 1.04578
R7329 VSS.t523 VSS.t7 1.04337
R7330 VSS.t1707 VSS.t645 1.04199
R7331 VSS.n580 VSS.t260 1.04143
R7332 VSS.t2005 VSS.t2010 1.04075
R7333 VSS.t1056 VSS.n873 1.04056
R7334 VSS.n9 VSS.t279 1.22208
R7335 VSS.n583 VSS.t97 1.0394
R7336 VSS.n731 VSS.t134 1.03912
R7337 VSS.n724 VSS.t132 1.03909
R7338 VSS.n613 VSS.t67 1.03446
R7339 VSS.n614 VSS.t196 1.03345
R7340 VSS.n584 VSS.t81 1.02748
R7341 VSS.t201 VSS.t239 1.02703
R7342 VSS.n1295 VSS.t99 1.02592
R7343 VSS.n811 VSS.t113 1.02468
R7344 VSS.t388 VSS.t260 1.02241
R7345 VSS.t545 VSS.t83 1.02113
R7346 VSS.n1308 VSS.t284 1.02107
R7347 VSS.n811 VSS.t726 1.02085
R7348 VSS.t969 VSS.t79 1.01702
R7349 VSS.t1130 VSS.t1127 1.01517
R7350 VSS.t1981 VSS.t1987 1.01385
R7351 VSS.t653 VSS.t199 1.01285
R7352 VSS.n585 VSS.t15 1.01189
R7353 VSS.n976 VSS.t124 1.01057
R7354 VSS.t81 VSS.t545 1.00936
R7355 VSS.n1049 VSS.t72 1.009
R7356 VSS.n287 VSS.t11 1.09742
R7357 VSS.n615 VSS.t159 1.007
R7358 VSS.t199 VSS.t79 1.00535
R7359 VSS.n614 VSS.t67 1.00505
R7360 VSS.t382 VSS.t380 1.00497
R7361 VSS.t839 VSS.t375 1.00479
R7362 VSS.n542 VSS.t232 1.00407
R7363 VSS.t50 VSS.n251 0.136987
R7364 VSS.t702 VSS.t812 1.00386
R7365 VSS.t1099 VSS.n292 1.07584
R7366 VSS.t402 VSS.t52 1.00263
R7367 VSS.n1239 VSS.t479 1.00254
R7368 VSS.t1055 VSS.t1098 1.00017
R7369 VSS.t585 VSS.n976 0.998453
R7370 VSS.n369 VSS.t740 0.850511
R7371 VSS.t538 VSS.n374 1.05902
R7372 VSS.n583 VSS.t441 0.991353
R7373 VSS.n1090 VSS.t86 0.988645
R7374 VSS.n613 VSS.t182 0.984822
R7375 VSS.t248 VSS.t86 0.984798
R7376 VSS.n291 VSS.t13 1.0625
R7377 VSS.t1053 VSS.t812 0.981793
R7378 VSS.t46 VSS.t653 0.980677
R7379 VSS.t161 VSS.n1083 0.97995
R7380 VSS.t850 VSS.t273 0.979936
R7381 VSS.t192 VSS.t273 0.979854
R7382 VSS.t253 VSS.n1271 0.975449
R7383 VSS.t674 VSS.n740 0.975151
R7384 VSS.n315 VSS.t759 0.726357
R7385 VSS.n615 VSS.t196 0.972646
R7386 VSS.t1155 VSS.t1130 0.971075
R7387 VSS.t227 VSS.n942 0.969179
R7388 VSS.n1239 VSS.t11 0.966808
R7389 VSS.n584 VSS.t97 0.966671
R7390 VSS.t420 VSS.t2518 0.964843
R7391 VSS.n290 VSS.t420 0.076345
R7392 VSS.t762 VSS.t122 0.964373
R7393 VSS.t331 VSS.t245 0.963431
R7394 VSS.t1997 VSS.t1999 0.96171
R7395 VSS.n784 VSS.t56 0.958882
R7396 VSS.t153 VSS.n548 0.957697
R7397 VSS.t103 VSS.t248 0.949829
R7398 VSS.t1999 VSS.t2002 0.948045
R7399 VSS.t54 VSS.t402 0.944166
R7400 VSS.t9 VSS.t7 0.929643
R7401 VSS.t117 VSS.n32 0.86358
R7402 VSS.t1112 VSS.n285 0.0802057
R7403 VSS.t174 VSS.t120 0.920429
R7404 VSS.n1165 VSS.t271 0.911564
R7405 VSS.t702 VSS.n357 0.0661794
R7406 VSS.t1981 VSS.t1973 0.902454
R7407 VSS.t2002 VSS.t2005 0.889716
R7408 VSS.n291 VSS.t271 0.728237
R7409 VSS.n285 VSS.t242 0.728125
R7410 VSS.n32 VSS.t242 0.728101
R7411 VSS.n373 VSS.t1058 0.736831
R7412 VSS.t375 VSS.t407 0.86725
R7413 VSS.n1466 VSS.t232 0.866086
R7414 VSS.n731 VSS.t373 0.861284
R7415 VSS.t1971 VSS.t1973 0.849232
R7416 VSS.t1108 VSS.t1112 0.846403
R7417 VSS.t136 VSS.t786 0.837845
R7418 VSS.t150 VSS.t331 0.816357
R7419 VSS.n1272 VSS.t19 0.805504
R7420 VSS.t331 VSS.t948 0.801022
R7421 VSS.n724 VSS.t134 0.800764
R7422 VSS.n373 VSS.t362 0.960812
R7423 VSS.t169 VSS.n290 0.662883
R7424 VSS.n873 VSS.t1099 0.799263
R7425 VSS.t204 VSS.n740 0.790943
R7426 VSS.n812 VSS.t1315 0.790059
R7427 VSS.t779 VSS.n315 0.722607
R7428 VSS.t1132 VSS.t1127 0.777003
R7429 VSS.n1165 VSS.t279 0.769461
R7430 VSS.n542 VSS.t222 0.762495
R7431 VSS.n1271 VSS.t31 0.755899
R7432 VSS.n468 VSS.t1987 0.74103
R7433 VSS.n1165 VSS.t825 0.739676
R7434 VSS.t2 VSS.n542 0.728118
R7435 VSS.t2302 VSS.n292 0.605056
R7436 VSS.t674 VSS.t402 0.727823
R7437 VSS.t2 VSS.n387 0.609849
R7438 VSS.t2 VSS.n251 0.505311
R7439 VSS.t253 VSS.n357 0.610739
R7440 VSS.t124 VSS.n284 0.760785
R7441 VSS.t50 VSS.t74 0.702633
R7442 VSS.t26 VSS.t37 0.697243
R7443 VSS.n812 VSS.t113 0.692275
R7444 VSS.t1971 VSS.t1966 0.691888
R7445 VSS.n385 VSS.t153 0.752778
R7446 VSS.t2 VSS.n99 0.68391
R7447 VSS.t674 VSS.n141 0.68391
R7448 VSS.t674 VSS.n118 0.68391
R7449 VSS.n1172 VSS.t271 0.666899
R7450 VSS.n1176 VSS.t271 0.666899
R7451 VSS.n1234 VSS.t271 0.666899
R7452 VSS.n1230 VSS.t271 0.666899
R7453 VSS.n1191 VSS.t271 0.666899
R7454 VSS.n1186 VSS.t271 0.666899
R7455 VSS.n1279 VSS.t253 0.666899
R7456 VSS.t253 VSS.n56 0.666899
R7457 VSS.t253 VSS.n55 0.666899
R7458 VSS.n1323 VSS.t264 0.666899
R7459 VSS.n1328 VSS.t264 0.666899
R7460 VSS.n1142 VSS.t266 0.666899
R7461 VSS.t2 VSS.n79 0.666899
R7462 VSS.t2 VSS.n78 0.666899
R7463 VSS.n650 VSS.t948 0.666899
R7464 VSS.n649 VSS.t948 0.666899
R7465 VSS.n640 VSS.t948 0.666899
R7466 VSS.t1542 VSS.n270 0.666899
R7467 VSS.t674 VSS.n129 0.666899
R7468 VSS.t242 VSS.n11 0.666899
R7469 VSS.n854 VSS.t242 0.666899
R7470 VSS.n853 VSS.t242 0.666899
R7471 VSS.n990 VSS.t2302 0.666899
R7472 VSS.t169 VSS.n213 0.666899
R7473 VSS.t169 VSS.n215 0.666899
R7474 VSS.t169 VSS.n214 0.666899
R7475 VSS.t169 VSS.n189 0.666899
R7476 VSS.t169 VSS.n190 0.666899
R7477 VSS.t169 VSS.n210 0.666899
R7478 VSS.t169 VSS.n209 0.666899
R7479 VSS.t169 VSS.n195 0.666899
R7480 VSS.n1492 VSS.n433 0.66578
R7481 VSS.n1243 VSS.n433 0.66578
R7482 VSS.n1244 VSS.n1243 0.66578
R7483 VSS.n1244 VSS.n1158 0.66578
R7484 VSS.n1158 VSS.n1157 0.66578
R7485 VSS.n1157 VSS.n1054 0.66578
R7486 VSS.n1054 VSS.n1053 0.66578
R7487 VSS.n1053 VSS.n612 0.66578
R7488 VSS.n1006 VSS.n612 0.66578
R7489 VSS.n1006 VSS.n1005 0.66578
R7490 VSS.n1490 VSS.n434 0.66578
R7491 VSS.n1318 VSS.n434 0.66578
R7492 VSS.n1319 VSS.n1318 0.66578
R7493 VSS.n1319 VSS.n587 0.66578
R7494 VSS.n1051 VSS.n587 0.66578
R7495 VSS.n1052 VSS.n1051 0.66578
R7496 VSS.n1052 VSS.n1050 0.66578
R7497 VSS.n1050 VSS.n653 0.66578
R7498 VSS.n1004 VSS.n653 0.66578
R7499 VSS.n1286 VSS.t253 0.664341
R7500 VSS.t2302 VSS.n873 0.663224
R7501 VSS.t674 VSS.n724 0.663162
R7502 VSS.t674 VSS.n731 0.663017
R7503 VSS.t269 VSS.t2005 0.662798
R7504 VSS.t269 VSS.t273 0.662518
R7505 VSS.n1276 VSS.t253 0.655024
R7506 VSS.t253 VSS.n54 0.655024
R7507 VSS.t253 VSS.n38 0.655024
R7508 VSS.n1139 VSS.t266 0.655024
R7509 VSS.n987 VSS.t2302 0.655024
R7510 VSS.t269 VSS.n528 0.649813
R7511 VSS.t269 VSS.n527 0.649813
R7512 VSS.t269 VSS.n436 0.649813
R7513 VSS.t269 VSS.n520 0.649813
R7514 VSS.t269 VSS.n442 0.649813
R7515 VSS.t269 VSS.n445 0.649813
R7516 VSS.t269 VSS.n446 0.649813
R7517 VSS.t269 VSS.n447 0.649813
R7518 VSS.t269 VSS.n515 0.649813
R7519 VSS.t269 VSS.n451 0.649813
R7520 VSS.t269 VSS.n511 0.649813
R7521 VSS.t269 VSS.n455 0.649813
R7522 VSS.t269 VSS.n507 0.649813
R7523 VSS.t269 VSS.n458 0.649813
R7524 VSS.t269 VSS.n463 0.649813
R7525 VSS.t269 VSS.n501 0.649813
R7526 VSS.t269 VSS.n500 0.649813
R7527 VSS.t269 VSS.n465 0.649813
R7528 VSS.t269 VSS.n472 0.649813
R7529 VSS.t269 VSS.n483 0.649813
R7530 VSS.t253 VSS.n62 0.649813
R7531 VSS.t253 VSS.n59 0.649813
R7532 VSS.t253 VSS.n61 0.649813
R7533 VSS.t253 VSS.n60 0.649813
R7534 VSS.t253 VSS.n51 0.649813
R7535 VSS.t253 VSS.n50 0.649813
R7536 VSS.t253 VSS.n49 0.649813
R7537 VSS.t253 VSS.n48 0.649813
R7538 VSS.t253 VSS.n45 0.649813
R7539 VSS.t253 VSS.n44 0.649813
R7540 VSS.t253 VSS.n43 0.649813
R7541 VSS.t253 VSS.n36 0.649813
R7542 VSS.t253 VSS.n42 0.649813
R7543 VSS.t253 VSS.n41 0.649813
R7544 VSS.t253 VSS.n40 0.649813
R7545 VSS.t253 VSS.n39 0.649813
R7546 VSS.t253 VSS.n37 0.649813
R7547 VSS.n1341 VSS.t264 0.649813
R7548 VSS.n1343 VSS.t264 0.649813
R7549 VSS.n1358 VSS.t264 0.649813
R7550 VSS.n1360 VSS.t264 0.649813
R7551 VSS.n1368 VSS.t264 0.649813
R7552 VSS.n1371 VSS.t264 0.649813
R7553 VSS.n1377 VSS.t264 0.649813
R7554 VSS.n1380 VSS.t264 0.649813
R7555 VSS.n1383 VSS.t264 0.649813
R7556 VSS.n1384 VSS.t264 0.649813
R7557 VSS.n1387 VSS.t264 0.649813
R7558 VSS.t264 VSS.n255 0.0258175
R7559 VSS.n1431 VSS.t264 0.649813
R7560 VSS.n1427 VSS.t264 0.649813
R7561 VSS.n1423 VSS.t264 0.649813
R7562 VSS.n1413 VSS.t264 0.649813
R7563 VSS.n1409 VSS.t264 0.649813
R7564 VSS.n1407 VSS.t264 0.649813
R7565 VSS.n1405 VSS.t264 0.649813
R7566 VSS.t1365 VSS.n103 0.649813
R7567 VSS.n634 VSS.t948 0.649813
R7568 VSS.t674 VSS.n108 0.649813
R7569 VSS.t674 VSS.n109 0.649813
R7570 VSS.t674 VSS.n133 0.649813
R7571 VSS.t674 VSS.n132 0.649813
R7572 VSS.t674 VSS.n111 0.649813
R7573 VSS.t674 VSS.n128 0.649813
R7574 VSS.t674 VSS.n127 0.649813
R7575 VSS.t674 VSS.n125 0.649813
R7576 VSS.t674 VSS.n114 0.649813
R7577 VSS.t674 VSS.n115 0.649813
R7578 VSS.t674 VSS.n123 0.649813
R7579 VSS.t674 VSS.n117 0.649813
R7580 VSS.t674 VSS.n121 0.649813
R7581 VSS.t674 VSS.n120 0.649813
R7582 VSS.t674 VSS.n119 0.649813
R7583 VSS.t242 VSS.n18 0.649813
R7584 VSS.t242 VSS.n17 0.649813
R7585 VSS.t242 VSS.n12 0.649813
R7586 VSS.t242 VSS.n13 0.649813
R7587 VSS.t242 VSS.n16 0.649813
R7588 VSS.t242 VSS.n15 0.649813
R7589 VSS.t242 VSS.n14 0.649813
R7590 VSS.n940 VSS.t242 0.649813
R7591 VSS.t169 VSS.n193 0.649813
R7592 VSS.t253 VSS.n52 0.648546
R7593 VSS.n1346 VSS.t264 0.648546
R7594 VSS.n1400 VSS.t264 0.648546
R7595 VSS.t674 VSS.n112 0.648546
R7596 VSS.t169 VSS.n194 0.648546
R7597 VSS.t269 VSS.n530 0.648101
R7598 VSS.n1224 VSS.t271 0.648101
R7599 VSS.n1216 VSS.t271 0.648101
R7600 VSS.n1215 VSS.t271 0.648101
R7601 VSS.n1212 VSS.t271 0.648101
R7602 VSS.n1210 VSS.t271 0.648101
R7603 VSS.n1209 VSS.t271 0.648101
R7604 VSS.n1199 VSS.t271 0.648101
R7605 VSS.n1195 VSS.t271 0.648101
R7606 VSS.n1182 VSS.t271 0.648101
R7607 VSS.n1291 VSS.t253 0.648101
R7608 VSS.t253 VSS.n58 0.648101
R7609 VSS.t253 VSS.n53 0.648101
R7610 VSS.n1321 VSS.t264 0.648101
R7611 VSS.t266 VSS.n217 0.648101
R7612 VSS.t266 VSS.n234 0.648101
R7613 VSS.t266 VSS.n218 0.648101
R7614 VSS.t266 VSS.n219 0.648101
R7615 VSS.t266 VSS.n233 0.648101
R7616 VSS.t266 VSS.n220 0.648101
R7617 VSS.t266 VSS.n221 0.648101
R7618 VSS.t266 VSS.n231 0.648101
R7619 VSS.t266 VSS.n230 0.648101
R7620 VSS.t266 VSS.n223 0.648101
R7621 VSS.t266 VSS.n224 0.648101
R7622 VSS.t266 VSS.n228 0.648101
R7623 VSS.t266 VSS.n226 0.648101
R7624 VSS.t266 VSS.n227 0.648101
R7625 VSS.t816 VSS.n243 0.648101
R7626 VSS.t816 VSS.n246 0.648101
R7627 VSS.t816 VSS.n245 0.648101
R7628 VSS.t816 VSS.n240 0.648101
R7629 VSS.t816 VSS.n241 0.648101
R7630 VSS.t816 VSS.n237 0.648101
R7631 VSS.t816 VSS.n238 0.648101
R7632 VSS.t816 VSS.n239 0.648101
R7633 VSS.n275 VSS.t816 0.0256865
R7634 VSS.t816 VSS.n236 0.368551
R7635 VSS.t2 VSS.n96 0.648101
R7636 VSS.t2 VSS.n95 0.648101
R7637 VSS.t2 VSS.n84 0.648101
R7638 VSS.t2 VSS.n85 0.648101
R7639 VSS.t2 VSS.n94 0.648101
R7640 VSS.t2 VSS.n93 0.648101
R7641 VSS.t2 VSS.n92 0.648101
R7642 VSS.t2 VSS.n86 0.648101
R7643 VSS.t2 VSS.n88 0.648101
R7644 VSS.t2 VSS.n89 0.0256865
R7645 VSS.t2 VSS.n72 0.648101
R7646 VSS.n150 VSS.t2 0.0256865
R7647 VSS.t2 VSS.n81 0.648101
R7648 VSS.t2 VSS.n77 0.648101
R7649 VSS.t2 VSS.n76 0.648101
R7650 VSS.t2 VSS.n75 0.648101
R7651 VSS.t1365 VSS.n104 0.648101
R7652 VSS.n643 VSS.t948 0.648101
R7653 VSS.t1542 VSS.n271 0.648101
R7654 VSS.t493 VSS.n171 0.648101
R7655 VSS.t493 VSS.n184 0.648101
R7656 VSS.t493 VSS.n182 0.648101
R7657 VSS.t493 VSS.n181 0.648101
R7658 VSS.t493 VSS.n180 0.648101
R7659 VSS.t493 VSS.n179 0.648101
R7660 VSS.t493 VSS.n178 0.648101
R7661 VSS.t493 VSS.n177 0.648101
R7662 VSS.t493 VSS.n172 0.648101
R7663 VSS.t493 VSS.n176 0.648101
R7664 VSS.t493 VSS.n173 0.648101
R7665 VSS.t493 VSS.n175 0.648101
R7666 VSS.t493 VSS.n174 0.648101
R7667 VSS.t493 VSS.n158 0.648101
R7668 VSS.t493 VSS.n169 0.648101
R7669 VSS.t493 VSS.n168 0.648101
R7670 VSS.t493 VSS.n159 0.648101
R7671 VSS.t493 VSS.n167 0.648101
R7672 VSS.t493 VSS.n160 0.648101
R7673 VSS.t493 VSS.n161 0.648101
R7674 VSS.t493 VSS.n163 0.648101
R7675 VSS.t493 VSS.n164 0.0256865
R7676 VSS.t493 VSS.n157 0.648101
R7677 VSS.t493 VSS.n156 0.648101
R7678 VSS.t493 VSS.n153 0.648101
R7679 VSS.t493 VSS.n155 0.648101
R7680 VSS.t493 VSS.n154 0.648101
R7681 VSS.t493 VSS.n170 0.648101
R7682 VSS.n409 VSS.t493 0.0256865
R7683 VSS.t674 VSS.n113 0.648101
R7684 VSS.n843 VSS.t242 0.648101
R7685 VSS.n838 VSS.t242 0.648101
R7686 VSS.n832 VSS.t242 0.648101
R7687 VSS.n822 VSS.t242 0.648101
R7688 VSS.n824 VSS.t242 0.648101
R7689 VSS.n829 VSS.t242 0.648101
R7690 VSS.t169 VSS.n188 0.648101
R7691 VSS.t169 VSS.n208 0.648101
R7692 VSS.t169 VSS.n207 0.648101
R7693 VSS.t169 VSS.n205 0.648101
R7694 VSS.t169 VSS.n196 0.648101
R7695 VSS.t169 VSS.n197 0.648101
R7696 VSS.t169 VSS.n202 0.648101
R7697 VSS.t169 VSS.n200 0.648101
R7698 VSS.t169 VSS.n201 0.648101
R7699 VSS.t169 VSS.n186 0.648101
R7700 VSS.t169 VSS.n187 0.648101
R7701 VSS.t169 VSS.n185 0.648101
R7702 VSS.t696 VSS.n429 136.673
R7703 VSS.t674 VSS.n138 0.647276
R7704 VSS.t2 VSS.n100 0.646387
R7705 VSS.t674 VSS.n139 0.646387
R7706 VSS.n740 VSS.t52 0.64131
R7707 VSS.n7 VSS.t762 0.612535
R7708 VSS.t15 VSS.n586 0.609708
R7709 VSS.t816 VSS.n374 0.509472
R7710 VSS.t266 VSS.t248 0.604514
R7711 VSS.t10 VSS.t271 0.586707
R7712 VSS.t1999 VSS.t269 0.570572
R7713 VSS.n615 VSS.t948 0.553129
R7714 VSS.t2 VSS.n1466 0.552998
R7715 VSS.t117 VSS.n279 1.09572
R7716 VSS.t266 VSS.n1083 0.552959
R7717 VSS.t388 VSS.n257 0.111502
R7718 VSS.n584 VSS.t264 0.55264
R7719 VSS.n1239 VSS.t271 0.552591
R7720 VSS.t2 VSS.n548 0.552508
R7721 VSS.n287 VSS.t271 0.423371
R7722 VSS.n1049 VSS.t1542 0.552276
R7723 VSS.t493 VSS.t79 0.552268
R7724 VSS.t674 VSS.t375 0.55194
R7725 VSS.t1098 VSS.t2302 0.548887
R7726 VSS.t422 VSS.n235 0.490017
R7727 VSS.t357 VSS.t1436 0.535865
R7728 VSS.t762 VSS.t210 0.535307
R7729 VSS.n614 VSS.t948 0.506655
R7730 VSS.n976 VSS.t493 0.505809
R7731 VSS.n585 VSS.t264 0.505766
R7732 VSS.n613 VSS.t948 0.505696
R7733 VSS.n583 VSS.t264 0.505657
R7734 VSS.n407 VSS.t786 0.0578381
R7735 VSS.t101 VSS.t253 0.505037
R7736 VSS.t266 VSS.n1090 0.505014
R7737 VSS.t242 VSS.n784 0.504932
R7738 VSS.n616 VSS.t150 0.496237
R7739 VSS.n582 VSS.t441 0.496229
R7740 VSS.t493 VSS.t653 0.476561
R7741 VSS.n369 VSS.t103 1.08686
R7742 VSS.t569 VSS.n256 1.12546
R7743 VSS.t253 VSS.n1295 0.463156
R7744 VSS.t253 VSS.n1308 0.463143
R7745 VSS.n811 VSS.t242 0.463041
R7746 VSS.n9 VSS.t271 0.201156
R7747 VSS.n148 VSS.t176 0.078889
R7748 VSS.t382 VSS.n288 0.0788348
R7749 VSS.t545 VSS.t264 0.462794
R7750 VSS.n415 VSS.t493 0.39163
R7751 VSS.t596 VSS.t266 0.462477
R7752 VSS.t569 VSS.n582 0.461196
R7753 VSS.t1058 VSS.n372 0.548061
R7754 VSS.t1605 VSS.t1604 0.455586
R7755 VSS.t997 VSS.n431 0.343079
R7756 VSS.n372 VSS.t1805 0.340139
R7757 VSS.t159 VSS.n616 0.44619
R7758 VSS.t269 VSS.n468 0.429125
R7759 VSS.t1056 VSS.t1173 0.428814
R7760 VSS.n580 VSS.t264 0.423657
R7761 VSS.n1166 VSS.t271 0.423335
R7762 VSS.t149 VSS.n645 0.419846
R7763 VSS.n645 VSS.t66 0.419846
R7764 VSS.n420 VSS.t1138 0.291407
R7765 VSS.t342 VSS.n586 0.417453
R7766 VSS.n581 VSS.t571 0.401611
R7767 VSS.t645 VSS.t948 0.398318
R7768 VSS.n432 VSS.t1605 0.295388
R7769 VSS.n1272 VSS.t253 0.388125
R7770 VSS.t253 VSS.t1053 0.387886
R7771 VSS.t266 VSS.t174 0.387835
R7772 VSS.t72 VSS.t636 0.383912
R7773 VSS.t269 VSS.t1971 0.383106
R7774 VSS.t269 VSS.t2045 0.36686
R7775 VSS.n1478 VSS.t17 0.36115
R7776 VSS.n1167 VSS.t316 0.360471
R7777 VSS.n7 VSS.n346 0.302362
R7778 VSS.t674 VSS.t437 0.355752
R7779 VSS.t242 VSS.t5 0.355691
R7780 VSS.t190 VSS.n581 0.35105
R7781 VSS.t663 VSS.t1211 0.344973
R7782 VSS.t1219 VSS.n314 0.331025
R7783 VSS.n411 VSS.t1660 0.433869
R7784 VSS.t1663 VSS.n413 0.433869
R7785 VSS.t542 VSS.n314 0.328656
R7786 VSS.n386 VSS.t60 0.238005
R7787 VSS.t1614 VSS.t468 0.338964
R7788 VSS.t1658 VSS.n411 0.235729
R7789 VSS.t1660 VSS.n413 0.235729
R7790 VSS.t493 VSS.t201 0.326228
R7791 VSS.n323 VSS.t2083 0.0850573
R7792 VSS.t39 VSS.n1167 0.301114
R7793 VSS.t1433 VSS.t91 0.301114
R7794 VSS.t13 VSS.n289 0.118323
R7795 VSS.t309 VSS.n266 0.17801
R7796 VSS.t70 VSS.t1124 0.301114
R7797 VSS.t949 VSS.n306 0.418807
R7798 VSS.t395 VSS.t583 0.301114
R7799 VSS.t396 VSS.t1059 0.301114
R7800 VSS.t520 VSS.t521 0.301114
R7801 VSS.t172 VSS.n618 0.301114
R7802 VSS.t519 VSS.n151 0.118323
R7803 VSS.t1208 VSS.n579 0.301114
R7804 VSS.t1837 VSS.t1849 0.301114
R7805 VSS.t1829 VSS.t1842 0.301114
R7806 VSS.t393 VSS.n261 0.231997
R7807 VSS.t1436 VSS.t931 0.300775
R7808 VSS.t423 VSS.t422 0.300775
R7809 VSS.n301 VSS.t180 0.418597
R7810 VSS.n810 VSS.t953 0.300775
R7811 VSS.t384 VSS.t70 0.300775
R7812 VSS.n618 VSS.t481 0.300775
R7813 VSS.n307 VSS.t949 0.177814
R7814 VSS.n306 VSS.t1353 0.177814
R7815 VSS.t583 VSS.n105 0.369774
R7816 VSS.t1353 VSS.t1059 0.300775
R7817 VSS.n617 VSS.t519 0.300775
R7818 VSS.n286 VSS.t937 1.25072
R7819 VSS.n106 VSS.t9 0.0564889
R7820 VSS.t498 VSS.t111 0.283644
R7821 VSS.t111 VSS.n383 0.0914569
R7822 VSS.t674 VSS.t48 0.274811
R7823 VSS.t269 VSS.t22 0.255732
R7824 VSS.t1651 VSS.t309 0.248522
R7825 VSS.t269 VSS.t2014 0.24247
R7826 VSS.n261 VSS.t500 0.531845
R7827 VSS.t1315 VSS.n419 0.119605
R7828 VSS.n152 VSS.t164 0.360183
R7829 VSS.t1083 VSS.n312 0.119605
R7830 VSS.n398 VSS.t245 0.119605
R7831 VSS.n260 VSS.t1441 0.235599
R7832 VSS.n708 VSS.t512 0.241078
R7833 VSS.t435 VSS.t587 0.241078
R7834 VSS.t1138 VSS.n810 0.241078
R7835 VSS.n425 VSS.t423 0.119605
R7836 VSS.t306 VSS.n426 0.360183
R7837 VSS.t307 VSS.n872 0.241078
R7838 VSS.n300 VSS.t927 0.119605
R7839 VSS.n872 VSS.t927 0.241078
R7840 VSS.t831 VSS.t867 0.241078
R7841 VSS.n418 VSS.t867 0.119605
R7842 VSS.n419 VSS.t922 0.360183
R7843 VSS.t180 VSS.n302 0.119605
R7844 VSS.n299 VSS.t433 0.235599
R7845 VSS.t514 VSS.n708 0.241078
R7846 VSS.n305 VSS.t512 0.119605
R7847 VSS.t516 VSS.n309 0.235599
R7848 VSS.t438 VSS.n308 0.235599
R7849 VSS.n397 VSS.t395 0.119605
R7850 VSS.t1441 VSS.t438 0.241078
R7851 VSS.t481 VSS.t129 0.241078
R7852 VSS.t1360 VSS.t172 0.241078
R7853 VSS.n617 VSS.t576 0.241078
R7854 VSS.n946 VSS.t1669 0.232973
R7855 VSS.n901 VSS.t1609 0.232973
R7856 VSS.t169 VSS.t369 0.231809
R7857 VSS.n645 VSS.t948 0.227167
R7858 VSS.t256 VSS.t1941 0.227075
R7859 VSS.t845 VSS.t1813 0.227075
R7860 VSS.t853 VSS.t997 0.227075
R7861 VSS.t1885 VSS.t542 0.227075
R7862 VSS.t60 VSS.t1757 0.227075
R7863 VSS.t2068 VSS.t2070 0.226736
R7864 VSS.t2075 VSS.t2073 0.226736
R7865 VSS.t2078 VSS.t2080 0.226736
R7866 VSS.t2165 VSS.t2163 0.226736
R7867 VSS.t2170 VSS.t2168 0.226736
R7868 VSS.t2175 VSS.t2173 0.226736
R7869 VSS.t2180 VSS.t2178 0.226736
R7870 VSS.t2185 VSS.t2183 0.226736
R7871 VSS.t2190 VSS.t2188 0.226736
R7872 VSS.t2193 VSS.t563 0.226736
R7873 VSS.t2153 VSS.t2155 0.226736
R7874 VSS.t2148 VSS.t2150 0.226736
R7875 VSS.t2143 VSS.t2145 0.226736
R7876 VSS.t2138 VSS.t2140 0.226736
R7877 VSS.t2133 VSS.t2135 0.226736
R7878 VSS.t2128 VSS.t2130 0.226736
R7879 VSS.t2123 VSS.t2125 0.226736
R7880 VSS.t2118 VSS.t2120 0.226736
R7881 VSS.t2113 VSS.t2115 0.226736
R7882 VSS.t2108 VSS.t2110 0.226736
R7883 VSS.t2103 VSS.t2105 0.226736
R7884 VSS.t2098 VSS.t2100 0.226736
R7885 VSS.t2093 VSS.t2095 0.226736
R7886 VSS.t2090 VSS.t2088 0.226736
R7887 VSS.t1908 VSS.t1906 0.226736
R7888 VSS.t1913 VSS.t1911 0.226736
R7889 VSS.t1918 VSS.t1916 0.226736
R7890 VSS.t1923 VSS.t1921 0.226736
R7891 VSS.t1928 VSS.t1926 0.226736
R7892 VSS.t1931 VSS.t1933 0.226736
R7893 VSS.t1938 VSS.t1936 0.226736
R7894 VSS.t1964 VSS.t1963 0.226736
R7895 VSS.t1862 VSS.t1860 0.226736
R7896 VSS.t1867 VSS.t1865 0.226736
R7897 VSS.t1872 VSS.t1870 0.226736
R7898 VSS.t1877 VSS.t1875 0.226736
R7899 VSS.t1882 VSS.t1880 0.226736
R7900 VSS.t1787 VSS.t1785 0.226736
R7901 VSS.t1792 VSS.t1790 0.226736
R7902 VSS.t1797 VSS.t1795 0.226736
R7903 VSS.t1724 VSS.t1722 0.226736
R7904 VSS.t1729 VSS.t1727 0.226736
R7905 VSS.t1734 VSS.t1732 0.226736
R7906 VSS.t1739 VSS.t1737 0.226736
R7907 VSS.t1744 VSS.t1742 0.226736
R7908 VSS.t1749 VSS.t1747 0.226736
R7909 VSS.t1754 VSS.t1752 0.226736
R7910 VSS.t1683 VSS.t1685 0.226736
R7911 VSS.t1690 VSS.t1688 0.226736
R7912 VSS.t1693 VSS.t1695 0.226736
R7913 VSS.t1700 VSS.t1698 0.226736
R7914 VSS.t1705 VSS.t1703 0.226736
R7915 VSS.n280 VSS.t1644 0.135098
R7916 VSS.t1618 VSS.t1620 0.226736
R7917 VSS.t1625 VSS.t1623 0.226736
R7918 VSS.t1628 VSS.t1630 0.226736
R7919 VSS.n384 VSS.t344 0.312561
R7920 VSS.t1206 VSS.t1781 0.226736
R7921 VSS.t1849 VSS.n295 0.0895683
R7922 VSS.t781 VSS.t1800 0.226736
R7923 VSS.t1676 VSS.t1498 0.226736
R7924 VSS.t1803 VSS.t1805 0.224575
R7925 VSS.t230 VSS.t1658 0.224575
R7926 VSS.t1842 VSS.n294 0.0886049
R7927 VSS.t1215 VSS.n579 0.221736
R7928 VSS.t269 VSS.t1981 0.220778
R7929 VSS.n105 VSS.t163 0.116473
R7930 VSS.n325 VSS.t2093 0.0863258
R7931 VSS.n326 VSS.t2098 0.0863258
R7932 VSS.n327 VSS.t2103 0.0863258
R7933 VSS.n328 VSS.t2108 0.0863258
R7934 VSS.n329 VSS.t2113 0.0863258
R7935 VSS.n330 VSS.t2118 0.0863258
R7936 VSS.n331 VSS.t2123 0.0863258
R7937 VSS.n332 VSS.t2128 0.0863258
R7938 VSS.n333 VSS.t2133 0.0863258
R7939 VSS.n334 VSS.t2138 0.0863258
R7940 VSS.n335 VSS.t2143 0.0863258
R7941 VSS.n336 VSS.t2148 0.0863258
R7942 VSS.n337 VSS.t2153 0.0863258
R7943 VSS.n338 VSS.t2158 0.0863258
R7944 VSS.t2193 VSS.n345 0.0863258
R7945 VSS.t2163 VSS.n339 0.0863258
R7946 VSS.t2168 VSS.n340 0.0863258
R7947 VSS.t2173 VSS.n341 0.0863258
R7948 VSS.t2178 VSS.n342 0.0863258
R7949 VSS.t2183 VSS.n343 0.0863258
R7950 VSS.t2188 VSS.n344 0.0863258
R7951 VSS.t1781 VSS.n382 0.0863258
R7952 VSS.t1752 VSS.n395 0.0863258
R7953 VSS.t1880 VSS.n363 0.0863258
R7954 VSS.n359 VSS.t1859 0.130189
R7955 VSS.t1865 VSS.n360 0.0863258
R7956 VSS.t1870 VSS.n361 0.0863258
R7957 VSS.t1875 VSS.n362 0.0863258
R7958 VSS.n353 VSS.t1931 0.0863258
R7959 VSS.n356 VSS.t1962 0.130189
R7960 VSS.t1936 VSS.n354 0.0863258
R7961 VSS.t1926 VSS.n352 0.0863258
R7962 VSS.t2067 VSS.n320 0.130189
R7963 VSS.n322 VSS.t2078 0.0863258
R7964 VSS.t2073 VSS.n321 0.0863258
R7965 VSS.n348 VSS.t1905 0.130189
R7966 VSS.t1911 VSS.n349 0.0863258
R7967 VSS.t1916 VSS.n350 0.0863258
R7968 VSS.t1921 VSS.n351 0.0863258
R7969 VSS.n377 VSS.t1784 0.130189
R7970 VSS.n378 VSS.t1789 0.130189
R7971 VSS.n379 VSS.t1794 0.130189
R7972 VSS.n375 VSS.t1799 0.130189
R7973 VSS.n389 VSS.t1721 0.130189
R7974 VSS.t1727 VSS.n390 0.0863258
R7975 VSS.t1732 VSS.n391 0.0863258
R7976 VSS.t1737 VSS.n392 0.0863258
R7977 VSS.t1682 VSS.n400 0.130189
R7978 VSS.n402 VSS.t1693 0.0863258
R7979 VSS.t1688 VSS.n401 0.0863258
R7980 VSS.t1643 VSS.t1642 0.218325
R7981 VSS.t1617 VSS.n421 0.130189
R7982 VSS.n423 VSS.t1628 0.0863258
R7983 VSS.t1623 VSS.n422 0.0863258
R7984 VSS.t1703 VSS.n404 0.0863258
R7985 VSS.n403 VSS.t1698 0.0863258
R7986 VSS.n393 VSS.t1742 0.0863258
R7987 VSS.t1747 VSS.n394 0.0863258
R7988 VSS.t2088 VSS.n324 0.0863258
R7989 VSS.t538 VSS.n368 0.129991
R7990 VSS.n371 VSS.t1803 0.0861948
R7991 VSS.t1669 VSS.n410 0.129991
R7992 VSS.t1609 VSS.n430 0.129991
R7993 VSS.t1830 VSS.n264 0.335808
R7994 VSS.t674 VSS.n718 0.213167
R7995 VSS.t2158 VSS.n1491 0.210486
R7996 VSS.n355 VSS.t1941 0.0818513
R7997 VSS.t1884 VSS.n364 0.123414
R7998 VSS.t1756 VSS.n396 0.123414
R7999 VSS.t1649 VSS.n303 0.119725
R8000 VSS.n718 VSS.t863 0.194259
R8001 VSS.t228 VSS.n266 0.308308
R8002 VSS.t523 VSS.n1466 0.185716
R8003 VSS.t105 VSS.n427 0.180789
R8004 VSS.n366 VSS.t89 0.24604
R8005 VSS.n254 VSS.t1135 0.120486
R8006 VSS.n416 VSS.t1646 0.24604
R8007 VSS.n417 VSS.t1649 0.238594
R8008 VSS.n578 VSS.t1835 0.180789
R8009 VSS.t169 VSS.t1155 0.179795
R8010 VSS.t1140 VSS.t58 0.17801
R8011 VSS.n949 VSS.t1676 0.170825
R8012 VSS.n148 VSS.t228 1.11668
R8013 VSS.t479 VSS.n1240 0.167426
R8014 VSS.t1208 VSS.t1852 0.167039
R8015 VSS.n273 VSS.t1647 0.0836055
R8016 VSS.n293 VSS.t1828 0.0823774
R8017 VSS.t1780 VSS.t477 0.164539
R8018 VSS.t1835 VSS.n297 0.0820912
R8019 VSS.t1832 VSS.t1833 0.164539
R8020 VSS.t76 VSS.t547 0.163868
R8021 VSS.n1478 VSS.t887 0.159236
R8022 VSS.t1828 VSS.t1829 0.158289
R8023 VSS.t1836 VSS.t1837 0.158289
R8024 VSS.n414 VSS.t1663 0.0793054
R8025 VSS.n7 VSS.n6 0.155751
R8026 VSS.n7 VSS.n5 0.155751
R8027 VSS.n7 VSS.n4 0.155751
R8028 VSS.n7 VSS.n3 0.155751
R8029 VSS.n7 VSS.n2 0.155751
R8030 VSS.n7 VSS.n1 0.155751
R8031 VSS.n7 VSS.t2189 43.5659
R8032 VSS.t2154 VSS.n7 43.5659
R8033 VSS.t2144 VSS.n7 43.5659
R8034 VSS.t2129 VSS.n7 43.5659
R8035 VSS.t2119 VSS.n7 43.5659
R8036 VSS.t2104 VSS.n7 43.5659
R8037 VSS.n7 VSS.t2089 43.5659
R8038 VSS.n7 VSS.t2084 43.5659
R8039 VSS.n7 VSS.t2074 43.5657
R8040 VSS.n365 VSS.t918 0.0697521
R8041 VSS.n424 VSS.t1108 0.217128
R8042 VSS.n317 VSS.t256 0.230905
R8043 VSS.t2085 VSS.t2083 0.135506
R8044 VSS.t1665 VSS.n949 0.130789
R8045 VSS.n281 VSS.t455 0.0642264
R8046 VSS.n367 VSS.t1834 0.185751
R8047 VSS.t206 VSS.n291 0.878824
R8048 VSS.t1839 VSS.n366 0.0333775
R8049 VSS.t969 VSS.t239 0.090789
R8050 VSS.t915 VSS.t107 0.0905
R8051 VSS.t1648 VSS.n417 0.0296542
R8052 VSS.t2070 VSS.t2072 0.0855
R8053 VSS.t2077 VSS.t2075 0.0855
R8054 VSS.t2080 VSS.t2082 0.0855
R8055 VSS.t2162 VSS.t2160 0.0855
R8056 VSS.t2167 VSS.t2165 0.0855
R8057 VSS.t2172 VSS.t2170 0.0855
R8058 VSS.t2177 VSS.t2175 0.0855
R8059 VSS.t2182 VSS.t2180 0.0855
R8060 VSS.t2187 VSS.t2185 0.0855
R8061 VSS.t2192 VSS.t2190 0.0855
R8062 VSS.t2155 VSS.t2157 0.0855
R8063 VSS.t2150 VSS.t2152 0.0855
R8064 VSS.t2145 VSS.t2147 0.0855
R8065 VSS.t2140 VSS.t2142 0.0855
R8066 VSS.t2135 VSS.t2137 0.0855
R8067 VSS.t2130 VSS.t2132 0.0855
R8068 VSS.t2125 VSS.t2127 0.0855
R8069 VSS.t2120 VSS.t2122 0.0855
R8070 VSS.t2115 VSS.t2117 0.0855
R8071 VSS.t2110 VSS.t2112 0.0855
R8072 VSS.t2105 VSS.t2107 0.0855
R8073 VSS.t2100 VSS.t2102 0.0855
R8074 VSS.t2095 VSS.t2097 0.0855
R8075 VSS.t2092 VSS.t2090 0.0855
R8076 VSS.t2085 VSS.t2087 0.0855
R8077 VSS.t1910 VSS.t1908 0.0855
R8078 VSS.t1915 VSS.t1913 0.0855
R8079 VSS.t1920 VSS.t1918 0.0855
R8080 VSS.t1923 VSS.t1925 0.0855
R8081 VSS.t1930 VSS.t1928 0.0855
R8082 VSS.t1933 VSS.t1935 0.0855
R8083 VSS.t1962 VSS.t1204 0.0855
R8084 VSS.t1864 VSS.t1862 0.0855
R8085 VSS.t1869 VSS.t1867 0.0855
R8086 VSS.t1874 VSS.t1872 0.0855
R8087 VSS.t1879 VSS.t1877 0.0855
R8088 VSS.t1789 VSS.t1787 0.0855
R8089 VSS.t1794 VSS.t1792 0.0855
R8090 VSS.t1799 VSS.t1797 0.0855
R8091 VSS.t781 VSS.t820 0.0855
R8092 VSS.t740 VSS.t1813 0.0855
R8093 VSS.t1726 VSS.t1724 0.0855
R8094 VSS.t1731 VSS.t1729 0.0855
R8095 VSS.t1736 VSS.t1734 0.0855
R8096 VSS.t1739 VSS.t1741 0.0855
R8097 VSS.t1746 VSS.t1744 0.0855
R8098 VSS.t1751 VSS.t1749 0.0855
R8099 VSS.t1685 VSS.t1687 0.0855
R8100 VSS.t1692 VSS.t1690 0.0855
R8101 VSS.t1695 VSS.t1697 0.0855
R8102 VSS.t1700 VSS.t1702 0.0855
R8103 VSS.t1644 VSS.t1645 0.0855
R8104 VSS.t1135 VSS.t69 0.0855
R8105 VSS.t1620 VSS.t1622 0.0855
R8106 VSS.t1627 VSS.t1625 0.0855
R8107 VSS.t1940 VSS.t1938 0.07425
R8108 VSS.t1882 VSS.t1884 0.07425
R8109 VSS.t1902 VSS.t1219 0.07425
R8110 VSS.t1754 VSS.t1756 0.07425
R8111 VSS.t1707 VSS.n310 0.0377157
R8112 VSS.t1647 VSS.t1648 0.07425
R8113 VSS.t1630 VSS.t1632 0.07425
R8114 VSS.t380 VSS.t726 0.07175
R8115 VSS.t1834 VSS.n577 0.0705
R8116 VSS.n946 VSS.t312 0.0697501
R8117 VSS.n901 VSS.t400 0.0697501
R8118 VSS.t237 VSS.n1240 0.0642198
R8119 VSS.t634 VSS.t433 0.060789
R8120 VSS.n578 VSS.n577 0.0505
R8121 VSS.t915 VSS.n427 0.0305
R8122 VSS.t2 VSS.n83 0.0284977
R8123 VSS.t674 VSS.n142 0.0284977
R8124 VSS.t674 VSS.n140 0.0275327
R8125 VSS.t2 VSS.n82 0.027532
R8126 VSS.t253 VSS.n46 0.0271432
R8127 VSS.t253 VSS.n57 0.0266767
R8128 VSS.n642 VSS.t948 0.0266763
R8129 VSS.t1542 VSS.n269 0.0266763
R8130 VSS.t674 VSS.n130 0.0266763
R8131 VSS.t169 VSS.n212 0.0266763
R8132 VSS.t269 VSS.n525 0.0258175
R8133 VSS.t269 VSS.n518 0.0258175
R8134 VSS.t269 VSS.n448 0.0258175
R8135 VSS.t269 VSS.n514 0.0258175
R8136 VSS.t269 VSS.n452 0.0258175
R8137 VSS.t269 VSS.n510 0.0258175
R8138 VSS.t269 VSS.n456 0.0258175
R8139 VSS.t269 VSS.n505 0.0258175
R8140 VSS.t269 VSS.n460 0.0258175
R8141 VSS.t269 VSS.n461 0.0258175
R8142 VSS.t269 VSS.n503 0.0258175
R8143 VSS.t269 VSS.n466 0.0258175
R8144 VSS.t269 VSS.n467 0.0258175
R8145 VSS.t269 VSS.n497 0.0258175
R8146 VSS.t269 VSS.n496 0.0258175
R8147 VSS.t269 VSS.n470 0.0258175
R8148 VSS.t269 VSS.n494 0.0258175
R8149 VSS.t269 VSS.n473 0.0258175
R8150 VSS.t269 VSS.n492 0.0258175
R8151 VSS.t269 VSS.n475 0.0258175
R8152 VSS.t269 VSS.n490 0.0258175
R8153 VSS.t269 VSS.n477 0.0258175
R8154 VSS.t269 VSS.n488 0.0258175
R8155 VSS.t269 VSS.n479 0.0258175
R8156 VSS.t269 VSS.n486 0.0258175
R8157 VSS.t269 VSS.n481 0.0258175
R8158 VSS.t269 VSS.n484 0.0258175
R8159 VSS.t1932 VSS.t271 109.992
R8160 VSS.t271 VSS.t1927 109.992
R8161 VSS.t253 VSS.n47 0.0258175
R8162 VSS.t253 VSS.n63 0.0258175
R8163 VSS.t253 VSS.n64 0.0258175
R8164 VSS.t253 VSS.n35 0.0258175
R8165 VSS.n66 VSS.t1871 109.992
R8166 VSS.n1338 VSS.t264 0.0258175
R8167 VSS.n1364 VSS.t264 0.0258175
R8168 VSS.n1392 VSS.t264 0.0258175
R8169 VSS.n1416 VSS.t264 0.0258175
R8170 VSS.n1402 VSS.t264 0.0258175
R8171 VSS.n631 VSS.t948 0.0258175
R8172 VSS.n71 VSS.t1704 109.992
R8173 VSS.t948 VSS.n70 0.00916143
R8174 VSS.t674 VSS.n137 0.0258175
R8175 VSS.t674 VSS.n136 0.0258175
R8176 VSS.t674 VSS.n135 0.0258175
R8177 VSS.t674 VSS.n134 0.0258175
R8178 VSS.t674 VSS.n110 0.0258175
R8179 VSS.t674 VSS.n131 0.0258175
R8180 VSS.t674 VSS.n126 0.0258175
R8181 VSS.t674 VSS.n116 0.0258175
R8182 VSS.t674 VSS.n124 0.0258175
R8183 VSS.t674 VSS.n122 0.0258175
R8184 VSS.t169 VSS.n191 0.0258175
R8185 VSS.t169 VSS.n192 0.0258175
R8186 VSS.t169 VSS.n211 0.0258175
R8187 VSS.t266 VSS.n232 0.0256865
R8188 VSS.t266 VSS.n222 0.0256865
R8189 VSS.t266 VSS.n229 0.0256865
R8190 VSS.t266 VSS.n225 0.0256865
R8191 VSS.t816 VSS.n244 0.0256865
R8192 VSS.t816 VSS.n242 0.0256865
R8193 VSS.t816 VSS.n249 0.00911134
R8194 VSS.t816 VSS.n248 0.0148087
R8195 VSS.t2 VSS.n98 0.0256865
R8196 VSS.t2 VSS.n97 0.0256865
R8197 VSS.t2 VSS.n91 0.0256865
R8198 VSS.t2 VSS.n87 0.0256865
R8199 VSS.t2 VSS.n90 0.0256865
R8200 VSS.t2 VSS.n74 0.0256865
R8201 VSS.t2 VSS.n272 3.73731
R8202 VSS.n1436 VSS.t2 0.0256865
R8203 VSS.t2 VSS.n80 0.0256865
R8204 VSS.n265 VSS.t0 93.7036
R8205 VSS.t493 VSS.n183 0.0256865
R8206 VSS.t493 VSS.n162 0.0256865
R8207 VSS.t493 VSS.n166 0.0256865
R8208 VSS.t493 VSS.n165 0.0256865
R8209 VSS.t169 VSS.n206 0.0256865
R8210 VSS.t169 VSS.n204 0.0256865
R8211 VSS.t169 VSS.n198 0.0256865
R8212 VSS.t169 VSS.n203 0.0256865
R8213 VSS.t169 VSS.n199 0.0256865
R8214 VSS.n931 VSS.t169 0.0256865
R8215 VSS VSS.n1492 0.01986
R8216 VSS.n1491 VSS.t2160 0.01675
R8217 VSS.t269 VSS.n499 0.00194928
R8218 VSS.t269 VSS.n493 0.00194928
R8219 VSS.t269 VSS.n474 0.00194928
R8220 VSS.t269 VSS.n491 0.00194928
R8221 VSS.t269 VSS.n476 0.00194928
R8222 VSS.t269 VSS.n489 0.00194928
R8223 VSS.t269 VSS.n478 0.00194928
R8224 VSS.t269 VSS.n487 0.00194928
R8225 VSS.t269 VSS.n480 0.00194928
R8226 VSS.t269 VSS.n485 0.00194928
R8227 VSS.t269 VSS.n482 0.00194928
R8228 VSS.n101 VSS.n318 0.00166667
R8229 VSS.n319 VSS.t887 8.61398
R8230 VSS.t2302 VSS.t169 0.0364616
R8231 VSS.n406 VSS.t1365 0.0330475
R8232 VSS.t816 VSS.t266 0.0253793
R8233 VSS.t948 VSS.n69 0.0238141
R8234 VSS.t253 VSS.n65 0.0235547
R8235 VSS.t2 VSS.n73 0.0214518
R8236 VSS.t674 VSS.n145 0.0201017
R8237 VSS.t2 VSS.n262 0.0200316
R8238 VSS.n67 VSS.n268 0.0194628
R8239 VSS.t948 VSS.n259 0.0193371
R8240 VSS.t264 VSS.n268 0.0187288
R8241 VSS.n252 VSS.t493 0.0179415
R8242 VSS.t2 VSS.n101 0.0174198
R8243 VSS.n68 VSS.n365 4.24345
R8244 VSS.n27 VSS.t271 1.27372
R8245 VSS.n31 VSS.t242 1.09621
R8246 VSS.n7 VSS.n0 1.05816
R8247 VSS.n7 VSS.n10 1.00353
R8248 sg13cmos5l_o21ai_1_5.A2.n4 sg13cmos5l_o21ai_1_5.A2 33.0167
R8249 sg13cmos5l_o21ai_1_5.A2.n0 sg13cmos5l_o21ai_1_5.A2 30.2706
R8250 sg13cmos5l_o21ai_1_5.A2.n0 sg13cmos5l_o21ai_1_5.A2 29.5522
R8251 sg13cmos5l_o21ai_1_5.A2.n5 sg13cmos5l_o21ai_1_5.A2.n4 26.7386
R8252 sg13cmos5l_o21ai_1_5.A2.n3 sg13cmos5l_o21ai_1_5.A2.n2 22.4472
R8253 sg13cmos5l_o21ai_1_5.A2.n2 sg13cmos5l_o21ai_1_5.A2 18.8863
R8254 sg13cmos5l_o21ai_1_5.A2.n1 sg13cmos5l_o21ai_1_5.A2 18.5561
R8255 sg13cmos5l_o21ai_1_5.A2.n3 sg13cmos5l_o21ai_1_5.A2 18.5519
R8256 sg13cmos5l_o21ai_1_5.A2.n4 sg13cmos5l_o21ai_1_5.A2.n3 16.0736
R8257 sg13cmos5l_o21ai_1_5.A2 sg13cmos5l_o21ai_1_5.A2.t1 15.0005
R8258 sg13cmos5l_o21ai_1_5.A2.n1 sg13cmos5l_o21ai_1_5.A2.n0 11.1125
R8259 sg13cmos5l_o21ai_1_5.A2.n5 sg13cmos5l_o21ai_1_5.A2 10.3557
R8260 sg13cmos5l_o21ai_1_5.A2.n0 sg13cmos5l_o21ai_1_5.A2 9.55745
R8261 sg13cmos5l_o21ai_1_5.A2 sg13cmos5l_o21ai_1_5.A2.n5 9.10376
R8262 sg13cmos5l_o21ai_1_5.A2.n2 sg13cmos5l_o21ai_1_5.A2.n1 5.7029
R8263 sg13cmos5l_o21ai_1_5.A2 sg13cmos5l_o21ai_1_5.A2.t0 5.6237
R8264 sg13cmos5l_buf_8_2.A.n0 sg13cmos5l_buf_8_2.A 54.7924
R8265 sg13cmos5l_buf_8_2.A.n3 sg13cmos5l_buf_8_2.A.n2 46.9528
R8266 sg13cmos5l_buf_8_2.A.n6 sg13cmos5l_buf_8_2.A 46.4697
R8267 sg13cmos5l_buf_8_2.A.n2 sg13cmos5l_buf_8_2.A 33.3346
R8268 sg13cmos5l_buf_8_2.A.n1 sg13cmos5l_buf_8_2.A 31.1333
R8269 sg13cmos5l_buf_8_2.A.n3 sg13cmos5l_buf_8_2.A 23.5123
R8270 sg13cmos5l_buf_8_2.A.n5 sg13cmos5l_buf_8_2.A.n0 22.0743
R8271 sg13cmos5l_buf_8_2.A.t0 sg13cmos5l_buf_8_2.A.n6 20.662
R8272 sg13cmos5l_buf_8_2.A.n4 sg13cmos5l_buf_8_2.A 19.8455
R8273 sg13cmos5l_buf_8_2.A.n6 sg13cmos5l_buf_8_2.A.n5 18.3167
R8274 sg13cmos5l_buf_8_2.A.n1 sg13cmos5l_buf_8_2.A 18.1212
R8275 sg13cmos5l_buf_8_2.A.n0 sg13cmos5l_buf_8_2.A 18.0005
R8276 sg13cmos5l_buf_8_2.A.n2 sg13cmos5l_buf_8_2.A.n1 14.1367
R8277 sg13cmos5l_buf_8_2.A.n5 sg13cmos5l_buf_8_2.A.n4 12.3767
R8278 sg13cmos5l_buf_8_2.A sg13cmos5l_buf_8_2.A.t6 5.07593
R8279 sg13cmos5l_buf_8_2.A sg13cmos5l_buf_8_2.A.t7 5.07515
R8280 sg13cmos5l_buf_8_2.A.n4 sg13cmos5l_buf_8_2.A.n3 5.06626
R8281 sg13cmos5l_buf_8_2.A sg13cmos5l_buf_8_2.A.t5 5.00562
R8282 sg13cmos5l_buf_8_2.A sg13cmos5l_buf_8_2.A.t3 4.98179
R8283 sg13cmos5l_buf_8_2.A sg13cmos5l_buf_8_2.A.t1 4.98179
R8284 sg13cmos5l_buf_8_2.A sg13cmos5l_buf_8_2.A.t2 4.95591
R8285 sg13cmos5l_buf_8_2.A sg13cmos5l_buf_8_2.A.t4 4.95591
R8286 sg13cmos5l_buf_8_2.A sg13cmos5l_buf_8_2.A.t0 1.9649
R8287 sg13cmos5l_dfrbpq_1_28.RESET_B.t2 sg13cmos5l_dfrbpq_1_28.RESET_B.t1 33.4028
R8288 sg13cmos5l_dfrbpq_1_28.RESET_B.t4 sg13cmos5l_dfrbpq_1_28.RESET_B.t3 33.4028
R8289 sg13cmos5l_dfrbpq_1_28.RESET_B.t6 sg13cmos5l_dfrbpq_1_28.RESET_B.t5 33.4028
R8290 sg13cmos5l_dfrbpq_1_28.RESET_B.t7 sg13cmos5l_dfrbpq_1_28.RESET_B.t8 33.4028
R8291 sg13cmos5l_dfrbpq_1_28.RESET_B.t11 sg13cmos5l_dfrbpq_1_28.RESET_B.t12 33.4028
R8292 sg13cmos5l_dfrbpq_1_28.RESET_B.t10 sg13cmos5l_dfrbpq_1_28.RESET_B.t9 33.4028
R8293 sg13cmos5l_dfrbpq_1_28.RESET_B.t14 sg13cmos5l_dfrbpq_1_28.RESET_B.t13 33.4028
R8294 sg13cmos5l_dfrbpq_1_28.RESET_B.n5 sg13cmos5l_dfrbpq_1_28.RESET_B.n4 21.3736
R8295 sg13cmos5l_dfrbpq_1_28.RESET_B sg13cmos5l_dfrbpq_1_28.RESET_B.n6 20.9228
R8296 sg13cmos5l_dfrbpq_1_28.RESET_B.n6 sg13cmos5l_dfrbpq_1_28.RESET_B 18.0005
R8297 sg13cmos5l_dfrbpq_1_28.RESET_B sg13cmos5l_dfrbpq_1_28.RESET_B.t2 15.0489
R8298 sg13cmos5l_dfrbpq_1_28.RESET_B sg13cmos5l_dfrbpq_1_28.RESET_B.t4 15.0489
R8299 sg13cmos5l_dfrbpq_1_28.RESET_B sg13cmos5l_dfrbpq_1_28.RESET_B.t6 15.0489
R8300 sg13cmos5l_dfrbpq_1_28.RESET_B sg13cmos5l_dfrbpq_1_28.RESET_B.t10 15.0489
R8301 sg13cmos5l_dfrbpq_1_28.RESET_B sg13cmos5l_dfrbpq_1_28.RESET_B.t14 15.0489
R8302 sg13cmos5l_dfrbpq_1_28.RESET_B sg13cmos5l_dfrbpq_1_28.RESET_B.t7 15.0005
R8303 sg13cmos5l_dfrbpq_1_28.RESET_B sg13cmos5l_dfrbpq_1_28.RESET_B.t11 15.0005
R8304 sg13cmos5l_dfrbpq_1_28.RESET_B.n6 sg13cmos5l_dfrbpq_1_28.RESET_B.n5 14.9141
R8305 sg13cmos5l_dfrbpq_1_28.RESET_B.n5 sg13cmos5l_dfrbpq_1_28.RESET_B.n2 14.7232
R8306 sg13cmos5l_dfrbpq_1_28.RESET_B.n2 sg13cmos5l_dfrbpq_1_28.RESET_B.n0 14.4917
R8307 sg13cmos5l_dfrbpq_1_28.RESET_B.n3 sg13cmos5l_dfrbpq_1_28.RESET_B 12.3269
R8308 sg13cmos5l_dfrbpq_1_28.RESET_B.n1 sg13cmos5l_dfrbpq_1_28.RESET_B 11.7695
R8309 sg13cmos5l_dfrbpq_1_28.RESET_B.n0 sg13cmos5l_dfrbpq_1_28.RESET_B 11.4482
R8310 sg13cmos5l_dfrbpq_1_28.RESET_B.n2 sg13cmos5l_dfrbpq_1_28.RESET_B.n1 11.1125
R8311 sg13cmos5l_dfrbpq_1_28.RESET_B.n0 sg13cmos5l_dfrbpq_1_28.RESET_B 9.96981
R8312 sg13cmos5l_dfrbpq_1_28.RESET_B.n1 sg13cmos5l_dfrbpq_1_28.RESET_B 9.55186
R8313 sg13cmos5l_dfrbpq_1_28.RESET_B.n4 sg13cmos5l_dfrbpq_1_28.RESET_B 9.0005
R8314 sg13cmos5l_dfrbpq_1_28.RESET_B.n3 sg13cmos5l_dfrbpq_1_28.RESET_B 9.0005
R8315 sg13cmos5l_dfrbpq_1_28.RESET_B sg13cmos5l_dfrbpq_1_28.RESET_B.t0 5.69515
R8316 sg13cmos5l_dfrbpq_1_28.RESET_B.n4 sg13cmos5l_dfrbpq_1_28.RESET_B.n3 1.84546
R8317 sg13cmos5l_buf_1_45.X.t13 sg13cmos5l_buf_1_45.X.t12 33.4028
R8318 sg13cmos5l_buf_1_45.X.t9 sg13cmos5l_buf_1_45.X.t8 33.4028
R8319 sg13cmos5l_buf_1_45.X.t15 sg13cmos5l_buf_1_45.X.t14 33.4028
R8320 sg13cmos5l_buf_1_45.X.t11 sg13cmos5l_buf_1_45.X.t10 33.4028
R8321 sg13cmos5l_buf_1_45.X.t7 sg13cmos5l_buf_1_45.X.t6 33.4028
R8322 sg13cmos5l_buf_1_45.X.t5 sg13cmos5l_buf_1_45.X.t4 33.4028
R8323 sg13cmos5l_buf_1_45.X.t1 sg13cmos5l_buf_1_45.X.t2 33.4028
R8324 sg13cmos5l_buf_1_45.X sg13cmos5l_buf_1_45.X.n6 31.8212
R8325 sg13cmos5l_buf_1_45.X.n0 sg13cmos5l_buf_1_45.X 31.0133
R8326 sg13cmos5l_buf_1_45.X.n1 sg13cmos5l_buf_1_45.X 23.6471
R8327 sg13cmos5l_buf_1_45.X.n3 sg13cmos5l_buf_1_45.X.n2 20.693
R8328 sg13cmos5l_buf_1_45.X.n5 sg13cmos5l_buf_1_45.X 20.6639
R8329 sg13cmos5l_buf_1_45.X.n1 sg13cmos5l_buf_1_45.X 18.0005
R8330 sg13cmos5l_buf_1_45.X sg13cmos5l_buf_1_45.X.t15 15.0489
R8331 sg13cmos5l_buf_1_45.X sg13cmos5l_buf_1_45.X.t7 15.0489
R8332 sg13cmos5l_buf_1_45.X sg13cmos5l_buf_1_45.X.t5 15.0489
R8333 sg13cmos5l_buf_1_45.X sg13cmos5l_buf_1_45.X.t11 15.0489
R8334 sg13cmos5l_buf_1_45.X sg13cmos5l_buf_1_45.X.t9 15.0489
R8335 sg13cmos5l_buf_1_45.X sg13cmos5l_buf_1_45.X.t13 15.0489
R8336 sg13cmos5l_buf_1_45.X sg13cmos5l_buf_1_45.X.t3 15.0122
R8337 sg13cmos5l_buf_1_45.X sg13cmos5l_buf_1_45.X.t1 15.0005
R8338 sg13cmos5l_buf_1_45.X.n6 sg13cmos5l_buf_1_45.X.n5 12.7419
R8339 sg13cmos5l_buf_1_45.X.n5 sg13cmos5l_buf_1_45.X.n4 12.2183
R8340 sg13cmos5l_buf_1_45.X.n2 sg13cmos5l_buf_1_45.X.n1 12.1685
R8341 sg13cmos5l_buf_1_45.X.n0 sg13cmos5l_buf_1_45.X 10.4473
R8342 sg13cmos5l_buf_1_45.X.n6 sg13cmos5l_buf_1_45.X 9.28205
R8343 sg13cmos5l_buf_1_45.X.n4 sg13cmos5l_buf_1_45.X 9.0005
R8344 sg13cmos5l_buf_1_45.X.n3 sg13cmos5l_buf_1_45.X 9.0005
R8345 sg13cmos5l_buf_1_45.X sg13cmos5l_buf_1_45.X.t0 5.73774
R8346 sg13cmos5l_buf_1_45.X.n4 sg13cmos5l_buf_1_45.X.n3 3.6173
R8347 sg13cmos5l_buf_1_45.X.n2 sg13cmos5l_buf_1_45.X.n0 1.96646
R8348 sg13cmos5l_buf_1_15.A.n0 sg13cmos5l_buf_1_15.A 50.5388
R8349 sg13cmos5l_buf_1_15.A.n2 sg13cmos5l_buf_1_15.A 42.3944
R8350 sg13cmos5l_buf_1_15.A.n0 sg13cmos5l_buf_1_15.A 40.133
R8351 sg13cmos5l_buf_1_15.A.t3 sg13cmos5l_buf_1_15.A.t4 33.4028
R8352 sg13cmos5l_buf_1_15.A.t6 sg13cmos5l_buf_1_15.A.t5 33.4028
R8353 sg13cmos5l_buf_1_15.A.n3 sg13cmos5l_buf_1_15.A 20.1739
R8354 sg13cmos5l_buf_1_15.A.n2 sg13cmos5l_buf_1_15.A.n1 19.2143
R8355 sg13cmos5l_buf_1_15.A.n1 sg13cmos5l_buf_1_15.A 18.1939
R8356 sg13cmos5l_buf_1_15.A.n3 sg13cmos5l_buf_1_15.A.n2 17.6567
R8357 sg13cmos5l_buf_1_15.A sg13cmos5l_buf_1_15.A.t0 17.0317
R8358 sg13cmos5l_buf_1_15.A.n4 sg13cmos5l_buf_1_15.A.n3 15.7911
R8359 sg13cmos5l_buf_1_15.A sg13cmos5l_buf_1_15.A.t6 15.0489
R8360 sg13cmos5l_buf_1_15.A sg13cmos5l_buf_1_15.A.t3 15.0005
R8361 sg13cmos5l_buf_1_15.A sg13cmos5l_buf_1_15.A.t2 15.0005
R8362 sg13cmos5l_buf_1_15.A sg13cmos5l_buf_1_15.A.t1 15.0005
R8363 sg13cmos5l_buf_1_15.A.n1 sg13cmos5l_buf_1_15.A.n0 12.7991
R8364 sg13cmos5l_buf_1_15.A.n4 sg13cmos5l_buf_1_15.A 10.7781
R8365 sg13cmos5l_buf_1_15.A.t0 sg13cmos5l_buf_1_15.A 9.34537
R8366 sg13cmos5l_buf_1_15.A sg13cmos5l_buf_1_15.A.n4 9.05872
C0 a_20997_12189# VDD 0.24175f
C1 sg13cmos5l_a21oi_1_6.A2 a_19542_9254# 0.04026f
C2 sg13cmos5l_nor2_1_16.Y a_12694_16742# 0.06179f
C3 sg13cmos5l_o21ai_1_15.Y VDD 0.36381f
C4 a_22126_6351# sg13cmos5l_buf_1_4.A 0.10673f
C5 sg13cmos5l_a21oi_1_21.A1 valid 0.04432f
C6 sg13cmos5l_buf_1_15.A a_20503_16710# 0.01035f
C7 sg13cmos5l_nand4_1_1.B bn4 1.21718f
C8 sg13cmos5l_nand4_1_8.B sg13cmos5l_nor4_1_4.C 0.16644f
C9 sg13cmos5l_inv_1_31.A a_19173_19031# 0.2026f
C10 sg13cmos5l_buf_1_65.A sg13cmos5l_dfrbpq_1_13.RESET_B 0.19706f
C11 sg13cmos5l_inv_1_12.A a_20997_9959# 0.02064f
C12 sg13cmos5l_buf_1_25.A a_12040_15272# 0.18135f
C13 sg13cmos5l_buf_1_0.A a_19179_7796# 0.01858f
C14 sg13cmos5l_o21ai_1_13.B1 a_10625_19286# 0.02439f
C15 a_9096_15996# VDD 0.25781f
C16 sg13cmos5l_buf_1_13.A a_18188_4614# 0.02088f
C17 sg13cmos5l_nand4_1_18.D sg13cmos5l_a21oi_1_15.Y 0.08944f
C18 a_21084_18222# a_21866_18416# 0.24435f
C19 sg13cmos5l_buf_1_66.X sg13cmos5l_nand4_1_1.B 0.01768f
C20 sg13cmos5l_buf_1_7.X a_19467_5423# 0.27974f
C21 sg13cmos5l_o21ai_1_6.Y sg13cmos5l_o21ai_1_6.B1 0.12004f
C22 sg13cmos5l_o21ai_1_19.Y sg13cmos5l_nand3b_1_1.C 0.09956f
C23 sg13cmos5l_o21ai_1_0.A1 a_13212_5773# 0.03097f
C24 sg13cmos5l_inv_1_15.Y sg13cmos5l_nor4_1_2.Y 0.02484f
C25 sg13cmos5l_dfrbpq_1_13.RESET_B a_7620_9952# 0.30602f
C26 a_11180_15198# a_11464_15366# 0.01225f
C27 sg13cmos5l_o21ai_1_26.B1 sg13cmos5l_o21ai_1_25.Y 0.03504f
C28 sg13cmos5l_nand2_1_15.B sg13cmos5l_o21ai_1_28.B1 0.17343f
C29 a_21839_13799# a_21745_13799# 0.16704f
C30 a_21215_18528# a_22005_18416# 0.02241f
C31 a_4568_15238# VDD 0.25541f
C32 sg13cmos5l_buf_1_43.X sg13cmos5l_nand4_1_16.D 0.04992f
C33 a_15496_13760# sg13cmos5l_nand2_1_15.Y 0.01873f
C34 a_4127_17016# a_3996_16710# 0.28418f
C35 sg13cmos5l_inv_1_7.Y bp8 0.02129f
C36 sg13cmos5l_buf_1_15.A a_9070_18447# 0.01874f
C37 sg13cmos5l_inv_1_31.A a_20716_16746# 0.01112f
C38 sg13cmos5l_dfrbpq_1_13.CLK sg13cmos5l_buf_1_13.X 0.02797f
C39 sg13cmos5l_o21ai_1_20.B1 sg13cmos5l_o21ai_1_7.Y 0.03826f
C40 a_22506_11460# bp1 0.01169f
C41 a_7507_9380# a_7750_9508# 0.08536f
C42 sg13cmos5l_dfrbpq_1_39.Q bn4 0.02724f
C43 a_22506_6924# bp5 0.06287f
C44 sg13cmos5l_o21ai_1_23.A2 bn1 0.02869f
C45 a_5931_7796# a_5700_7687# 0.07823f
C46 a_6671_7751# a_7338_7972# 0.09257f
C47 a_5412_7992# a_6577_7751# 0.25046f
C48 sg13cmos5l_nand4_1_15.B sg13cmos5l_a21oi_1_6.A2 0.01387f
C49 sg13cmos5l_nand4_1_1.B VDD 0.91609f
C50 sg13cmos5l_inv_1_17.A a_22241_7864# 0.04517f
C51 sg13cmos5l_buf_1_16.A sg13cmos5l_nand4_1_18.D 0.03385f
C52 sg13cmos5l_dfrbpq_1_29.Q a_22506_14484# 0.0759f
C53 sg13cmos5l_and2_1_3.X sg13cmos5l_a21oi_1_16.A2 0.03881f
C54 sg13cmos5l_nand2_1_13.A a_14548_12508# 0.01058f
C55 sg13cmos5l_inv_1_15.A sg13cmos5l_nand4_1_15.B 0.05923f
C56 sg13cmos5l_buf_1_66.X sg13cmos5l_o21ai_1_28.Y 0.04081f
C57 sg13cmos5l_nand4_1_8.B a_16376_15242# 0.01343f
C58 sg13cmos5l_buf_1_3.A a_22126_3327# 0.12502f
C59 sg13cmos5l_nand2b_1_0.B a_13786_7642# 0.01254f
C60 sg13cmos5l_nand4_1_18.B sg13cmos5l_a21oi_1_15.Y 0.0286f
C61 sg13cmos5l_inv_1_25.Y code1 0.0215f
C62 sg13cmos5l_a21oi_1_24.A1 sg13cmos5l_inv_1_25.Y 0.33165f
C63 sg13cmos5l_o21ai_1_19.Y sg13cmos5l_nand3_1_5.Y 0.01813f
C64 a_21462_17532# sg13cmos5l_dfrbpq_1_30.D 0.10685f
C65 sg13cmos5l_and2_1_3.X sg13cmos5l_inv_1_16.Y 0.04993f
C66 sg13cmos5l_a21oi_1_2.Y a_21099_6935# 0.02408f
C67 sg13cmos5l_dlygate4sd3_1_50.A a_4031_15967# 0.01545f
C68 sg13cmos5l_o21ai_1_28.A1 valid 0.05654f
C69 sg13cmos5l_dlygate4sd3_1_51.X sg13cmos5l_dfrbpq_1_24.RESET_B 0.07029f
C70 sg13cmos5l_a22oi_1_0.B2 sg13cmos5l_a22oi_1_0.A2 0.3899f
C71 sg13cmos5l_dfrbpq_1_8.D a_20192_7010# 0.03631f
C72 sg13cmos5l_o21ai_1_10.A2 sg13cmos5l_o21ai_1_8.B1 0.35503f
C73 sg13cmos5l_a21oi_1_9.A2 a_13460_6924# 0.01188f
C74 sg13cmos5l_a21oi_1_1.A2 a_19542_9254# 0.04471f
C75 sg13cmos5l_buf_1_21.A sg13cmos5l_inv_1_20.Y 0.04919f
C76 sg13cmos5l_nand3_1_5.Y a_7238_17508# 0.01888f
C77 sg13cmos5l_inv_1_16.A a_20554_13945# 0.01083f
C78 sg13cmos5l_a21oi_1_18.B1 sg13cmos5l_nand4_1_3.D 0.50317f
C79 sg13cmos5l_dfrbpq_1_39.Q VDD 0.45296f
C80 sg13cmos5l_a21oi_1_7.A2 a_20997_11471# 0.01875f
C81 sg13cmos5l_a21oi_1_27.B1 sg13cmos5l_a21oi_1_12.Y 0.01457f
C82 sg13cmos5l_nand2_1_0.B sg13cmos5l_nand3_1_0.A 0.02463f
C83 a_15610_9912# sg13cmos5l_dlygate4sd3_1_14.A 0.31794f
C84 sg13cmos5l_dlygate4sd3_1_22.A sg13cmos5l_inv_1_4.Y 0.06747f
C85 sg13cmos5l_o21ai_1_28.Y VDD 0.34262f
C86 sg13cmos5l_nand4_1_15.B sg13cmos5l_a21oi_1_17.Y 0.04974f
C87 sg13cmos5l_o21ai_1_14.Y sg13cmos5l_buf_1_66.X 0.14839f
C88 sg13cmos5l_buf_8_2.A a_19160_9190# 0.01116f
C89 a_19930_4618# a_20294_4650# 0.01503f
C90 sg13cmos5l_o21ai_1_7.Y sg13cmos5l_o21ai_1_12.Y 0.01541f
C91 a_14761_15238# a_14957_15532# 0.01485f
C92 sg13cmos5l_nand4_1_18.B sg13cmos5l_buf_1_16.A 0.02478f
C93 sg13cmos5l_buf_8_2.A sg13cmos5l_a21o_1_2.B1 0.04017f
C94 sg13cmos5l_nand4_1_1.A a_18782_12218# 0.01774f
C95 sg13cmos5l_inv_1_1.A sg13cmos5l_buf_1_53.A 0.01583f
C96 a_12496_18478# VDD 0.13686f
C97 sg13cmos5l_nand4_1_8.B sg13cmos5l_o21ai_1_28.B1 0.03401f
C98 a_18762_20068# VDD 0.27541f
C99 sg13cmos5l_inv_1_1.A a_14152_14484# 0.19299f
C100 sg13cmos5l_nand4_1_16.D a_14761_15238# 0.1264f
C101 a_1409_19960# comp 0.01842f
C102 sg13cmos5l_a21o_1_0.A2 sg13cmos5l_a21o_1_0.A1 0.14383f
C103 sg13cmos5l_dfrbpq_1_7.D a_20104_10034# 0.04363f
C104 a_18952_4688# a_18587_4948# 0.03494f
C105 sg13cmos5l_dfrbpq_1_28.RESET_B a_21063_16964# 0.27973f
C106 sg13cmos5l_buf_1_7.X a_20554_9916# 0.03388f
C107 a_12939_19031# VDD 0.22972f
C108 a_7350_17532# VDD 0.16047f
C109 sg13cmos5l_o21ai_1_26.B1 valid 0.02057f
C110 sg13cmos5l_nor3_1_6.Y sg13cmos5l_a21oi_1_7.A2 0.0182f
C111 sg13cmos5l_dfrbpq_1_30.Q a_18670_16263# 0.01007f
C112 sg13cmos5l_inv_1_15.A sg13cmos5l_a21oi_1_15.A2 0.12436f
C113 sg13cmos5l_buf_1_0.A sg13cmos5l_dfrbpq_1_8.D 0.10354f
C114 a_3112_19902# VDD 0.1598f
C115 sg13cmos5l_inv_1_1.Y a_20294_13722# 0.01377f
C116 sg13cmos5l_a21oi_1_10.A2 a_8878_7191# 0.04079f
C117 sg13cmos5l_o21ai_1_14.Y VDD 0.51672f
C118 sg13cmos5l_nand3_1_0.B a_16167_9404# 0.01465f
C119 a_9832_16082# VDD 0.14463f
C120 a_9274_6888# sg13cmos5l_a21oi_1_10.A1 0.0473f
C121 sg13cmos5l_buf_1_43.X a_17445_15213# 0.01513f
C122 sg13cmos5l_a21oi_1_0.Y a_18188_4614# 0.04083f
C123 sg13cmos5l_nor3_1_6.Y sg13cmos5l_a21oi_1_3.A2 0.05498f
C124 sg13cmos5l_buf_1_7.X sg13cmos5l_dlygate4sd3_1_4.A 0.0102f
C125 sg13cmos5l_buf_1_63.A a_12694_16742# 0.0109f
C126 sg13cmos5l_buf_1_15.A sg13cmos5l_dfrbpq_1_45.D 0.05356f
C127 sg13cmos5l_dfrbpq_1_13.RESET_B a_8879_10309# 0.14049f
C128 sg13cmos5l_inv_1_13.Y a_18478_10215# 0.05157f
C129 sg13cmos5l_dfrbpq_1_24.RESET_B a_7498_18226# 0.04112f
C130 sg13cmos5l_buf_1_15.A sg13cmos5l_nand3b_1_1.Y 0.02737f
C131 sg13cmos5l_nand2_1_19.A sg13cmos5l_nand3_1_2.A 0.2689f
C132 sg13cmos5l_a21oi_1_3.A2 sg13cmos5l_inv_1_9.Y 0.22474f
C133 sg13cmos5l_buf_1_1.A sg13cmos5l_a21oi_1_2.B1 0.95925f
C134 a_4823_17137# a_4917_16904# 0.45119f
C135 sg13cmos5l_buf_1_45.X sg13cmos5l_nand2_1_19.A 0.04481f
C136 sg13cmos5l_nand4_1_12.Y bn5 0.60436f
C137 sg13cmos5l_mux2_1_0.A1 a_8200_12342# 0.02404f
C138 sg13cmos5l_dfrbpq_1_13.RESET_B a_5931_7796# 0.28334f
C139 sg13cmos5l_buf_1_25.A bn1 0.73294f
C140 sg13cmos5l_dlygate4sd3_1_18.X a_18478_10215# 0.10682f
C141 sg13cmos5l_and4_1_1.A a_7736_13726# 0.01022f
C142 sg13cmos5l_dfrbpq_1_13.CLK sg13cmos5l_inv_1_13.Y 0.08543f
C143 sg13cmos5l_buf_1_13.X a_17914_9912# 0.04909f
C144 sg13cmos5l_nand4_1_8.B sg13cmos5l_a21oi_1_3.A2 0.03921f
C145 a_7073_19960# a_7354_19738# 0.18796f
C146 sg13cmos5l_buf_1_0.A a_15104_7849# 0.03008f
C147 sg13cmos5l_dlygate4sd3_1_25.A a_17633_10214# 0.01255f
C148 sg13cmos5l_nor3_1_2.Y sg13cmos5l_dlygate4sd3_1_42.A 0.18507f
C149 a_6766_7191# a_6881_7190# 0.3854f
C150 sg13cmos5l_buf_1_53.A sg13cmos5l_dlygate4sd3_1_77.A 0.01789f
C151 sg13cmos5l_a21oi_1_9.B1 a_10864_5654# 0.04581f
C152 sg13cmos5l_nand3_1_0.A a_16586_7832# 0.01868f
C153 sg13cmos5l_inv_1_8.A sg13cmos5l_nand2b_1_0.B 0.02427f
C154 sg13cmos5l_nor2_1_2.A a_7895_6553# 0.02769f
C155 sg13cmos5l_inv_1_31.A sg13cmos5l_dfrbpq_1_35.D 0.01111f
C156 sg13cmos5l_buf_8_2.A sg13cmos5l_nor3_1_2.B 0.06077f
C157 sg13cmos5l_a21oi_1_4.A2 busy 0.03249f
C158 sg13cmos5l_a21oi_1_1.A2 bp2 0.01669f
C159 a_14561_9376# VDD 0.20746f
C160 sg13cmos5l_nor4_1_4.C sg13cmos5l_dfrbpq_1_24.Q 0.1597f
C161 sg13cmos5l_buf_1_10.A sg13cmos5l_dfrbpq_1_11.D 0.14951f
C162 sg13cmos5l_dfrbpq_1_28.RESET_B sg13cmos5l_a21oi_1_13.Y 0.0944f
C163 sg13cmos5l_nand4_1_7.B sg13cmos5l_a21oi_1_4.A2 0.70263f
C164 sg13cmos5l_inv_1_36.Y a_14561_11726# 0.01709f
C165 sg13cmos5l_inv_1_17.A a_22096_14726# 0.01323f
C166 a_4838_9186# a_5412_9199# 0.18486f
C167 a_20997_4629# bp2 0.05842f
C168 sg13cmos5l_nand3b_1_3.C sg13cmos5l_nand2_1_9.Y 0.34998f
C169 a_14724_6480# VDD 0.07342f
C170 sg13cmos5l_nor2b_1_0.B_N a_13198_9228# 0.18277f
C171 sg13cmos5l_nor4_1_4.C sg13cmos5l_inv_1_25.Y 0.04868f
C172 sg13cmos5l_nand2b_1_0.B sg13cmos5l_a22oi_1_2.Y 0.27135f
C173 a_18756_19024# VDD 0.0733f
C174 sg13cmos5l_a22oi_1_0.A2 a_14061_8784# 0.19744f
C175 sg13cmos5l_nand3b_1_0.C sg13cmos5l_nor2b_1_0.B_N 0.01704f
C176 sg13cmos5l_buf_1_57.A a_17002_15457# 0.01442f
C177 sg13cmos5l_dfrbpq_1_13.CLK sg13cmos5l_inv_1_18.A 0.62882f
C178 sg13cmos5l_a21oi_1_4.A2 sg13cmos5l_nand4_1_3.B 0.09616f
C179 sg13cmos5l_buf_1_4.A a_20513_4166# 0.04573f
C180 sg13cmos5l_inv_1_32.Y a_13764_16000# 0.03888f
C181 sg13cmos5l_a22oi_1_0.A2 a_13014_8460# 0.01754f
C182 sg13cmos5l_dfrbpq_1_13.CLK a_11360_9318# 0.02567f
C183 sg13cmos5l_dlygate4sd3_1_24.A a_22506_6924# 0.02581f
C184 sg13cmos5l_buf_1_9.A a_21185_7864# 0.02107f
C185 a_21761_15424# bn7 0.01356f
C186 sg13cmos5l_a21oi_1_2.B1 bn9 0.0547f
C187 a_20997_4629# a_21099_4772# 0.36168f
C188 a_21215_17016# VDD 0.24101f
C189 a_13786_7642# sg13cmos5l_nand2b_1_3.B 0.0117f
C190 a_8637_5682# a_8719_5782# 0.01126f
C191 sg13cmos5l_dfrbpq_1_48.Q VDD 0.34466f
C192 sg13cmos5l_nand2b_1_4.B VDD 0.40734f
C193 sg13cmos5l_buf_1_9.A a_21099_8447# 0.04973f
C194 sg13cmos5l_inv_1_12.A sg13cmos5l_dfrbpq_1_28.Q 0.04474f
C195 a_6730_11428# VDD 0.09587f
C196 a_16078_19287# VDD 0.15704f
C197 sg13cmos5l_inv_1_1.A sg13cmos5l_a21oi_1_2.B1 0.10007f
C198 sg13cmos5l_nand3_1_2.Y sg13cmos5l_nand2_1_19.A 0.26694f
C199 a_5998_13911# VDD 0.15829f
C200 sg13cmos5l_buf_1_21.A sg13cmos5l_nand2_1_0.B 0.02325f
C201 sg13cmos5l_nand4_1_18.B sg13cmos5l_buf_1_22.A 0.02415f
C202 sg13cmos5l_inv_1_1.A sg13cmos5l_nand4_1_3.D 0.4511f
C203 sg13cmos5l_buf_8_2.A sg13cmos5l_a21oi_1_15.Y 0.02221f
C204 sg13cmos5l_buf_1_45.X a_16836_20088# 0.28237f
C205 sg13cmos5l_dfrbpq_1_44.Q VDD 0.27917f
C206 sg13cmos5l_nand4_1_18.B a_9056_13058# 0.01784f
C207 sg13cmos5l_o21ai_1_7.Y sg13cmos5l_dfrbpq_1_24.RESET_B 0.07681f
C208 sg13cmos5l_nand4_1_18.B sg13cmos5l_dfrbpq_1_45.Q 0.2423f
C209 sg13cmos5l_buf_1_57.A busy 0.02608f
C210 a_14181_16007# sg13cmos5l_inv_1_24.Y 0.01361f
C211 a_22241_9376# VDD 0.20473f
C212 sg13cmos5l_nand4_1_18.C sg13cmos5l_inv_1_12.A 0.42338f
C213 sg13cmos5l_nand4_1_7.B sg13cmos5l_buf_1_57.A 0.0283f
C214 a_5318_13410# a_6021_12983# 0.02431f
C215 sg13cmos5l_a21oi_1_4.A2 sg13cmos5l_buf_1_21.A 0.11902f
C216 sg13cmos5l_buf_8_2.A sg13cmos5l_buf_1_16.A 0.21503f
C217 sg13cmos5l_buf_1_13.X a_16631_8065# 0.05522f
C218 sg13cmos5l_inv_1_5.A a_17931_6935# 0.04592f
C219 sg13cmos5l_buf_1_13.X a_18593_10214# 0.01552f
C220 sg13cmos5l_buf_1_63.A a_15760_19990# 0.01059f
C221 a_16954_11424# sg13cmos5l_dlygate4sd3_1_13.X 0.01001f
C222 sg13cmos5l_buf_1_16.A a_19160_9190# 0.05235f
C223 sg13cmos5l_a21oi_1_0.A2 sg13cmos5l_dlygate4sd3_1_1.A 0.01653f
C224 sg13cmos5l_buf_1_24.A a_11656_15272# 0.19421f
C225 sg13cmos5l_nand3b_1_3.C code1 0.08913f
C226 sg13cmos5l_buf_1_57.A sg13cmos5l_nand4_1_3.B 0.02179f
C227 sg13cmos5l_dlygate4sd3_1_50.X a_3900_16357# 0.0129f
C228 sg13cmos5l_and4_1_1.A a_8118_13790# 0.03955f
C229 a_4127_17016# a_4778_16904# 0.01562f
C230 a_7822_19959# a_7937_19960# 0.3854f
C231 a_4607_18528# VDD 0.24571f
C232 sg13cmos5l_inv_1_8.A a_15104_7849# 0.06184f
C233 sg13cmos5l_nand4_1_12.Y sg13cmos5l_buf_1_43.X 0.04673f
C234 sg13cmos5l_dfrbpq_1_15.Q sg13cmos5l_nor4_1_0.C 0.2277f
C235 a_20609_15424# VDD 0.20788f
C236 sg13cmos5l_nand4_1_6.B sg13cmos5l_inv_1_24.A 0.08572f
C237 sg13cmos5l_dfrbpq_1_28.RESET_B sg13cmos5l_dfrbpq_1_28.D 0.06328f
C238 sg13cmos5l_dfrbpq_1_19.CLK code5 0.04497f
C239 sg13cmos5l_o21ai_1_22.Y sg13cmos5l_buf_1_65.A 0.01371f
C240 sg13cmos5l_nand2_1_2.Y VDD 0.53292f
C241 a_13786_7642# a_14230_7670# 0.01359f
C242 sg13cmos5l_dlygate4sd3_1_18.X a_17914_9912# 0.02744f
C243 sg13cmos5l_buf_1_20.A sg13cmos5l_mux2_1_0.A1 0.10429f
C244 sg13cmos5l_inv_1_14.Y sg13cmos5l_dlygate4sd3_1_1.A 0.0652f
C245 sg13cmos5l_o21ai_1_17.Y sg13cmos5l_or4_1_1.X 0.06009f
C246 sg13cmos5l_buf_1_45.X a_14536_14484# 0.01727f
C247 sg13cmos5l_dfrbpq_1_17.Q a_8520_8436# 0.08178f
C248 sg13cmos5l_buf_1_13.A VDD 4.8755f
C249 sg13cmos5l_nand2b_1_1.A_N sg13cmos5l_nor2b_1_0.B_N 0.07442f
C250 sg13cmos5l_dlygate4sd3_1_25.A a_17518_10215# 0.01031f
C251 sg13cmos5l_o21ai_1_15.B1 a_9734_17508# 0.02889f
C252 sg13cmos5l_dfrbpq_1_15.Q sg13cmos5l_nor2_1_2.B 0.16566f
C253 a_19630_15423# VDD 0.1589f
C254 a_13478_16434# bn2 0.01009f
C255 sg13cmos5l_a21oi_1_17.Y a_16085_12508# 0.10322f
C256 sg13cmos5l_buf_1_0.A a_20207_5773# 0.03265f
C257 sg13cmos5l_buf_1_63.A sg13cmos5l_a21oi_1_21.A1 3.21154f
C258 a_16650_6460# VDD 0.27693f
C259 a_14542_7191# sg13cmos5l_dlygate4sd3_1_7.X 0.10798f
C260 a_20015_19381# VDD 0.1744f
C261 sg13cmos5l_a21oi_1_8.A2 a_8021_5412# 0.05566f
C262 sg13cmos5l_nand3_1_6.C a_11884_15996# 0.01295f
C263 sg13cmos5l_inv_1_15.A a_12616_14484# 0.21724f
C264 sg13cmos5l_and2_1_6.A sg13cmos5l_nor2_1_3.Y 0.10287f
C265 sg13cmos5l_inv_1_17.A a_22049_10888# 0.0272f
C266 sg13cmos5l_nand2b_1_0.B sg13cmos5l_nand2_1_5.Y 0.14273f
C267 sg13cmos5l_inv_1_16.A bn8 0.0381f
C268 sg13cmos5l_buf_1_13.A a_16330_5380# 0.02931f
C269 a_20997_4629# a_20868_4663# 0.01562f
C270 sg13cmos5l_inv_1_8.A sg13cmos5l_nand2b_1_3.B 0.02291f
C271 sg13cmos5l_nand2b_1_3.B a_15905_7190# 0.01035f
C272 sg13cmos5l_dfrbpq_1_34.Q sg13cmos5l_dlygate4sd3_1_82.X 0.05f
C273 sg13cmos5l_o21ai_1_20.A1 sg13cmos5l_nand3b_1_1.Y 0.01658f
C274 sg13cmos5l_buf_1_65.A sg13cmos5l_nand2_1_9.Y 0.01405f
C275 sg13cmos5l_buf_1_13.A a_15016_5498# 0.01522f
C276 a_9062_5850# a_9322_5380# 0.45119f
C277 sg13cmos5l_dlygate4sd3_1_76.A sg13cmos5l_a21oi_1_15.A2 0.0519f
C278 sg13cmos5l_a21oi_1_27.A1 a_10112_13058# 0.02246f
C279 a_8272_11702# VDD 0.13602f
C280 sg13cmos5l_dfrbpq_1_41.CLK busy 0.04054f
C281 sg13cmos5l_inv_1_17.A sg13cmos5l_inv_1_12.A 0.02731f
C282 sg13cmos5l_buf_1_9.A a_21070_7863# 0.02152f
C283 sg13cmos5l_nand4_1_18.B sg13cmos5l_buf_1_53.A 0.02009f
C284 a_4360_19808# code7 0.15701f
C285 sg13cmos5l_a21oi_1_0.A2 a_18634_7897# 0.03959f
C286 VDD bp7 0.2703f
C287 sg13cmos5l_dfrbpq_1_41.CLK sg13cmos5l_nand4_1_7.B 0.90903f
C288 sg13cmos5l_a21oi_1_14.Y sg13cmos5l_dfrbpq_1_29.Q 0.3155f
C289 sg13cmos5l_dfrbpq_1_24.RESET_B a_6123_12983# 0.28019f
C290 sg13cmos5l_buf_1_45.X bn5 0.27413f
C291 sg13cmos5l_nand3_1_0.A sg13cmos5l_inv_1_18.Y 0.03837f
C292 sg13cmos5l_nand2_1_15.B a_13575_13940# 0.02271f
C293 sg13cmos5l_buf_8_2.A a_21839_10309# 0.03905f
C294 sg13cmos5l_nand4_1_7.B sg13cmos5l_nand4_1_1.A 0.12536f
C295 sg13cmos5l_dfrbpq_1_29.D a_20294_14922# 0.1833f
C296 sg13cmos5l_inv_1_2.A a_20580_6928# 0.07009f
C297 sg13cmos5l_dlygate4sd3_1_80.X VDD 0.38753f
C298 a_19048_3900# VDD 0.21364f
C299 sg13cmos5l_nand4_1_6.B bn0 0.08201f
C300 sg13cmos5l_buf_1_53.A code0 0.01475f
C301 a_6401_8702# VDD 0.20617f
C302 sg13cmos5l_a21oi_1_0.A2 a_18874_9912# 0.05946f
C303 sg13cmos5l_nand4_1_3.B sg13cmos5l_nand4_1_1.A 0.28583f
C304 sg13cmos5l_buf_8_2.A a_12929_13238# 0.02977f
C305 sg13cmos5l_buf_1_63.A sg13cmos5l_o21ai_1_28.A1 0.30823f
C306 a_5604_12976# a_6123_12983# 0.20754f
C307 a_6021_12983# a_5892_13397# 0.01562f
C308 a_9610_12433# sg13cmos5l_dfrbpq_1_13.RESET_B 0.19027f
C309 sg13cmos5l_dfrbpq_1_24.RESET_B a_5259_14495# 0.28406f
C310 a_13384_14484# bn0 0.15448f
C311 sg13cmos5l_nor2_1_3.Y clk 0.04417f
C312 sg13cmos5l_dfrbpq_1_28.RESET_B a_21099_13844# 0.28127f
C313 sg13cmos5l_inv_1_13.Y a_18593_10214# 0.05507f
C314 sg13cmos5l_buf_1_26.A sg13cmos5l_nand3b_1_1.Y 0.09798f
C315 a_18952_3176# comp_clk 0.15509f
C316 sg13cmos5l_inv_1_1.Y sg13cmos5l_dlygate4sd3_1_22.A 0.01649f
C317 a_6401_16262# sg13cmos5l_o21ai_1_11.A2 0.05511f
C318 bp2 bp8 0.02085f
C319 bp6 bp7 0.0715f
C320 bp9 bp4 0.0137f
C321 sg13cmos5l_nand3b_1_3.C sg13cmos5l_nor4_1_4.C 0.0295f
C322 sg13cmos5l_dlygate4sd3_1_50.X sg13cmos5l_o21ai_1_20.Y 0.08979f
C323 a_7738_7294# sg13cmos5l_a21oi_1_8.A2 0.01572f
C324 sg13cmos5l_buf_1_16.A sg13cmos5l_a21oi_1_15.Y 0.04851f
C325 sg13cmos5l_nand2_1_3.Y a_6394_7294# 0.01581f
C326 sg13cmos5l_nand3_1_0.C a_17024_7010# 0.02369f
C327 sg13cmos5l_dlygate4sd3_1_25.A a_18272_10034# 0.03947f
C328 sg13cmos5l_a21oi_1_24.A2 sg13cmos5l_nand4_1_1.B 0.05522f
C329 sg13cmos5l_a21oi_1_0.Y VDD 0.26238f
C330 sg13cmos5l_mux2_1_0.A1 a_7416_12404# 0.09573f
C331 sg13cmos5l_buf_1_47.X sg13cmos5l_nor2_1_12.Y 0.42152f
C332 sg13cmos5l_nor2_1_10.Y sg13cmos5l_o21ai_1_22.B1 0.03911f
C333 sg13cmos5l_buf_1_63.A sg13cmos5l_o21ai_1_26.B1 0.03934f
C334 a_18497_6352# VDD 0.20878f
C335 sg13cmos5l_nand4_1_18.D sg13cmos5l_a21oi_1_2.B1 0.0902f
C336 a_22126_7863# bp1 0.04453f
C337 sg13cmos5l_inv_1_5.A a_15141_6141# 0.22747f
C338 sg13cmos5l_nand3_1_5.Y sg13cmos5l_nand2_1_11.B 0.12165f
C339 sg13cmos5l_nand4_1_3.D sg13cmos5l_nand4_1_18.D 0.22503f
C340 sg13cmos5l_o21ai_1_22.B1 a_9526_16742# 0.02424f
C341 sg13cmos5l_dfrbpq_1_2.D sg13cmos5l_buf_1_0.A 0.3992f
C342 sg13cmos5l_buf_1_5.A VDD 0.75712f
C343 a_12040_15272# valid 0.1576f
C344 sg13cmos5l_and2_1_3.X sg13cmos5l_a21oi_1_3.A2 0.64255f
C345 a_21839_8797# bp1 0.02366f
C346 sg13cmos5l_nor3_1_0.Y sg13cmos5l_inv_1_20.Y 0.01241f
C347 sg13cmos5l_o21ai_1_21.Y a_3975_16964# 0.03482f
C348 sg13cmos5l_nand2_1_13.A sg13cmos5l_inv_1_8.A 0.0261f
C349 sg13cmos5l_inv_1_32.Y a_13782_15302# 0.04612f
C350 a_12045_11808# sg13cmos5l_buf_1_14.A 0.07464f
C351 sg13cmos5l_buf_1_42.A bn5 0.08142f
C352 a_17355_19892# valid 0.01406f
C353 sg13cmos5l_dfrbpq_1_41.CLK a_12239_18335# 0.01078f
C354 sg13cmos5l_inv_1_17.A a_19530_11460# 0.01668f
C355 sg13cmos5l_dlygate4sd3_1_71.X sg13cmos5l_buf_1_7.X 0.06239f
C356 a_9348_5416# a_9636_5837# 0.24435f
C357 sg13cmos5l_buf_1_7.X a_21839_7285# 0.10879f
C358 sg13cmos5l_buf_1_43.X a_17224_12972# 0.25875f
C359 a_15392_18390# VDD 0.07606f
C360 sg13cmos5l_o21ai_1_17.Y bn3 0.66059f
C361 sg13cmos5l_inv_1_12.A a_19649_13238# 0.02018f
C362 sg13cmos5l_a21oi_1_0.Y bp6 0.1121f
C363 sg13cmos5l_inv_1_15.A sg13cmos5l_nand2_1_15.B 0.10019f
C364 sg13cmos5l_nand4_1_18.B sg13cmos5l_a21oi_1_2.B1 0.01555f
C365 sg13cmos5l_inv_1_12.A bp0 0.98353f
C366 sg13cmos5l_nand4_1_18.B sg13cmos5l_nand4_1_3.D 0.02848f
C367 a_7078_14044# VDD 0.20756f
C368 a_20580_6928# a_20997_6935# 0.28418f
C369 a_20225_19960# VDD 0.20283f
C370 sg13cmos5l_o21ai_1_11.B1 sg13cmos5l_o21ai_1_10.A2 0.1043f
C371 sg13cmos5l_buf_1_0.A a_20398_4167# 0.03464f
C372 sg13cmos5l_inv_1_2.A a_21099_6935# 0.02211f
C373 sg13cmos5l_or4_1_0.D VDD 0.40817f
C374 sg13cmos5l_buf_1_5.A bp6 0.211f
C375 sg13cmos5l_a21oi_1_12.Y a_7616_15366# 0.02195f
C376 sg13cmos5l_o21ai_1_25.Y bn1 0.0109f
C377 sg13cmos5l_inv_1_31.A sg13cmos5l_inv_1_15.A 0.03244f
C378 sg13cmos5l_nand3_1_5.Y a_4114_17886# 0.04814f
C379 sg13cmos5l_a21oi_1_27.A1 a_9350_12210# 0.03465f
C380 sg13cmos5l_buf_1_9.A a_21089_6352# 0.01085f
C381 sg13cmos5l_o21ai_1_19.Y sg13cmos5l_dfrbpq_1_19.CLK 0.17941f
C382 sg13cmos5l_nand3_1_8.Y sg13cmos5l_dfrbpq_1_27.Q 0.03247f
C383 sg13cmos5l_inv_1_0.Y a_18587_4948# 0.0273f
C384 sg13cmos5l_mux2_1_1.A1 a_8796_14020# 0.0152f
C385 a_20580_14040# VDD 0.07255f
C386 sg13cmos5l_or2_1_1.X a_12022_8814# 0.04808f
C387 sg13cmos5l_a21oi_1_21.A1 sg13cmos5l_inv_1_31.A 0.28168f
C388 sg13cmos5l_nor3_1_6.Y sg13cmos5l_a21oi_1_2.A2 0.02037f
C389 a_6123_12983# a_6863_13333# 0.17382f
C390 sg13cmos5l_nor3_1_2.B sg13cmos5l_o21ai_1_0.A2 0.13441f
C391 a_13210_19738# code3 0.06065f
C392 sg13cmos5l_nand2b_1_1.A_N a_8637_5682# 0.11581f
C393 sg13cmos5l_a21oi_1_19.Y bn4 0.02019f
C394 sg13cmos5l_nor4_1_0.C sg13cmos5l_nand3_1_3.Y 0.03751f
C395 sg13cmos5l_dfrbpq_1_28.RESET_B a_21839_13799# 0.10868f
C396 sg13cmos5l_buf_8_2.A sg13cmos5l_buf_1_53.A 0.01816f
C397 sg13cmos5l_nor2_1_2.B sg13cmos5l_dfrbpq_1_47.Q 0.04058f
C398 sg13cmos5l_inv_1_16.Y a_17892_11885# 0.01676f
C399 sg13cmos5l_buf_1_0.A a_20294_7362# 0.04623f
C400 sg13cmos5l_inv_1_9.Y sg13cmos5l_a21oi_1_2.A2 0.25765f
C401 sg13cmos5l_buf_1_66.X sg13cmos5l_inv_1_24.A 0.09762f
C402 sg13cmos5l_o21ai_1_18.B1 valid 0.06966f
C403 sg13cmos5l_nor3_1_6.Y sg13cmos5l_a21oi_1_6.A2 0.61679f
C404 a_14926_16935# VDD 0.15965f
C405 sg13cmos5l_inv_1_12.Y VDD 0.47728f
C406 sg13cmos5l_a21oi_1_27.A1 clk 0.10497f
C407 sg13cmos5l_nor3_1_7.Y sg13cmos5l_buf_1_14.A 0.07821f
C408 sg13cmos5l_inv_1_31.A sg13cmos5l_dfrbpq_1_33.Q 0.05078f
C409 sg13cmos5l_a21oi_1_4.A1 sg13cmos5l_nand2_1_15.Y 0.28364f
C410 sg13cmos5l_inv_1_15.A sg13cmos5l_nor3_1_6.Y 0.0155f
C411 sg13cmos5l_inv_1_3.Y a_17126_7362# 0.03607f
C412 a_13294_16935# VDD 0.16541f
C413 sg13cmos5l_nor2_1_2.B sg13cmos5l_nand3_1_3.Y 0.22852f
C414 sg13cmos5l_nand2_1_3.Y sg13cmos5l_a21oi_1_8.A2 0.08159f
C415 a_15976_12972# VDD 0.21191f
C416 sg13cmos5l_dfrbpq_1_5.CLK a_21099_14495# 0.02789f
C417 sg13cmos5l_a21oi_1_3.A2 a_17030_8874# 0.04299f
C418 sg13cmos5l_dlygate4sd3_1_13.X a_17510_10702# 0.01401f
C419 sg13cmos5l_a21oi_1_6.A2 sg13cmos5l_inv_1_9.Y 0.01551f
C420 a_10880_16878# VDD 0.07849f
C421 a_17109_9344# VDD 0.09551f
C422 sg13cmos5l_o21ai_1_22.Y sg13cmos5l_o21ai_1_14.A1 0.04012f
C423 sg13cmos5l_nand4_1_0.C sg13cmos5l_dfrbpq_1_15.Q 0.06113f
C424 sg13cmos5l_buf_1_47.X sg13cmos5l_nand2_1_12.Y 0.0459f
C425 a_14929_16357# bn2 0.01563f
C426 sg13cmos5l_nand4_1_8.B sg13cmos5l_a21oi_1_6.A2 0.04096f
C427 sg13cmos5l_inv_1_5.A a_17098_6130# 0.70751f
C428 a_6401_16262# VDD 0.20649f
C429 sg13cmos5l_inv_1_24.A VDD 0.86835f
C430 sg13cmos5l_inv_1_15.A sg13cmos5l_nand4_1_8.B 0.05474f
C431 sg13cmos5l_nand4_1_15.B sg13cmos5l_a21oi_1_4.A1 0.04557f
C432 a_13096_15996# sg13cmos5l_a21oi_1_4.A2 0.16062f
C433 sg13cmos5l_inv_1_8.A sg13cmos5l_dfrbpq_1_2.D 0.14587f
C434 sg13cmos5l_nand3_1_2.A sg13cmos5l_nand2_1_19.Y 0.0257f
C435 sg13cmos5l_dfrbpq_1_13.CLK a_14561_11726# 0.02068f
C436 sg13cmos5l_buf_1_65.A sg13cmos5l_nor4_1_4.C 0.32961f
C437 sg13cmos5l_nand2b_1_0.B a_15405_11808# 0.04058f
C438 sg13cmos5l_o21ai_1_1.B1 sg13cmos5l_inv_1_18.A 0.19014f
C439 sg13cmos5l_a21oi_1_19.Y VDD 0.35756f
C440 sg13cmos5l_o21ai_1_28.A1 sg13cmos5l_nand2_1_15.B 0.14821f
C441 a_4727_16043# VDD 0.52414f
C442 a_13228_13722# VDD 0.14656f
C443 sg13cmos5l_o21ai_1_21.Y sg13cmos5l_dfrbpq_1_19.D 0.09216f
C444 sg13cmos5l_nor2b_1_0.B_N VDD 1.13325f
C445 a_11278_13239# a_11393_13238# 0.3854f
C446 a_11274_20068# sg13cmos5l_dlygate4sd3_1_54.A 0.10748f
C447 a_5259_14495# a_5999_14845# 0.17382f
C448 sg13cmos5l_nand4_1_12.Y sg13cmos5l_o21ai_1_23.B1 0.04426f
C449 sg13cmos5l_a22oi_1_2.Y sg13cmos5l_dfrbpq_1_2.D 0.02269f
C450 sg13cmos5l_buf_1_45.X a_14761_15238# 0.05232f
C451 sg13cmos5l_a21oi_1_4.B1 sg13cmos5l_dlygate4sd3_1_14.A 0.17654f
C452 a_3532_16434# VDD 0.13766f
C453 a_10954_18481# bn3 0.03044f
C454 a_9867_5423# a_10607_5773# 0.17382f
C455 sg13cmos5l_nand2_1_0.A sg13cmos5l_nor4_1_0.Y 0.02875f
C456 sg13cmos5l_dfrbpq_1_13.CLK sg13cmos5l_dfrbpq_1_13.Q 0.49709f
C457 a_12545_9376# a_12826_9154# 0.18796f
C458 sg13cmos5l_inv_1_20.Y sg13cmos5l_nor2_1_3.Y 0.01057f
C459 sg13cmos5l_a21oi_1_24.A1 bn2 0.02983f
C460 valid bn1 0.17248f
C461 bn4 bn0 0.02124f
C462 code1 bn2 0.03264f
C463 bn3 busy 0.02479f
C464 sg13cmos5l_buf_1_63.A a_12232_14484# 0.20051f
C465 sg13cmos5l_buf_1_42.A sg13cmos5l_buf_1_43.X 1.50258f
C466 sg13cmos5l_nand4_1_8.B sg13cmos5l_a21oi_1_17.Y 0.15029f
C467 a_17039_18335# VDD 0.17495f
C468 sg13cmos5l_dfrbpq_1_39.Q sg13cmos5l_dlygate4sd3_1_98.A 0.06233f
C469 sg13cmos5l_nand4_1_7.B bn3 0.01679f
C470 sg13cmos5l_o21ai_1_23.B1 a_18286_16935# 0.03393f
C471 a_9176_13726# VDD 0.26131f
C472 a_20997_6935# a_21099_6935# 0.3643f
C473 sg13cmos5l_buf_1_24.A sg13cmos5l_o21ai_1_5.A1 0.08646f
C474 sg13cmos5l_dfrbpq_1_13.CLK sg13cmos5l_o21ai_1_0.A1 0.79015f
C475 sg13cmos5l_nand3b_1_0.C sg13cmos5l_buf_1_10.A 0.03362f
C476 sg13cmos5l_dfrbpq_1_28.RESET_B sg13cmos5l_nand4_1_15.B 0.05852f
C477 sg13cmos5l_nand4_1_5.D sg13cmos5l_nor3_1_6.Y 0.01894f
C478 sg13cmos5l_buf_1_26.A sg13cmos5l_a21oi_1_26.A1 0.1567f
C479 sg13cmos5l_inv_1_1.Y bp3 0.02895f
C480 sg13cmos5l_o21ai_1_0.A2 a_12430_9375# 0.11942f
C481 sg13cmos5l_nand4_1_15.B sg13cmos5l_mux2_1_1.A1 0.47814f
C482 sg13cmos5l_nand3_1_5.Y a_5222_17508# 0.01326f
C483 sg13cmos5l_a21oi_1_13.Y a_20580_14488# 0.02372f
C484 sg13cmos5l_nor3_1_6.Y sg13cmos5l_a21oi_1_1.A2 0.28613f
C485 sg13cmos5l_nor4_1_2.Y busy 0.02744f
C486 sg13cmos5l_o21ai_1_5.A1 a_12136_16082# 0.02229f
C487 sg13cmos5l_buf_1_25.A sg13cmos5l_buf_1_26.A 0.02344f
C488 a_22096_10190# a_22506_9948# 0.07015f
C489 sg13cmos5l_nor4_1_2.Y sg13cmos5l_nand4_1_7.B 0.1517f
C490 sg13cmos5l_a21oi_1_18.B1 sg13cmos5l_inv_1_24.Y 0.02123f
C491 sg13cmos5l_a21oi_1_4.A2 sg13cmos5l_nor3_1_0.Y 1.03865f
C492 sg13cmos5l_buf_1_7.X a_17386_6892# 0.18545f
C493 sg13cmos5l_nand4_1_8.B sg13cmos5l_nand4_1_5.D 0.02311f
C494 sg13cmos5l_nand3_1_0.B sg13cmos5l_nand2_1_13.Y 0.09037f
C495 VDD bn0 0.43559f
C496 sg13cmos5l_a21oi_1_26.Y sg13cmos5l_buf_1_26.A 0.01076f
C497 sg13cmos5l_nand3_1_2.Y sg13cmos5l_nand2_1_19.Y 0.05132f
C498 sg13cmos5l_buf_1_1.A a_18575_8797# 0.01928f
C499 sg13cmos5l_nor4_1_2.Y sg13cmos5l_nand4_1_3.B 0.10261f
C500 sg13cmos5l_buf_8_2.A sg13cmos5l_a21oi_1_2.B1 0.35912f
C501 sg13cmos5l_nand2b_1_4.B sg13cmos5l_nand2_1_6.A 0.03246f
C502 sg13cmos5l_buf_8_2.A sg13cmos5l_nand4_1_3.D 0.01997f
C503 sg13cmos5l_inv_1_3.Y a_17700_7349# 0.01214f
C504 sg13cmos5l_and4_1_1.A a_8337_13362# 0.13212f
C505 a_18689_14750# VDD 0.20599f
C506 sg13cmos5l_o21ai_1_5.A1 sg13cmos5l_nor2_1_15.Y 0.14515f
C507 a_15503_19847# VDD 0.16962f
C508 sg13cmos5l_dfrbpq_1_5.CLK bn7 0.80735f
C509 sg13cmos5l_a21oi_1_3.A2 a_17604_8861# 0.01641f
C510 sg13cmos5l_inv_1_29.Y VDD 0.12252f
C511 sg13cmos5l_buf_1_13.X a_18660_11016# 0.29041f
C512 a_15405_11808# a_15872_11546# 0.01438f
C513 sg13cmos5l_a21oi_1_18.B1 bn7 0.03726f
C514 sg13cmos5l_buf_1_5.A a_18374_7674# 0.0163f
C515 sg13cmos5l_dlygate4sd3_1_29.X a_17098_6130# 0.09332f
C516 sg13cmos5l_nand2_1_1.A sg13cmos5l_a21oi_1_5.A2 0.02354f
C517 sg13cmos5l_nand4_1_3.B a_13015_13686# 0.01043f
C518 sg13cmos5l_buf_8_2.A sg13cmos5l_o21ai_1_22.B1 0.03197f
C519 sg13cmos5l_o21ai_1_9.A2 sg13cmos5l_a21oi_1_4.A1 0.24038f
C520 sg13cmos5l_nor3_1_2.B a_6383_9263# 0.01462f
C521 a_8122_8400# a_8520_8436# 0.02111f
C522 sg13cmos5l_buf_1_13.A sg13cmos5l_inv_1_6.Y 0.44054f
C523 a_15392_13854# VDD 0.07632f
C524 a_9274_6888# clk 0.0139f
C525 sg13cmos5l_buf_1_10.A sg13cmos5l_dlygate4sd3_1_16.A 0.62876f
C526 sg13cmos5l_nand3b_1_3.C sg13cmos5l_dfrbpq_1_20.D 0.03277f
C527 sg13cmos5l_dfrbpq_1_15.CLK a_6730_11428# 0.04378f
C528 sg13cmos5l_dfrbpq_1_15.CLK a_5998_13911# 0.01352f
C529 sg13cmos5l_buf_1_16.A sg13cmos5l_buf_1_53.A 0.01056f
C530 sg13cmos5l_o21ai_1_10.A2 sg13cmos5l_nand2_1_9.Y 0.40292f
C531 sg13cmos5l_inv_1_17.A sg13cmos5l_dfrbpq_1_28.Q 0.03843f
C532 sg13cmos5l_nand2b_1_0.B a_14534_10702# 0.03047f
C533 a_9322_5380# clk 0.03793f
C534 sg13cmos5l_o21ai_1_7.A2 a_8043_19031# 0.03396f
C535 a_19718_12214# a_19830_12278# 0.3854f
C536 sg13cmos5l_dlygate4sd3_1_65.A a_9464_17549# 0.28903f
C537 sg13cmos5l_nand3_1_3.Y a_10811_4948# 0.05006f
C538 sg13cmos5l_nand2b_1_1.A_N sg13cmos5l_buf_1_10.A 0.01974f
C539 sg13cmos5l_dfrbpq_1_39.Q a_21084_18222# 0.01349f
C540 sg13cmos5l_o21ai_1_17.B1 a_10774_17886# 0.04289f
C541 sg13cmos5l_a21oi_1_27.B1 sg13cmos5l_a21oi_1_4.A1 0.30236f
C542 sg13cmos5l_a21oi_1_18.B1 sg13cmos5l_dfrbpq_1_38.Q 0.01305f
C543 a_22126_6351# bp1 0.03814f
C544 sg13cmos5l_o21ai_1_19.Y a_7524_19024# 0.04358f
C545 sg13cmos5l_buf_1_24.A sg13cmos5l_o21ai_1_5.A2 0.05431f
C546 sg13cmos5l_dlygate4sd3_1_42.X a_4838_9186# 0.17853f
C547 a_5098_9409# a_5541_9165# 0.02241f
C548 a_21099_6935# a_22096_7166# 0.03546f
C549 sg13cmos5l_a21oi_1_0.A2 sg13cmos5l_buf_1_7.X 0.36519f
C550 sg13cmos5l_buf_1_1.A bn7 0.19998f
C551 sg13cmos5l_inv_1_6.Y bp7 0.04619f
C552 a_9147_13028# sg13cmos5l_a21oi_1_27.A2 0.1892f
C553 sg13cmos5l_dlygate4sd3_1_64.X sg13cmos5l_o21ai_1_21.B1 0.02294f
C554 a_3500_19734# sg13cmos5l_dlygate4sd3_1_50.X 0.20639f
C555 sg13cmos5l_inv_1_36.A start 0.03351f
C556 sg13cmos5l_inv_1_1.A sg13cmos5l_nand3_1_0.C 0.01814f
C557 sg13cmos5l_inv_1_15.A sg13cmos5l_inv_1_25.Y 0.18834f
C558 sg13cmos5l_nor2b_1_2.Y sg13cmos5l_nand2b_1_3.B 0.02497f
C559 sg13cmos5l_nor2b_1_1.A VDD 0.70462f
C560 sg13cmos5l_buf_1_7.X sg13cmos5l_inv_1_14.Y 0.07834f
C561 sg13cmos5l_a21oi_1_2.Y sg13cmos5l_a21oi_1_0.Y 0.05374f
C562 sg13cmos5l_a21oi_1_27.B1 sg13cmos5l_o21ai_1_18.B1 0.01828f
C563 sg13cmos5l_nor2_1_16.Y bn1 0.02678f
C564 sg13cmos5l_nand4_1_15.B sg13cmos5l_nor3_1_4.A 0.34756f
C565 a_6766_7191# VDD 0.1595f
C566 sg13cmos5l_nor3_1_6.Y sg13cmos5l_dlygate4sd3_1_76.A 0.02279f
C567 sg13cmos5l_buf_1_7.X a_18928_7166# 0.15627f
C568 sg13cmos5l_dfrbpq_1_41.CLK sg13cmos5l_buf_1_47.X 0.04541f
C569 sg13cmos5l_o21ai_1_10.Y sg13cmos5l_o21ai_1_11.B1 0.05084f
C570 sg13cmos5l_a21oi_1_4.A1 a_16085_12508# 0.02805f
C571 a_19136_13854# VDD 0.08053f
C572 sg13cmos5l_buf_1_63.A a_17355_19892# 0.0156f
C573 sg13cmos5l_nand4_1_18.B sg13cmos5l_mux2_1_0.S 0.11121f
C574 sg13cmos5l_a21oi_1_27.B1 sg13cmos5l_mux2_1_1.A1 0.03555f
C575 sg13cmos5l_dfrbpq_1_34.Q VDD 0.64731f
C576 sg13cmos5l_buf_1_13.X a_19919_10775# 0.14421f
C577 a_20580_4968# VDD 0.07266f
C578 sg13cmos5l_a21oi_1_10.Y sg13cmos5l_dfrbpq_1_13.D 0.07879f
C579 a_14218_19993# a_13958_19770# 0.45119f
C580 sg13cmos5l_inv_1_13.Y a_18660_11016# 0.04654f
C581 sg13cmos5l_buf_1_45.X sg13cmos5l_o21ai_1_23.B1 1.15843f
C582 a_8637_5682# VDD 0.23082f
C583 sg13cmos5l_buf_1_13.A sg13cmos5l_inv_1_11.Y 0.02002f
C584 sg13cmos5l_buf_1_6.A VDD 0.31266f
C585 a_8602_9154# a_8955_9228# 0.04844f
C586 sg13cmos5l_dlygate4sd3_1_18.A VDD 0.25572f
C587 sg13cmos5l_a21oi_1_2.B1 sg13cmos5l_a21oi_1_15.Y 0.21186f
C588 a_13738_15964# a_14181_16007# 0.02241f
C589 sg13cmos5l_or4_1_0.C a_8321_9376# 0.02468f
C590 a_18634_10921# a_19077_10677# 0.02241f
C591 sg13cmos5l_o21ai_1_0.A2 a_12631_5376# 0.01398f
C592 sg13cmos5l_buf_8_2.A a_12987_12214# 0.66035f
C593 a_17038_14751# a_17153_14750# 0.3854f
C594 bn7 bn9 0.03311f
C595 sg13cmos5l_a21oi_1_0.Y sg13cmos5l_inv_1_6.Y 0.02332f
C596 a_17510_10702# a_17622_10766# 0.3854f
C597 sg13cmos5l_dlygate4sd3_1_58.X a_9070_18447# 0.11427f
C598 sg13cmos5l_buf_1_13.A a_15783_7892# 0.27971f
C599 sg13cmos5l_buf_1_63.A sg13cmos5l_a21oi_1_4.A1 0.01152f
C600 sg13cmos5l_inv_1_8.A sg13cmos5l_buf_1_0.A 0.03054f
C601 sg13cmos5l_o21ai_1_5.A2 a_13596_13686# 0.01395f
C602 sg13cmos5l_and2_1_6.A sg13cmos5l_nand2_1_19.A 0.05978f
C603 a_7199_6432# a_6958_6162# 0.01058f
C604 a_7047_6380# a_7850_6320# 0.07823f
C605 sg13cmos5l_inv_1_0.A a_20398_4167# 0.10912f
C606 sg13cmos5l_buf_1_45.X a_13738_17476# 0.20425f
C607 sg13cmos5l_dfrbpq_1_15.CLK a_8272_11702# 0.03022f
C608 sg13cmos5l_dlygate4sd3_1_28.A bn9 0.05208f
C609 sg13cmos5l_buf_1_45.X a_13727_13992# 0.04141f
C610 sg13cmos5l_nand3_1_2.A sg13cmos5l_nand2b_1_0.B 0.85752f
C611 a_13676_19734# VDD 0.21797f
C612 sg13cmos5l_buf_1_5.A sg13cmos5l_inv_1_6.Y 0.01909f
C613 a_12040_13058# sg13cmos5l_and2_1_6.A 0.01137f
C614 sg13cmos5l_o21ai_1_28.B1 bn2 0.01171f
C615 sg13cmos5l_o21ai_1_3.Y sg13cmos5l_buf_1_13.A 0.02329f
C616 sg13cmos5l_a22oi_1_2.Y sg13cmos5l_buf_1_0.A 0.03646f
C617 a_6487_6126# a_6700_6162# 0.23043f
C618 sg13cmos5l_buf_1_16.A sg13cmos5l_a21oi_1_2.B1 0.39391f
C619 sg13cmos5l_a21oi_1_0.Y a_18662_5850# 0.01605f
C620 a_12512_5699# a_12844_5850# 0.07015f
C621 a_20554_14452# bn8 0.01152f
C622 sg13cmos5l_dfrbpq_1_28.Q bp0 1.55251f
C623 a_3879_16083# VDD 0.20625f
C624 sg13cmos5l_nand3b_1_3.C sg13cmos5l_a21oi_1_12.Y 0.01704f
C625 a_20997_14495# a_20997_13701# 0.01534f
C626 sg13cmos5l_and2_1_3.X sg13cmos5l_a21oi_1_6.A2 0.11328f
C627 sg13cmos5l_dfrbpq_1_28.Q a_20554_12433# 0.01202f
C628 sg13cmos5l_buf_1_59.A a_15400_15272# 0.18668f
C629 sg13cmos5l_o21ai_1_18.B1 sg13cmos5l_buf_1_63.A 0.34108f
C630 sg13cmos5l_dfrbpq_1_5.CLK a_21911_18649# 0.02753f
C631 sg13cmos5l_inv_1_15.A sg13cmos5l_and2_1_3.X 0.02103f
C632 sg13cmos5l_dfrbpq_1_15.CLK a_6401_8702# 0.01744f
C633 sg13cmos5l_buf_1_6.A bp6 0.25383f
C634 sg13cmos5l_buf_1_5.A a_18662_5850# 0.04882f
C635 sg13cmos5l_dfrbpq_1_41.CLK sg13cmos5l_o21ai_1_25.B1 0.06134f
C636 a_19169_18448# a_19450_18226# 0.18796f
C637 sg13cmos5l_buf_1_15.A sg13cmos5l_nand2_1_15.Y 0.03847f
C638 a_12082_7302# a_12430_6980# 0.01427f
C639 sg13cmos5l_nand2_1_0.B sg13cmos5l_dlygate4sd3_1_8.X 0.13076f
C640 sg13cmos5l_nand4_1_18.C bp0 0.08723f
C641 a_6021_12983# VDD 0.24903f
C642 sg13cmos5l_dlygate4sd3_1_76.X sg13cmos5l_inv_1_12.A 0.01128f
C643 sg13cmos5l_o21ai_1_26.B1 sg13cmos5l_inv_1_25.Y 0.03017f
C644 sg13cmos5l_nor2_1_7.Y sg13cmos5l_nand2_1_11.B 0.21581f
C645 sg13cmos5l_nand2_1_19.A clk 0.02471f
C646 a_11674_6130# a_12344_6166# 0.01535f
C647 a_7937_19960# VDD 0.20143f
C648 sg13cmos5l_buf_1_15.A sg13cmos5l_nand4_1_15.B 0.23085f
C649 sg13cmos5l_and2_1_3.X sg13cmos5l_a21oi_1_17.Y 0.05771f
C650 a_7520_7010# VDD 0.08203f
C651 sg13cmos5l_dfrbpq_1_41.CLK sg13cmos5l_inv_1_35.Y 0.10371f
C652 sg13cmos5l_o21ai_1_23.B1 sg13cmos5l_buf_1_42.A 0.06932f
C653 sg13cmos5l_inv_1_7.A VDD 0.45472f
C654 a_22506_4948# VDD 0.27437f
C655 sg13cmos5l_nand3_1_8.Y sg13cmos5l_a21oi_1_16.A2 0.01299f
C656 sg13cmos5l_inv_1_1.Y bn5 0.17018f
C657 sg13cmos5l_a21oi_1_2.A2 sg13cmos5l_inv_1_5.A 0.50435f
C658 a_18660_11016# a_18948_10711# 0.24435f
C659 sg13cmos5l_buf_1_63.A bn1 0.04187f
C660 a_9348_5416# VDD 0.07289f
C661 a_1409_9376# VDD 0.21696f
C662 sg13cmos5l_inv_1_31.A a_19169_18448# 0.01468f
C663 sg13cmos5l_dfrbpq_1_18.Q a_10833_14874# 0.01156f
C664 sg13cmos5l_a21oi_1_2.A2 a_17030_8874# 0.05004f
C665 a_17984_13854# VDD 0.07566f
C666 sg13cmos5l_o21ai_1_25.Y a_14244_20088# 0.02972f
C667 sg13cmos5l_buf_1_45.X sg13cmos5l_inv_1_32.Y 0.79309f
C668 a_13764_16000# a_15023_16357# 0.01412f
C669 sg13cmos5l_nand3_1_8.Y sg13cmos5l_inv_1_16.Y 0.01394f
C670 sg13cmos5l_nand4_1_1.C sg13cmos5l_a21oi_1_16.A2 0.06616f
C671 sg13cmos5l_buf_1_13.A sg13cmos5l_buf_1_4.A 0.05529f
C672 a_19035_16750# a_20384_16921# 0.0185f
C673 a_12616_14484# bn1 0.15442f
C674 sg13cmos5l_o21ai_1_10.A2 sg13cmos5l_nor4_1_4.C 0.12267f
C675 sg13cmos5l_nand4_1_5.D sg13cmos5l_and2_1_3.X 0.12624f
C676 sg13cmos5l_buf_1_13.A sg13cmos5l_inv_1_3.Y 0.11412f
C677 sg13cmos5l_buf_1_66.X a_11674_12936# 0.01625f
C678 sg13cmos5l_nor4_1_1.D a_10326_14484# 0.01135f
C679 sg13cmos5l_buf_1_5.A sg13cmos5l_inv_1_11.Y 0.02055f
C680 sg13cmos5l_nand2_1_1.A sg13cmos5l_nand4_1_18.A 0.24478f
C681 sg13cmos5l_nand3_1_0.C a_16188_9150# 0.02412f
C682 sg13cmos5l_inv_1_15.A sg13cmos5l_inv_1_5.A 0.0831f
C683 sg13cmos5l_inv_1_16.Y sg13cmos5l_nand4_1_1.C 0.06618f
C684 sg13cmos5l_buf_1_45.X a_15280_17750# 0.09648f
C685 sg13cmos5l_nor2_1_2.B sg13cmos5l_nand2_1_3.Y 0.33626f
C686 sg13cmos5l_dfrbpq_1_15.Q sg13cmos5l_dlygate4sd3_1_43.A 0.26544f
C687 sg13cmos5l_dfrbpq_1_19.CLK a_10066_19398# 0.02023f
C688 sg13cmos5l_buf_1_42.A sg13cmos5l_a21oi_1_19.A2 0.24544f
C689 sg13cmos5l_nand3b_1_3.C a_6670_18447# 0.04544f
C690 sg13cmos5l_dfrbpq_1_19.CLK a_4114_17886# 0.01652f
C691 sg13cmos5l_buf_1_2.A a_20464_5654# 0.04029f
C692 sg13cmos5l_nor4_1_2.Y a_18954_15532# 0.02124f
C693 sg13cmos5l_o21ai_1_25.Y a_14181_17519# 0.0105f
C694 sg13cmos5l_nand4_1_18.B sg13cmos5l_a21oi_1_12.A2 0.05639f
C695 sg13cmos5l_inv_1_7.A bp6 0.08594f
C696 sg13cmos5l_inv_1_8.A sg13cmos5l_a22oi_1_2.Y 0.03294f
C697 a_12631_5376# a_13102_5850# 0.16704f
C698 a_7047_6380# a_7895_6553# 0.07916f
C699 sg13cmos5l_dfrbpq_1_7.D bn9 0.03549f
C700 a_21839_14845# bn8 0.01092f
C701 sg13cmos5l_inv_1_17.A bp0 0.02247f
C702 sg13cmos5l_dfrbpq_1_13.CLK a_13596_13686# 0.05951f
C703 sg13cmos5l_dfrbpq_1_15.Q sg13cmos5l_dfrbpq_1_17.Q 1.31306f
C704 sg13cmos5l_dfrbpq_1_28.Q a_21839_12287# 0.01424f
C705 a_4646_19458# a_5349_19031# 0.02431f
C706 a_11674_12936# VDD 0.26895f
C707 a_20794_12936# a_21160_12972# 0.03608f
C708 sg13cmos5l_buf_8_2.A sg13cmos5l_dfrbpq_1_14.D 0.05171f
C709 a_9848_18262# a_10118_18262# 0.18796f
C710 sg13cmos5l_nand3b_1_3.C sg13cmos5l_inv_1_15.A 0.01095f
C711 sg13cmos5l_buf_1_5.A a_19236_5837# 0.01246f
C712 sg13cmos5l_or4_1_1.X a_10162_16742# 0.06822f
C713 sg13cmos5l_nor3_1_0.Y sg13cmos5l_and2_1_5.X 0.02971f
C714 sg13cmos5l_dlygate4sd3_1_7.X a_14438_6162# 0.17495f
C715 a_12224_9318# VDD 0.07946f
C716 sg13cmos5l_o21ai_1_25.Y sg13cmos5l_buf_1_26.A 0.02046f
C717 sg13cmos5l_nor2b_1_2.Y sg13cmos5l_dfrbpq_1_2.D 0.33945f
C718 sg13cmos5l_o21ai_1_1.Y a_14902_8814# 0.05721f
C719 sg13cmos5l_buf_1_4.A bp7 0.07028f
C720 a_20294_11898# a_20868_11885# 0.18486f
C721 a_17355_19892# sg13cmos5l_inv_1_31.A 0.01664f
C722 a_20580_11464# a_20997_11471# 0.28418f
C723 a_5541_9165# a_5643_9308# 0.36168f
C724 sg13cmos5l_nor4_1_2.Y a_17244_16754# 0.014f
C725 sg13cmos5l_nand2b_1_0.B sg13cmos5l_nand3_1_1.Y 0.01566f
C726 sg13cmos5l_dfrbpq_1_13.CLK sg13cmos5l_nand2b_1_3.Y 0.37032f
C727 sg13cmos5l_inv_1_36.Y sg13cmos5l_nand3b_1_0.C 0.37563f
C728 sg13cmos5l_a21oi_1_4.A1 sg13cmos5l_nand2_1_15.B 0.16773f
C729 sg13cmos5l_dlygate4sd3_1_65.A sg13cmos5l_nand3b_1_1.C 0.01553f
C730 sg13cmos5l_dlygate4sd3_1_55.X a_12134_19458# 0.17921f
C731 sg13cmos5l_inv_1_20.Y a_11372_10662# 0.03589f
C732 sg13cmos5l_buf_1_10.A VDD 0.58176f
C733 sg13cmos5l_o21ai_1_15.B1 sg13cmos5l_o21ai_1_22.Y 0.74661f
C734 a_7530_12972# VDD 0.2769f
C735 sg13cmos5l_inv_1_18.A a_11840_9389# 0.02036f
C736 a_10510_19287# a_10625_19286# 0.3854f
C737 sg13cmos5l_nand3b_1_3.C sg13cmos5l_o21ai_1_20.Y 0.0377f
C738 a_9765_19749# sg13cmos5l_dfrbpq_1_19.CLK 0.20353f
C739 sg13cmos5l_buf_1_47.X bn3 0.01455f
C740 sg13cmos5l_buf_1_0.A sg13cmos5l_inv_1_0.A 0.09758f
C741 sg13cmos5l_a22oi_1_0.B2 a_12426_9948# 0.07743f
C742 a_21254_10702# a_21366_10766# 0.3854f
C743 sg13cmos5l_nand2_1_15.B a_13114_14854# 0.0158f
C744 sg13cmos5l_dfrbpq_1_18.Q a_11393_13238# 0.02761f
C745 sg13cmos5l_nand4_1_1.A sg13cmos5l_nand4_1_18.A 0.034f
C746 a_14763_19892# a_15503_19847# 0.17382f
C747 a_20984_10702# a_21254_10702# 0.18796f
C748 sg13cmos5l_buf_8_2.A a_18106_17472# 0.01401f
C749 sg13cmos5l_buf_1_9.A sg13cmos5l_buf_1_8.A 0.01815f
C750 a_9350_12210# a_10053_12189# 0.02453f
C751 sg13cmos5l_nand4_1_7.B a_17038_14751# 0.0377f
C752 a_6666_14484# VDD 0.27655f
C753 sg13cmos5l_nor4_1_0.C sg13cmos5l_nor4_1_0.Y 0.09524f
C754 a_11274_5412# VDD 0.27758f
C755 a_15280_16238# a_15690_15996# 0.07015f
C756 sg13cmos5l_a21oi_1_4.A1 sg13cmos5l_nor3_1_6.Y 0.4621f
C757 sg13cmos5l_o21ai_1_6.Y a_9394_8814# 0.06342f
C758 sg13cmos5l_dfrbpq_1_24.Q a_7912_12972# 0.08904f
C759 sg13cmos5l_buf_1_47.X sg13cmos5l_nor4_1_2.Y 0.04717f
C760 sg13cmos5l_a21oi_1_27.B1 sg13cmos5l_buf_1_15.A 1.10239f
C761 sg13cmos5l_o21ai_1_11.A2 a_7378_16374# 0.06019f
C762 sg13cmos5l_dfrbpq_1_13.RESET_B sg13cmos5l_nand2b_1_4.B 0.01197f
C763 sg13cmos5l_buf_1_10.A bp6 0.03f
C764 sg13cmos5l_inv_1_15.A sg13cmos5l_dlygate4sd3_1_29.X 0.04087f
C765 sg13cmos5l_dfrbpq_1_13.RESET_B a_6730_11428# 0.19664f
C766 sg13cmos5l_a21oi_1_9.B1 a_10365_7194# 0.01495f
C767 sg13cmos5l_a21oi_1_3.A2 a_16954_11424# 0.01512f
C768 sg13cmos5l_buf_1_66.X a_12224_13058# 0.01143f
C769 sg13cmos5l_a21oi_1_4.A1 sg13cmos5l_inv_1_9.Y 0.13144f
C770 sg13cmos5l_inv_1_2.A sg13cmos5l_buf_1_13.A 0.09103f
C771 sg13cmos5l_nand3b_1_3.C sg13cmos5l_o21ai_1_28.A1 0.35334f
C772 sg13cmos5l_inv_1_24.Y code0 0.0131f
C773 a_22241_4166# bp1 0.02974f
C774 sg13cmos5l_a21oi_1_9.Y a_9761_6352# 0.01629f
C775 sg13cmos5l_dlygate4sd3_1_64.X a_7858_16742# 0.02425f
C776 sg13cmos5l_inv_1_31.A sg13cmos5l_dfrbpq_1_28.RESET_B 0.56845f
C777 sg13cmos5l_buf_1_5.A sg13cmos5l_buf_1_4.A 0.02024f
C778 sg13cmos5l_mux2_1_0.A1 a_7432_13854# 0.02037f
C779 sg13cmos5l_nand3_1_0.B VDD 0.81118f
C780 sg13cmos5l_dfrbpq_1_3.D a_17015_9577# 0.19066f
C781 sg13cmos5l_nand4_1_8.B sg13cmos5l_a21oi_1_4.A1 0.0307f
C782 sg13cmos5l_a21oi_1_4.A1 a_15358_14850# 0.11292f
C783 sg13cmos5l_buf_1_26.A valid 0.03985f
C784 a_7416_12404# a_7742_12508# 0.02749f
C785 a_13212_5773# a_13994_5692# 0.24435f
C786 sg13cmos5l_dfrbpq_1_18.Q sg13cmos5l_and4_1_1.A 0.18487f
C787 sg13cmos5l_buf_1_13.A a_15404_6888# 0.16185f
C788 sg13cmos5l_buf_1_54.A sg13cmos5l_nand4_1_15.B 0.11588f
C789 a_5349_19031# a_5451_19031# 0.3643f
C790 sg13cmos5l_inv_1_17.A a_21839_12287# 0.04343f
C791 sg13cmos5l_o21ai_1_26.B1 a_12902_17508# 0.01592f
C792 a_17051_15996# VDD 0.18238f
C793 a_21466_7642# bp2 0.04994f
C794 a_12224_13058# VDD 0.06897f
C795 sg13cmos5l_nand2_1_15.B bn1 0.04962f
C796 bn6 bn8 0.11738f
C797 sg13cmos5l_inv_1_36.Y sg13cmos5l_nand2b_1_1.A_N 0.21846f
C798 sg13cmos5l_nand2_1_13.A sg13cmos5l_nand3_1_2.A 0.03311f
C799 a_11656_15272# bn4 0.15484f
C800 sg13cmos5l_dfrbpq_1_5.CLK sg13cmos5l_buf_1_13.X 0.03843f
C801 sg13cmos5l_nor3_1_6.Y sg13cmos5l_mux2_1_1.A1 0.39404f
C802 sg13cmos5l_o21ai_1_15.Y sg13cmos5l_o21ai_1_22.Y 0.17993f
C803 a_5541_9165# sg13cmos5l_nor3_1_2.Y 0.01951f
C804 sg13cmos5l_nor2b_1_0.B_N sg13cmos5l_o21ai_1_3.Y 0.24414f
C805 a_11772_14484# VDD 0.01153f
C806 sg13cmos5l_o21ai_1_4.A1 sg13cmos5l_dlygate4sd3_1_7.X 0.0166f
C807 sg13cmos5l_a21oi_1_27.A2 VDD 0.3644f
C808 sg13cmos5l_nand4_1_16.D sg13cmos5l_a21oi_1_20.Y 0.20549f
C809 sg13cmos5l_inv_1_2.A bp7 0.04628f
C810 sg13cmos5l_a22oi_1_2.Y sg13cmos5l_nand2_1_5.Y 0.02086f
C811 sg13cmos5l_o21ai_1_0.B1 sg13cmos5l_dfrbpq_1_47.D 0.01315f
C812 sg13cmos5l_inv_1_1.Y a_20503_15960# 0.01586f
C813 sg13cmos5l_dfrbpq_1_28.RESET_B sg13cmos5l_nand4_1_8.B 0.28445f
C814 a_13592_6166# a_13862_6166# 0.18796f
C815 sg13cmos5l_inv_1_2.A a_19048_3900# 0.01199f
C816 sg13cmos5l_o21ai_1_15.B1 sg13cmos5l_a21oi_1_24.A1 0.02343f
C817 sg13cmos5l_a21o_1_2.B1 sg13cmos5l_a21oi_1_12.A2 0.01007f
C818 sg13cmos5l_dfrbpq_1_13.CLK sg13cmos5l_or2_1_1.X 0.12574f
C819 sg13cmos5l_a22oi_1_0.B2 a_15214_10215# 0.05032f
C820 sg13cmos5l_dfrbpq_1_18.Q sg13cmos5l_and2_1_6.A 0.06659f
C821 sg13cmos5l_inv_1_18.Y sg13cmos5l_dlygate4sd3_1_8.X 0.03162f
C822 a_11656_15272# VDD 0.18581f
C823 a_9636_12528# a_10895_12287# 0.01412f
C824 sg13cmos5l_buf_1_42.A sg13cmos5l_inv_1_12.A 0.02047f
C825 sg13cmos5l_dfrbpq_1_24.Q a_11874_14484# 0.02396f
C826 a_13212_5773# VDD 0.08012f
C827 sg13cmos5l_a21oi_1_1.A2 a_19342_10215# 0.04309f
C828 a_20554_11428# VDD 0.09603f
C829 a_17253_19749# VDD 0.24317f
C830 a_5124_9504# VDD 0.07923f
C831 a_10389_16258# VDD 0.1785f
C832 sg13cmos5l_dfrbpq_1_11.Q sg13cmos5l_dlygate4sd3_1_22.A 0.01494f
C833 sg13cmos5l_inv_1_6.Y a_20580_4968# 0.01044f
C834 sg13cmos5l_nand3_1_0.Y a_17733_8447# 0.02981f
C835 sg13cmos5l_nand4_1_8.B bn1 0.01039f
C836 sg13cmos5l_nand2_1_9.Y a_9096_15996# 0.01646f
C837 sg13cmos5l_dfrbpq_1_13.RESET_B a_8272_11702# 0.09648f
C838 sg13cmos5l_nor3_1_2.B a_10500_9952# 0.02443f
C839 sg13cmos5l_inv_1_15.Y sg13cmos5l_dlygate4sd3_1_13.A 0.43381f
C840 sg13cmos5l_dlygate4sd3_1_54.A bn3 0.04111f
C841 sg13cmos5l_buf_8_2.A sg13cmos5l_nand3_1_0.C 0.06754f
C842 sg13cmos5l_buf_8_2.A a_14283_17519# 0.05346f
C843 sg13cmos5l_nand4_1_18.B sg13cmos5l_o21ai_1_19.Y 0.01255f
C844 sg13cmos5l_nand3_1_2.Y sg13cmos5l_nand2_1_13.A 0.78552f
C845 sg13cmos5l_nor2b_1_1.A a_9734_17508# 0.01086f
C846 sg13cmos5l_dfrbpq_1_30.Q sg13cmos5l_dlygate4sd3_1_74.A 0.13357f
C847 sg13cmos5l_inv_1_2.A sg13cmos5l_a21oi_1_0.Y 0.01515f
C848 sg13cmos5l_inv_1_16.A VDD 0.69118f
C849 a_17126_7362# a_17931_6935# 0.07916f
C850 sg13cmos5l_dfrbpq_1_24.RESET_B a_4714_14452# 0.20262f
C851 a_18970_14448# VDD 0.28519f
C852 sg13cmos5l_buf_1_5.A sg13cmos5l_inv_1_2.A 0.05213f
C853 sg13cmos5l_nor3_1_2.Y a_5943_8436# 0.02677f
C854 a_1409_15424# VDD 0.21705f
C855 sg13cmos5l_dlygate4sd3_1_13.X sg13cmos5l_buf_1_5.A 0.03705f
C856 sg13cmos5l_nor2_1_2.A sg13cmos5l_a21oi_1_8.A2 0.02986f
C857 sg13cmos5l_buf_8_2.A sg13cmos5l_inv_1_24.Y 0.02365f
C858 a_6448_19262# a_6858_19020# 0.07015f
C859 a_22005_16043# VDD 0.0953f
C860 sg13cmos5l_nand4_1_1.B sg13cmos5l_nand2_1_9.Y 0.32982f
C861 sg13cmos5l_o21ai_1_5.A1 sg13cmos5l_nand4_1_6.B 0.14258f
C862 a_10954_18481# a_11397_18237# 0.02241f
C863 a_10694_18258# a_10980_18576# 0.26205f
C864 sg13cmos5l_o21ai_1_7.A2 a_7066_18226# 0.01222f
C865 a_20997_12189# a_21099_12332# 0.36168f
C866 sg13cmos5l_nor2_1_7.Y sg13cmos5l_nor2_1_6.Y 0.22577f
C867 a_21839_11821# a_22506_11460# 0.09257f
C868 a_7507_9380# sg13cmos5l_nor3_1_2.Y 0.1624f
C869 sg13cmos5l_a21oi_1_25.Y bn3 0.02207f
C870 sg13cmos5l_nor2b_1_2.Y sg13cmos5l_buf_1_0.A 0.0264f
C871 a_9624_17064# VDD 0.01784f
C872 a_14920_14484# VDD 0.18135f
C873 a_12140_19734# VDD 0.21093f
C874 sg13cmos5l_a21oi_1_18.B1 sg13cmos5l_inv_1_13.Y 0.08165f
C875 sg13cmos5l_and2_1_6.A sg13cmos5l_nand2_1_19.Y 0.07855f
C876 a_21084_16357# a_20974_16434# 0.25046f
C877 a_20716_16434# a_21063_16083# 0.03412f
C878 a_12896_13897# a_13228_13722# 0.07015f
C879 sg13cmos5l_dlygate4sd3_1_76.X sg13cmos5l_dfrbpq_1_28.Q 0.04225f
C880 sg13cmos5l_nor4_1_1.D a_8513_15260# 0.01034f
C881 a_7432_15366# a_7616_15366# 0.05762f
C882 a_19912_11460# bn8 0.15495f
C883 sg13cmos5l_buf_1_13.X bn9 0.01008f
C884 sg13cmos5l_nor3_1_6.Y sg13cmos5l_nor3_1_4.A 0.01966f
C885 sg13cmos5l_a21o_1_2.A1 sg13cmos5l_and4_1_1.A 0.08956f
C886 sg13cmos5l_a21oi_1_24.A1 sg13cmos5l_o21ai_1_15.Y 0.26331f
C887 sg13cmos5l_buf_8_2.A bn7 0.01382f
C888 sg13cmos5l_a21oi_1_27.B1 sg13cmos5l_o21ai_1_20.A1 0.02298f
C889 a_12134_19458# a_12420_19024# 0.26205f
C890 a_5998_17775# a_5792_17594# 0.01604f
C891 sg13cmos5l_a21oi_1_4.A1 sg13cmos5l_dfrbpq_1_24.Q 0.49968f
C892 sg13cmos5l_nor2b_1_0.B_N sg13cmos5l_dlygate4sd3_1_14.A 0.02268f
C893 sg13cmos5l_nand2_1_0.B sg13cmos5l_nor2_1_0.Y 0.01319f
C894 sg13cmos5l_o21ai_1_3.A2 sg13cmos5l_o21ai_1_1.Y 0.14821f
C895 a_17002_15457# a_16742_15234# 0.45119f
C896 a_10155_12332# VDD 0.21297f
C897 sg13cmos5l_inv_1_1.A sg13cmos5l_buf_1_13.X 0.15912f
C898 sg13cmos5l_a21oi_1_7.A2 a_19718_12214# 0.01424f
C899 sg13cmos5l_buf_1_66.X a_7090_15230# 0.08218f
C900 sg13cmos5l_nand4_1_3.B sg13cmos5l_a21oi_1_0.A2 0.04342f
C901 a_5829_8436# VDD 0.01371f
C902 a_10053_12189# a_10801_12287# 0.01058f
C903 sg13cmos5l_dfrbpq_1_0.D bp2 0.02492f
C904 sg13cmos5l_buf_1_66.X sg13cmos5l_nor4_1_1.D 0.04251f
C905 a_21911_16043# sg13cmos5l_inv_1_25.Y 0.04266f
C906 sg13cmos5l_a21o_1_0.A1 sg13cmos5l_inv_1_22.Y 0.12123f
C907 sg13cmos5l_buf_1_30.A sg13cmos5l_dlygate4sd3_1_64.X 0.019f
C908 sg13cmos5l_a21oi_1_25.A2 sg13cmos5l_nand4_1_5.D 0.01825f
C909 sg13cmos5l_nand4_1_18.B sg13cmos5l_nand2_1_18.A 0.03283f
C910 sg13cmos5l_dlygate4sd3_1_64.X sg13cmos5l_buf_1_66.X 1.41027f
C911 sg13cmos5l_mux2_1_0.S a_9056_13058# 0.02824f
C912 sg13cmos5l_a21oi_1_8.A1 sg13cmos5l_nor2_1_2.Y 0.10595f
C913 sg13cmos5l_o21ai_1_9.A2 sg13cmos5l_o21ai_1_9.B1 1.7698f
C914 sg13cmos5l_o21ai_1_28.Y a_12886_15230# 0.03967f
C915 a_9450_19020# a_9824_19106# 0.01702f
C916 sg13cmos5l_inv_1_12.Y sg13cmos5l_inv_1_2.A 0.03983f
C917 sg13cmos5l_inv_1_15.A bn2 0.07404f
C918 sg13cmos5l_nand4_1_1.A a_17342_13730# 0.01766f
C919 sg13cmos5l_mux2_1_0.S sg13cmos5l_dfrbpq_1_45.Q 0.66665f
C920 sg13cmos5l_dlygate4sd3_1_18.A a_17578_11428# 0.03192f
C921 a_22096_11702# VDD 0.13499f
C922 a_7050_9484# VDD 0.27693f
C923 sg13cmos5l_nor2_1_6.Y a_4950_15302# 0.01033f
C924 sg13cmos5l_o21ai_1_18.B1 sg13cmos5l_inv_1_25.Y 0.05813f
C925 sg13cmos5l_a21oi_1_21.A1 bn2 0.01771f
C926 sg13cmos5l_nor3_1_2.B a_11019_9959# 0.0201f
C927 sg13cmos5l_nand4_1_1.C sg13cmos5l_a21oi_1_7.A2 0.06645f
C928 sg13cmos5l_buf_8_2.A sg13cmos5l_dfrbpq_1_38.Q 0.04057f
C929 sg13cmos5l_nand2_1_19.Y clk 0.04616f
C930 sg13cmos5l_nand3_1_8.Y sg13cmos5l_a21oi_1_3.A2 0.01523f
C931 sg13cmos5l_buf_1_1.A sg13cmos5l_inv_1_13.Y 0.06308f
C932 sg13cmos5l_nand4_1_1.B code1 0.02689f
C933 sg13cmos5l_dfrbpq_1_24.Q sg13cmos5l_mux2_1_1.A1 0.91954f
C934 sg13cmos5l_nor4_1_1.D VDD 0.92188f
C935 a_17412_6928# a_18577_7285# 0.25046f
C936 sg13cmos5l_nand2_1_12.A a_13294_16935# 0.11537f
C937 a_17700_7349# a_17931_6935# 0.07823f
C938 sg13cmos5l_dfrbpq_1_28.RESET_B sg13cmos5l_inv_1_25.Y 0.82986f
C939 sg13cmos5l_inv_1_31.A a_21084_16357# 0.04386f
C940 sg13cmos5l_dlygate4sd3_1_64.X VDD 1.15319f
C941 sg13cmos5l_nand4_1_7.B a_16742_15234# 0.03488f
C942 sg13cmos5l_nor4_1_0.C sg13cmos5l_a22oi_1_1.B2 0.01561f
C943 sg13cmos5l_nand4_1_1.C sg13cmos5l_a21oi_1_3.A2 0.20683f
C944 sg13cmos5l_dfrbpq_1_21.D sg13cmos5l_o21ai_1_19.Y 0.06319f
C945 sg13cmos5l_o21ai_1_9.A2 sg13cmos5l_a21o_1_2.X 0.04727f
C946 sg13cmos5l_o21ai_1_19.Y a_7954_17886# 0.06016f
C947 sg13cmos5l_inv_1_15.A a_21866_18416# 0.0146f
C948 sg13cmos5l_nand3_1_0.B a_16566_8460# 0.04712f
C949 sg13cmos5l_buf_8_2.A a_12808_10034# 0.02259f
C950 sg13cmos5l_nand2b_1_4.Y sg13cmos5l_a21oi_1_8.A2 0.04617f
C951 sg13cmos5l_dlygate4sd3_1_43.A a_7162_6888# 0.28299f
C952 sg13cmos5l_inv_1_17.A a_21084_16710# 0.0169f
C953 sg13cmos5l_dfrbpq_1_13.CLK sg13cmos5l_nand2_1_13.Y 0.0142f
C954 sg13cmos5l_dfrbpq_1_39.D a_18756_17512# 0.0409f
C955 sg13cmos5l_o21ai_1_5.A1 sg13cmos5l_o21ai_1_11.A2 0.15444f
C956 sg13cmos5l_nand4_1_6.B sg13cmos5l_o21ai_1_5.A2 0.12751f
C957 sg13cmos5l_buf_1_15.A sg13cmos5l_inv_1_31.A 0.14042f
C958 sg13cmos5l_buf_1_63.A a_14244_20088# 0.01719f
C959 sg13cmos5l_buf_8_2.A a_12987_10318# 0.34695f
C960 sg13cmos5l_o21ai_1_5.A2 a_13676_12936# 0.04935f
C961 sg13cmos5l_nor2_1_2.B sg13cmos5l_a22oi_1_1.B2 0.01239f
C962 sg13cmos5l_buf_1_16.A a_18575_8797# 0.01412f
C963 sg13cmos5l_dlygate4sd3_1_80.X a_13478_16434# 0.17403f
C964 sg13cmos5l_dfrbpq_1_15.CLK a_6021_12983# 0.22061f
C965 sg13cmos5l_o21ai_1_23.A2 busy 0.02372f
C966 a_20997_12189# a_20868_12223# 0.01562f
C967 sg13cmos5l_o21ai_1_1.B1 sg13cmos5l_o21ai_1_1.Y 0.4473f
C968 sg13cmos5l_dfrbpq_1_15.Q a_8122_8400# 0.01306f
C969 sg13cmos5l_o21ai_1_5.A2 a_13384_14484# 0.04699f
C970 sg13cmos5l_o21ai_1_19.Y sg13cmos5l_buf_8_2.A 0.05176f
C971 sg13cmos5l_inv_1_8.A sg13cmos5l_nor2b_1_2.Y 0.1791f
C972 sg13cmos5l_o21ai_1_7.B1 a_6094_16935# 0.03982f
C973 sg13cmos5l_dfrbpq_1_19.CLK a_8043_19031# 0.05882f
C974 sg13cmos5l_a21oi_1_4.A1 sg13cmos5l_and2_1_3.X 0.0208f
C975 sg13cmos5l_nand3_1_0.Y sg13cmos5l_nand2b_1_3.B 0.09845f
C976 sg13cmos5l_inv_1_15.Y sg13cmos5l_nand4_1_15.B 0.02441f
C977 sg13cmos5l_a21oi_1_6.Y bp2 0.03792f
C978 sg13cmos5l_dfrbpq_1_39.D sg13cmos5l_dlygate4sd3_1_72.A 0.04127f
C979 sg13cmos5l_a21oi_1_27.B1 sg13cmos5l_a21o_1_2.X 0.06628f
C980 sg13cmos5l_inv_1_25.Y bn1 0.02464f
C981 a_12420_19024# a_12708_19445# 0.24435f
C982 sg13cmos5l_buf_1_15.A sg13cmos5l_nor3_1_6.Y 0.39118f
C983 sg13cmos5l_inv_1_36.Y VDD 0.46751f
C984 sg13cmos5l_buf_8_2.A a_7238_17508# 0.01073f
C985 sg13cmos5l_nor2b_1_2.Y sg13cmos5l_a22oi_1_2.Y 0.2233f
C986 sg13cmos5l_nor2b_1_2.Y a_13434_6887# 0.01065f
C987 sg13cmos5l_dfrbpq_1_13.CLK sg13cmos5l_nand3b_1_0.C 0.63528f
C988 sg13cmos5l_buf_1_2.A a_19720_3176# 0.02722f
C989 sg13cmos5l_o21ai_1_28.A1 bn2 0.03205f
C990 a_11562_12508# VDD 0.27925f
C991 a_5157_14495# a_5259_14495# 0.3643f
C992 sg13cmos5l_dlygate4sd3_1_16.A a_22522_7642# 0.2754f
C993 a_21370_6130# bp2 0.07604f
C994 sg13cmos5l_buf_1_15.A sg13cmos5l_inv_1_9.Y 0.01368f
C995 sg13cmos5l_dlygate4sd3_1_74.A a_20026_15202# 0.27781f
C996 sg13cmos5l_nand2b_1_1.A_N a_10878_7180# 0.01395f
C997 sg13cmos5l_nand4_1_8.B a_15784_15272# 0.0137f
C998 sg13cmos5l_inv_1_20.Y sg13cmos5l_a21o_1_0.A2 0.0168f
C999 sg13cmos5l_nand2b_1_1.A_N a_9934_9375# 0.02046f
C1000 sg13cmos5l_buf_1_63.A sg13cmos5l_buf_1_26.A 0.02527f
C1001 sg13cmos5l_buf_1_47.X a_10118_18262# 0.01403f
C1002 sg13cmos5l_buf_1_16.A sg13cmos5l_inv_1_24.Y 0.11091f
C1003 sg13cmos5l_buf_1_15.A sg13cmos5l_nand4_1_8.B 0.02764f
C1004 a_15680_5498# VDD 0.06838f
C1005 sg13cmos5l_buf_1_9.A a_21269_9484# 0.01018f
C1006 sg13cmos5l_buf_8_2.A sg13cmos5l_dfrbpq_1_7.D 0.14779f
C1007 sg13cmos5l_o21ai_1_0.A1 sg13cmos5l_o21ai_1_0.B1 0.5411f
C1008 sg13cmos5l_buf_1_5.A a_18952_3176# 0.01641f
C1009 a_9064_14570# VDD 0.16619f
C1010 sg13cmos5l_dfrbpq_1_13.Q sg13cmos5l_a21oi_1_11.Y 0.02426f
C1011 sg13cmos5l_buf_1_7.X a_19328_4782# 0.01732f
C1012 sg13cmos5l_dfrbpq_1_13.Q sg13cmos5l_a21oi_1_9.A1 0.02474f
C1013 sg13cmos5l_dfrbpq_1_28.RESET_B sg13cmos5l_and2_1_3.X 0.01641f
C1014 sg13cmos5l_dfrbpq_1_13.Q sg13cmos5l_nor3_1_1.Y 0.11203f
C1015 sg13cmos5l_inv_1_17.Y a_19179_10820# 0.02399f
C1016 sg13cmos5l_a21oi_1_7.A2 a_21254_10702# 0.06482f
C1017 sg13cmos5l_buf_1_4.A a_20580_4968# 0.02119f
C1018 sg13cmos5l_dfrbpq_1_37.D sg13cmos5l_dfrbpq_1_29.Q 0.08187f
C1019 sg13cmos5l_dlygate4sd3_1_18.A a_18123_11471# 0.02287f
C1020 a_4607_18528# a_4952_17549# 0.01139f
C1021 sg13cmos5l_buf_1_1.A sg13cmos5l_buf_1_9.A 0.04918f
C1022 sg13cmos5l_buf_1_4.A sg13cmos5l_buf_1_6.A 0.32893f
C1023 sg13cmos5l_nor3_1_2.B a_12987_10318# 0.06155f
C1024 sg13cmos5l_dfrbpq_1_20.Q a_5451_19031# 0.02829f
C1025 sg13cmos5l_nand4_1_18.C a_17224_12972# 0.15511f
C1026 sg13cmos5l_o21ai_1_0.A1 sg13cmos5l_a21oi_1_11.Y 0.07134f
C1027 sg13cmos5l_inv_1_15.Y sg13cmos5l_a21oi_1_15.A2 0.02864f
C1028 sg13cmos5l_dfrbpq_1_24.RESET_B a_4127_17016# 0.04331f
C1029 sg13cmos5l_mux2_1_0.S a_9636_12528# 0.01259f
C1030 sg13cmos5l_o21ai_1_0.A1 sg13cmos5l_a21oi_1_9.A1 0.19819f
C1031 sg13cmos5l_o21ai_1_28.B1 a_12406_15230# 0.02919f
C1032 sg13cmos5l_nor3_1_7.Y sg13cmos5l_nand2_1_2.Y 0.11685f
C1033 sg13cmos5l_o21ai_1_0.A1 sg13cmos5l_nor3_1_1.Y 0.21539f
C1034 a_18671_7285# a_18577_7285# 0.16704f
C1035 sg13cmos5l_buf_1_65.A a_7912_12972# 0.16176f
C1036 sg13cmos5l_o21ai_1_5.A1 bn4 0.05756f
C1037 sg13cmos5l_nand4_1_1.B sg13cmos5l_nor4_1_4.C 0.06602f
C1038 sg13cmos5l_inv_1_8.Y a_15496_5498# 0.02467f
C1039 sg13cmos5l_a21o_1_0.X a_10049_9376# 0.02439f
C1040 sg13cmos5l_inv_1_1.Y sg13cmos5l_dfrbpq_1_8.D 0.01784f
C1041 sg13cmos5l_dlygate4sd3_1_4.A a_20294_4650# 0.04805f
C1042 sg13cmos5l_buf_1_13.X a_16188_9150# 0.01524f
C1043 sg13cmos5l_inv_1_4.Y sg13cmos5l_dfrbpq_1_2.D 0.08281f
C1044 sg13cmos5l_dfrbpq_1_24.Q sg13cmos5l_nor3_1_4.A 0.31713f
C1045 a_5880_15552# VDD 0.01784f
C1046 sg13cmos5l_inv_1_1.Y a_20586_7972# 0.04116f
C1047 sg13cmos5l_buf_1_66.X sg13cmos5l_o21ai_1_5.A1 2.36026f
C1048 sg13cmos5l_o21ai_1_5.A2 sg13cmos5l_o21ai_1_11.A2 0.03711f
C1049 sg13cmos5l_buf_8_2.A sg13cmos5l_nand2_1_18.A 0.29644f
C1050 sg13cmos5l_inv_1_17.A a_21911_17137# 0.03509f
C1051 a_20026_15202# sg13cmos5l_dfrbpq_1_29.D 0.04949f
C1052 sg13cmos5l_nand3b_1_3.C sg13cmos5l_nand3_1_6.C 0.01201f
C1053 a_7238_19458# a_7941_19031# 0.02431f
C1054 sg13cmos5l_nand2_1_1.Y VDD 0.57579f
C1055 sg13cmos5l_buf_1_25.A busy 0.02477f
C1056 a_11397_18237# a_12145_18335# 0.01058f
C1057 a_12496_18478# a_12906_18556# 0.07015f
C1058 sg13cmos5l_or4_1_0.D a_8520_8436# 0.04447f
C1059 sg13cmos5l_buf_1_25.A sg13cmos5l_nand4_1_7.B 0.01957f
C1060 sg13cmos5l_inv_1_8.A a_15012_6175# 0.02065f
C1061 sg13cmos5l_o21ai_1_18.A2 a_8434_17886# 0.04784f
C1062 sg13cmos5l_buf_1_5.A a_17622_10766# 0.01073f
C1063 sg13cmos5l_dfrbpq_1_19.CLK sg13cmos5l_dlygate4sd3_1_65.A 0.01109f
C1064 a_18762_20068# a_19246_19959# 0.01641f
C1065 sg13cmos5l_a21oi_1_24.A1 sg13cmos5l_dfrbpq_1_48.Q 0.03475f
C1066 sg13cmos5l_a21oi_1_4.A2 bn5 0.03287f
C1067 sg13cmos5l_dfrbpq_1_13.CLK sg13cmos5l_nand2b_1_1.A_N 0.07361f
C1068 sg13cmos5l_nand3b_1_3.C sg13cmos5l_a21oi_1_4.A1 0.13762f
C1069 a_16078_19287# code1 0.03566f
C1070 sg13cmos5l_o21ai_1_5.A1 VDD 1.37942f
C1071 sg13cmos5l_buf_1_9.A bn9 0.60915f
C1072 a_12939_19031# a_13936_19262# 0.03546f
C1073 a_7350_17532# sg13cmos5l_o21ai_1_19.B1 0.01576f
C1074 sg13cmos5l_nor3_1_0.Y a_15299_10996# 0.03092f
C1075 sg13cmos5l_buf_1_16.A a_20384_18433# 0.02008f
C1076 sg13cmos5l_buf_1_7.X bp2 0.04076f
C1077 sg13cmos5l_dlygate4sd3_1_97.X VDD 0.26107f
C1078 sg13cmos5l_inv_1_1.A sg13cmos5l_buf_1_9.A 0.12691f
C1079 a_20716_16434# VDD 0.135f
C1080 sg13cmos5l_o21ai_1_14.Y sg13cmos5l_o21ai_1_19.B1 0.03141f
C1081 a_3112_19902# a_3296_19902# 0.05762f
C1082 a_8060_17488# VDD 0.01784f
C1083 a_17028_15552# a_17547_15356# 0.20773f
C1084 sg13cmos5l_inv_1_18.A a_14646_10766# 0.02608f
C1085 sg13cmos5l_o21ai_1_11.B1 a_6401_16262# 0.05214f
C1086 sg13cmos5l_nand4_1_18.A a_19534_13239# 0.01522f
C1087 a_15400_15272# VDD 0.18109f
C1088 sg13cmos5l_nand2_1_0.A sg13cmos5l_and4_1_0.D 0.01529f
C1089 sg13cmos5l_buf_1_45.X a_13764_16000# 0.28855f
C1090 sg13cmos5l_buf_1_17.X sg13cmos5l_buf_1_17.A 0.09698f
C1091 sg13cmos5l_nor2_1_10.Y a_10230_18326# 0.06106f
C1092 a_9322_19993# VDD 0.09413f
C1093 sg13cmos5l_buf_1_10.A sg13cmos5l_o21ai_1_3.Y 0.0227f
C1094 sg13cmos5l_buf_1_4.A sg13cmos5l_inv_1_7.A 0.15235f
C1095 sg13cmos5l_dlygate4sd3_1_16.A sg13cmos5l_dlygate4sd3_1_24.A 0.21746f
C1096 sg13cmos5l_buf_1_7.X a_21099_4772# 0.27992f
C1097 sg13cmos5l_dlygate4sd3_1_65.A a_9466_18226# 0.06941f
C1098 sg13cmos5l_a21oi_1_18.B1 a_17028_15552# 0.01927f
C1099 sg13cmos5l_dfrbpq_1_28.RESET_B a_19534_16263# 0.02676f
C1100 sg13cmos5l_buf_1_15.A a_10607_19847# 0.10868f
C1101 sg13cmos5l_nor2_1_10.Y a_10066_19398# 0.04811f
C1102 sg13cmos5l_inv_1_2.A a_20580_4968# 0.0708f
C1103 sg13cmos5l_a21oi_1_2.B1 a_21832_7806# 0.01854f
C1104 sg13cmos5l_nand4_1_18.B sg13cmos5l_nand2_1_11.B 0.68553f
C1105 sg13cmos5l_o21ai_1_5.A2 bn4 0.32031f
C1106 sg13cmos5l_inv_1_2.A sg13cmos5l_buf_1_6.A 0.07267f
C1107 a_21838_19959# sg13cmos5l_buf_1_25.A 0.10701f
C1108 sg13cmos5l_buf_1_57.A bn5 0.01397f
C1109 sg13cmos5l_buf_1_25.A sg13cmos5l_dfrbpq_1_33.D 0.05348f
C1110 sg13cmos5l_nand3_1_0.B sg13cmos5l_inv_1_11.Y 0.02007f
C1111 a_21084_16357# sg13cmos5l_inv_1_25.Y 0.04232f
C1112 sg13cmos5l_nand4_1_1.A a_18574_14751# 0.05318f
C1113 sg13cmos5l_buf_1_66.X sg13cmos5l_o21ai_1_5.A2 0.33968f
C1114 sg13cmos5l_o21ai_1_11.Y sg13cmos5l_o21ai_1_10.B1 0.09125f
C1115 sg13cmos5l_o21ai_1_6.Y sg13cmos5l_nor4_1_0.C 0.10965f
C1116 sg13cmos5l_buf_1_15.A sg13cmos5l_dfrbpq_1_24.Q 0.93083f
C1117 sg13cmos5l_o21ai_1_5.A1 a_6418_15230# 0.08219f
C1118 sg13cmos5l_nand2_1_3.Y sg13cmos5l_dlygate4sd3_1_43.A 0.06178f
C1119 sg13cmos5l_mux2_1_1.A0 a_8682_11460# 0.0117f
C1120 sg13cmos5l_o21ai_1_28.B1 sg13cmos5l_o21ai_1_28.Y 0.51508f
C1121 a_7524_19024# a_8043_19031# 0.20754f
C1122 a_7941_19031# a_7812_19445# 0.01562f
C1123 sg13cmos5l_nand4_1_1.B sg13cmos5l_a21oi_1_7.A2 0.08891f
C1124 sg13cmos5l_nand3b_1_3.C bn1 0.01584f
C1125 sg13cmos5l_buf_1_16.A a_18863_11821# 0.02477f
C1126 a_12906_18556# sg13cmos5l_dfrbpq_1_48.Q 0.09683f
C1127 sg13cmos5l_inv_1_8.A sg13cmos5l_nand3_1_2.A 0.46683f
C1128 sg13cmos5l_nand3_1_0.Y sg13cmos5l_dfrbpq_1_2.D 0.32316f
C1129 sg13cmos5l_buf_1_15.A sg13cmos5l_inv_1_25.Y 0.22407f
C1130 sg13cmos5l_buf_1_45.X sg13cmos5l_inv_1_8.A 0.33593f
C1131 sg13cmos5l_dfrbpq_1_28.RESET_B a_20997_14495# 0.03835f
C1132 a_12232_14484# bn2 0.15632f
C1133 sg13cmos5l_buf_1_25.A a_12708_19445# 0.0109f
C1134 sg13cmos5l_inv_1_31.A sg13cmos5l_buf_1_26.A 0.07213f
C1135 sg13cmos5l_nand4_1_18.B sg13cmos5l_buf_1_20.A 0.04839f
C1136 sg13cmos5l_nand4_1_18.D sg13cmos5l_inv_1_13.Y 0.19772f
C1137 a_13148_4968# VDD 0.02587f
C1138 sg13cmos5l_buf_1_54.A sg13cmos5l_nand4_1_8.B 0.01976f
C1139 sg13cmos5l_nand3_1_0.B sg13cmos5l_o21ai_1_3.Y 0.28089f
C1140 a_19630_15423# a_19336_15366# 0.01555f
C1141 sg13cmos5l_inv_1_1.Y sg13cmos5l_inv_1_12.A 0.02277f
C1142 sg13cmos5l_a21oi_1_2.B1 a_17316_8440# 0.01358f
C1143 sg13cmos5l_o21ai_1_5.A2 VDD 2.07893f
C1144 sg13cmos5l_inv_1_32.Y a_13768_14484# 0.04772f
C1145 sg13cmos5l_nor2_1_2.B sg13cmos5l_nor2_1_2.A 0.1952f
C1146 a_14561_9376# a_14842_9154# 0.18796f
C1147 a_22241_9376# bp1 0.02837f
C1148 sg13cmos5l_buf_1_10.A sg13cmos5l_buf_1_4.A 0.03725f
C1149 sg13cmos5l_buf_1_15.A sg13cmos5l_o21ai_1_21.A2 0.01499f
C1150 a_19450_18226# a_19829_18556# 0.02543f
C1151 sg13cmos5l_o21ai_1_1.Y sg13cmos5l_dlygate4sd3_1_9.A 0.13871f
C1152 sg13cmos5l_inv_1_1.Y a_20207_5773# 0.01779f
C1153 sg13cmos5l_buf_1_65.A sg13cmos5l_a21oi_1_4.A1 0.2152f
C1154 a_14438_6162# a_15243_6284# 0.07916f
C1155 a_14724_6480# a_15141_6141# 0.28324f
C1156 sg13cmos5l_o21ai_1_20.B1 a_3872_17594# 0.01984f
C1157 sg13cmos5l_buf_1_45.X a_15023_16357# 0.10896f
C1158 a_9765_19749# a_10513_19847# 0.01058f
C1159 sg13cmos5l_inv_1_33.Y VDD 0.12088f
C1160 sg13cmos5l_dfrbpq_1_15.CLK a_5124_9504# 0.09726f
C1161 sg13cmos5l_a21oi_1_12.A2 a_8844_15424# 0.29879f
C1162 sg13cmos5l_buf_1_47.X a_11397_18237# 0.03119f
C1163 a_18470_19458# a_19044_19445# 0.18486f
C1164 a_18756_19024# a_19173_19031# 0.28418f
C1165 a_18670_16263# VDD 0.15877f
C1166 sg13cmos5l_a21oi_1_5.A2 sg13cmos5l_a21oi_1_0.A2 0.03379f
C1167 sg13cmos5l_nor3_1_6.Y sg13cmos5l_o21ai_1_9.B1 0.12959f
C1168 sg13cmos5l_buf_1_26.A sg13cmos5l_nand4_1_8.B 0.1235f
C1169 sg13cmos5l_dfrbpq_1_47.Q a_12082_7302# 0.01099f
C1170 sg13cmos5l_dfrbpq_1_39.Q a_20682_19020# 0.01215f
C1171 sg13cmos5l_dfrbpq_1_41.CLK bn5 0.01716f
C1172 sg13cmos5l_buf_1_2.A sg13cmos5l_inv_1_2.Y 0.01406f
C1173 a_10878_7180# VDD 0.51404f
C1174 VDD bp5 0.44694f
C1175 sg13cmos5l_a22oi_1_0.B2 sg13cmos5l_nand3_1_0.A 0.02523f
C1176 a_9934_9375# VDD 0.16107f
C1177 a_11374_17775# a_11489_17774# 0.3854f
C1178 sg13cmos5l_nand3_1_2.A bp0 0.1974f
C1179 sg13cmos5l_a21oi_1_5.A2 sg13cmos5l_inv_1_14.Y 0.16574f
C1180 sg13cmos5l_inv_1_12.Y sg13cmos5l_nor3_1_7.Y 0.02351f
C1181 sg13cmos5l_o21ai_1_18.B1 sg13cmos5l_buf_1_65.A 0.04716f
C1182 sg13cmos5l_dfrbpq_1_7.D a_21839_10309# 0.01617f
C1183 a_16875_5423# a_17872_5654# 0.03546f
C1184 a_16773_5423# a_17521_5773# 0.01058f
C1185 sg13cmos5l_a21oi_1_5.A2 a_18928_7166# 0.01102f
C1186 sg13cmos5l_buf_1_57.A sg13cmos5l_dfrbpq_1_18.Q 0.01419f
C1187 sg13cmos5l_dlygate4sd3_1_72.A bn5 0.03878f
C1188 sg13cmos5l_nand4_1_6.B bn6 0.13875f
C1189 a_21063_16083# bn6 0.02472f
C1190 sg13cmos5l_buf_8_2.A sg13cmos5l_buf_1_13.X 0.07052f
C1191 sg13cmos5l_nor3_1_6.Y sg13cmos5l_a21o_1_2.X 0.43686f
C1192 a_22522_7642# VDD 0.25901f
C1193 sg13cmos5l_inv_1_31.A a_19829_18556# 0.01972f
C1194 sg13cmos5l_buf_1_42.A sg13cmos5l_a21oi_1_20.Y 0.01239f
C1195 sg13cmos5l_nand4_1_1.A sg13cmos5l_a21oi_1_23.A2 0.16225f
C1196 sg13cmos5l_nand3_1_3.Y a_10709_6460# 0.0195f
C1197 sg13cmos5l_nand4_1_1.B sg13cmos5l_inv_1_17.Y 0.01552f
C1198 a_21185_7864# VDD 0.20178f
C1199 a_20580_9952# a_21839_10309# 0.01412f
C1200 sg13cmos5l_inv_1_4.Y sg13cmos5l_buf_1_0.A 0.86236f
C1201 a_20554_14452# VDD 0.09458f
C1202 sg13cmos5l_buf_1_65.A sg13cmos5l_mux2_1_1.A1 0.24859f
C1203 sg13cmos5l_buf_1_43.X sg13cmos5l_buf_1_57.A 0.02021f
C1204 sg13cmos5l_inv_1_31.Y sg13cmos5l_buf_1_1.A 0.01376f
C1205 sg13cmos5l_nand3_1_4.Y a_9500_8416# 0.01222f
C1206 sg13cmos5l_nand3_1_8.Y sg13cmos5l_a21oi_1_6.A2 0.17331f
C1207 sg13cmos5l_inv_1_16.Y sg13cmos5l_inv_1_12.Y 0.04835f
C1208 a_8043_19031# a_8783_19381# 0.17382f
C1209 a_13764_17512# bn4 0.01138f
C1210 sg13cmos5l_or4_1_0.C a_10330_9154# 0.29252f
C1211 sg13cmos5l_inv_1_15.A sg13cmos5l_nand3_1_8.Y 0.02329f
C1212 a_21099_8447# VDD 0.20659f
C1213 sg13cmos5l_a21oi_1_4.A2 a_14761_15238# 0.16487f
C1214 sg13cmos5l_a21oi_1_6.A2 a_19179_10820# 0.01888f
C1215 sg13cmos5l_nand4_1_1.C sg13cmos5l_a21oi_1_6.A2 0.09638f
C1216 a_6730_11428# a_6756_11464# 0.24169f
C1217 sg13cmos5l_inv_1_9.Y a_17318_11898# 0.03231f
C1218 a_17825_17774# VDD 0.20834f
C1219 bp6 bp5 0.06305f
C1220 bp2 bp4 0.2133f
C1221 bp1 bp7 0.01892f
C1222 sg13cmos5l_inv_1_15.A sg13cmos5l_nand4_1_1.C 0.06544f
C1223 sg13cmos5l_nand4_1_1.C a_15496_13760# 0.16345f
C1224 a_5998_13911# sg13cmos5l_dfrbpq_1_24.D 0.10701f
C1225 sg13cmos5l_a21oi_1_4.A1 a_16091_9948# 0.02786f
C1226 sg13cmos5l_a21oi_1_18.B1 a_20554_13945# 0.01557f
C1227 a_13958_19770# VDD 0.52309f
C1228 sg13cmos5l_nand4_1_15.B sg13cmos5l_inv_1_36.A 1.54118f
C1229 sg13cmos5l_a21oi_1_4.A1 a_16193_10296# 0.01183f
C1230 sg13cmos5l_nor2_1_2.B sg13cmos5l_nand2b_1_4.Y 0.29896f
C1231 a_15622_8412# VDD 0.01276f
C1232 sg13cmos5l_nand2_1_11.B sg13cmos5l_a21o_1_2.B1 0.20773f
C1233 sg13cmos5l_o21ai_1_8.B1 a_7378_16374# 0.04607f
C1234 sg13cmos5l_buf_1_24.A a_11558_19020# 0.06564f
C1235 a_15488_9361# a_15208_9318# 0.01648f
C1236 sg13cmos5l_dfrbpq_1_13.RESET_B a_9348_5416# 0.29403f
C1237 a_18478_10215# VDD 0.15838f
C1238 sg13cmos5l_o21ai_1_1.B1 sg13cmos5l_nand3b_1_0.C 0.01468f
C1239 a_16454_8436# VDD 0.20311f
C1240 sg13cmos5l_a21oi_1_17.Y sg13cmos5l_nand3_1_8.Y 0.31152f
C1241 a_20294_12210# bn8 0.04543f
C1242 sg13cmos5l_nand2_1_18.A a_12929_13238# 0.07336f
C1243 sg13cmos5l_buf_1_13.A a_15141_6141# 0.05847f
C1244 sg13cmos5l_dfrbpq_1_13.D a_8637_5682# 0.02369f
C1245 sg13cmos5l_inv_1_8.A sg13cmos5l_nand3_1_1.Y 0.17061f
C1246 a_13764_17512# VDD 0.07349f
C1247 a_17445_15213# a_18193_15311# 0.01058f
C1248 sg13cmos5l_buf_1_10.A sg13cmos5l_inv_1_2.A 0.06416f
C1249 sg13cmos5l_dfrbpq_1_13.CLK VDD 2.40582f
C1250 sg13cmos5l_nand2b_1_0.B sg13cmos5l_inv_1_20.Y 0.02303f
C1251 sg13cmos5l_a21oi_1_17.Y sg13cmos5l_nand4_1_1.C 0.02775f
C1252 sg13cmos5l_buf_1_6.A a_18952_3176# 0.19271f
C1253 sg13cmos5l_nand3_1_1.Y sg13cmos5l_dlygate4sd3_1_25.A 0.01718f
C1254 sg13cmos5l_nand4_1_17.Y sg13cmos5l_a21oi_1_24.Y 0.07091f
C1255 a_22241_6352# bp5 0.03566f
C1256 a_15243_6284# a_16240_6382# 0.03412f
C1257 sg13cmos5l_inv_1_5.A a_16875_5423# 0.01308f
C1258 sg13cmos5l_o21ai_1_7.A2 sg13cmos5l_o21ai_1_11.A2 0.06114f
C1259 sg13cmos5l_nand2_1_13.A sg13cmos5l_and2_1_6.A 0.02727f
C1260 sg13cmos5l_a21oi_1_9.A2 a_10811_4948# 0.05653f
C1261 sg13cmos5l_buf_1_15.A sg13cmos5l_inv_1_5.A 0.01081f
C1262 a_22241_9376# a_22522_9154# 0.18796f
C1263 a_19275_17519# bn5 0.01877f
C1264 sg13cmos5l_o21ai_1_20.Y a_4070_19020# 0.03157f
C1265 sg13cmos5l_dfrbpq_1_39.Q a_21080_19061# 0.03698f
C1266 sg13cmos5l_o21ai_1_20.A1 sg13cmos5l_inv_1_25.Y 0.03629f
C1267 sg13cmos5l_nand2b_1_1.A_N sg13cmos5l_nand2b_1_5.Y 0.05819f
C1268 sg13cmos5l_buf_1_57.A a_14761_15238# 0.01554f
C1269 sg13cmos5l_nand2b_1_1.A_N sg13cmos5l_or4_1_0.C 0.03784f
C1270 sg13cmos5l_o21ai_1_21.B1 a_4594_17886# 0.04289f
C1271 sg13cmos5l_dfrbpq_1_20.Q a_4455_18476# 0.01628f
C1272 sg13cmos5l_nand3_1_8.Y sg13cmos5l_a21oi_1_1.A2 0.28644f
C1273 sg13cmos5l_dfrbpq_1_41.CLK sg13cmos5l_buf_1_43.X 0.29158f
C1274 a_9464_17549# VDD 0.2595f
C1275 sg13cmos5l_a21oi_1_4.A1 bn2 0.09565f
C1276 a_7841_10888# VDD 0.20652f
C1277 sg13cmos5l_nand4_1_5.D sg13cmos5l_nand4_1_1.C 0.11365f
C1278 sg13cmos5l_buf_1_43.X sg13cmos5l_nand4_1_1.A 0.07002f
C1279 sg13cmos5l_nand2_1_13.Y a_16666_12214# 0.01838f
C1280 sg13cmos5l_a21oi_1_1.A2 a_19179_10820# 0.03257f
C1281 sg13cmos5l_buf_1_15.A sg13cmos5l_nand3b_1_3.C 0.07373f
C1282 sg13cmos5l_o21ai_1_25.Y busy 0.11776f
C1283 sg13cmos5l_nand2_1_13.A a_9350_12210# 0.03085f
C1284 a_20554_8404# a_20580_8440# 0.24169f
C1285 a_20294_8874# a_21099_8447# 0.07916f
C1286 sg13cmos5l_inv_1_31.A a_21063_18476# 0.01739f
C1287 sg13cmos5l_dfrbpq_1_30.D a_21063_16083# 0.02459f
C1288 sg13cmos5l_dfrbpq_1_35.D a_18756_19024# 0.04122f
C1289 sg13cmos5l_a21o_1_0.A2 a_10788_10373# 0.01016f
C1290 sg13cmos5l_o21ai_1_20.A1 sg13cmos5l_o21ai_1_21.A2 0.03037f
C1291 a_21839_14845# VDD 0.17473f
C1292 sg13cmos5l_dfrbpq_1_13.RESET_B sg13cmos5l_buf_1_10.A 0.01685f
C1293 a_3782_9948# VDD 0.22154f
C1294 sg13cmos5l_a21oi_1_2.B1 sg13cmos5l_dlygate4sd3_1_28.A 0.07146f
C1295 sg13cmos5l_a21oi_1_19.Y sg13cmos5l_a21oi_1_24.A1 0.02699f
C1296 sg13cmos5l_a21oi_1_12.Y a_9096_15996# 0.04268f
C1297 sg13cmos5l_a21oi_1_27.B1 sg13cmos5l_dlygate4sd3_1_58.X 0.59495f
C1298 sg13cmos5l_dlygate4sd3_1_24.A VDD 0.42817f
C1299 a_4264_14570# VDD 0.15118f
C1300 sg13cmos5l_o21ai_1_6.Y sg13cmos5l_nand4_1_0.C 0.052f
C1301 sg13cmos5l_a21oi_1_2.A2 a_17126_7362# 0.04733f
C1302 sg13cmos5l_buf_1_10.A a_21256_3900# 0.01706f
C1303 sg13cmos5l_dfrbpq_1_9.Q sg13cmos5l_a21oi_1_0.Y 0.08178f
C1304 a_21070_7863# VDD 0.1579f
C1305 sg13cmos5l_buf_1_24.A a_11464_15366# 0.03493f
C1306 sg13cmos5l_nand3_1_0.Y sg13cmos5l_buf_1_0.A 0.88197f
C1307 a_7173_11471# a_7275_11471# 0.3643f
C1308 sg13cmos5l_buf_1_65.A sg13cmos5l_nor3_1_4.A 0.33973f
C1309 sg13cmos5l_nand2_1_13.A clk 0.02317f
C1310 sg13cmos5l_nor4_1_2.Y a_18574_14751# 0.04312f
C1311 a_16763_17508# VDD 0.16159f
C1312 a_20609_15424# a_20890_15202# 0.18796f
C1313 sg13cmos5l_buf_1_26.A sg13cmos5l_inv_1_25.Y 0.06567f
C1314 sg13cmos5l_inv_1_15.Y sg13cmos5l_nor3_1_6.Y 0.02284f
C1315 VDD code8 0.25208f
C1316 sg13cmos5l_o21ai_1_9.A2 sg13cmos5l_inv_1_36.A 0.01842f
C1317 sg13cmos5l_inv_1_1.Y a_20294_7362# 0.01796f
C1318 sg13cmos5l_nand2b_1_1.A_N sg13cmos5l_o21ai_1_1.B1 0.47442f
C1319 sg13cmos5l_a21oi_1_3.A2 sg13cmos5l_buf_1_13.A 0.22192f
C1320 a_11756_19734# code5 0.078f
C1321 sg13cmos5l_buf_8_2.A sg13cmos5l_inv_1_18.A 0.06624f
C1322 sg13cmos5l_a21oi_1_4.A1 sg13cmos5l_buf_1_14.A 0.27568f
C1323 a_16319_9456# sg13cmos5l_inv_1_5.A 0.19637f
C1324 a_16673_11726# VDD 0.20941f
C1325 sg13cmos5l_inv_1_15.Y sg13cmos5l_inv_1_9.Y 0.02855f
C1326 sg13cmos5l_inv_1_24.A a_19336_15366# 0.02314f
C1327 sg13cmos5l_a21oi_1_24.A1 a_17039_18335# 0.02547f
C1328 sg13cmos5l_a21oi_1_26.A2 sg13cmos5l_nand4_1_6.B 0.04859f
C1329 sg13cmos5l_dfrbpq_1_35.Q a_22784_19106# 0.03949f
C1330 sg13cmos5l_dfrbpq_1_19.CLK a_7066_18226# 0.02981f
C1331 sg13cmos5l_dfrbpq_1_15.Q sg13cmos5l_nand2b_1_4.B 0.11208f
C1332 sg13cmos5l_buf_1_42.A sg13cmos5l_nand4_1_16.D 0.01477f
C1333 sg13cmos5l_buf_1_16.A sg13cmos5l_buf_1_13.X 0.07312f
C1334 a_21839_13799# a_21531_13342# 0.01616f
C1335 a_15223_7638# VDD 0.1765f
C1336 sg13cmos5l_o21ai_1_22.Y sg13cmos5l_nor2b_1_1.A 0.01785f
C1337 sg13cmos5l_nor3_1_2.A a_7726_8703# 0.11847f
C1338 sg13cmos5l_buf_1_13.A a_17098_6130# 0.01291f
C1339 sg13cmos5l_dfrbpq_1_13.D a_9348_5416# 0.01088f
C1340 a_18287_15311# a_18193_15311# 0.16704f
C1341 a_15023_17869# VDD 0.17353f
C1342 sg13cmos5l_buf_1_25.A sg13cmos5l_buf_1_47.X 0.21442f
C1343 sg13cmos5l_buf_8_2.A sg13cmos5l_dfrbpq_1_30.Q 0.04595f
C1344 sg13cmos5l_buf_1_54.A sg13cmos5l_and2_1_3.X 0.01871f
C1345 a_16650_6460# a_17098_6130# 0.0185f
C1346 a_17914_9912# VDD 0.26595f
C1347 sg13cmos5l_o21ai_1_7.A2 sg13cmos5l_buf_1_66.X 0.21903f
C1348 a_20015_19381# a_20682_19020# 0.09257f
C1349 sg13cmos5l_a21oi_1_27.B1 sg13cmos5l_inv_1_36.A 0.02652f
C1350 sg13cmos5l_a21oi_1_8.Y a_8637_5682# 0.01639f
C1351 sg13cmos5l_o21ai_1_7.Y sg13cmos5l_o21ai_1_21.Y 0.01952f
C1352 a_19365_5423# VDD 0.24573f
C1353 a_21080_17549# bn5 0.01502f
C1354 a_14264_10702# a_14534_10702# 0.18796f
C1355 sg13cmos5l_dfrbpq_1_24.RESET_B a_4646_19458# 0.12852f
C1356 code1 bn0 0.08178f
C1357 bn2 bn1 0.31704f
C1358 valid busy 0.4319f
C1359 sg13cmos5l_a21oi_1_24.A1 bn0 0.02012f
C1360 sg13cmos5l_inv_1_5.A sg13cmos5l_a21oi_1_9.A2 0.02832f
C1361 a_10016_13854# VDD 0.08178f
C1362 sg13cmos5l_buf_1_3.A sample 0.03158f
C1363 sg13cmos5l_buf_1_66.X sg13cmos5l_mux2_1_0.A1 0.11357f
C1364 sg13cmos5l_nand2b_1_0.B sg13cmos5l_nand2_1_0.B 0.24873f
C1365 sg13cmos5l_nand4_1_7.B valid 0.01921f
C1366 sg13cmos5l_nand4_1_18.A sg13cmos5l_a21oi_1_0.A2 0.14324f
C1367 a_11759_10309# VDD 0.178f
C1368 sg13cmos5l_buf_1_7.X a_20997_11471# 0.03735f
C1369 sg13cmos5l_o21ai_1_23.B1 sg13cmos5l_a21oi_1_4.A2 0.01787f
C1370 sg13cmos5l_nand4_1_15.B a_17002_15457# 0.01028f
C1371 a_5345_19960# code6 0.01173f
C1372 sg13cmos5l_o21ai_1_7.A2 VDD 0.57615f
C1373 sg13cmos5l_a21oi_1_17.Y sg13cmos5l_dlygate4sd3_1_81.X 0.09451f
C1374 a_15503_19847# code1 0.01837f
C1375 sg13cmos5l_nor2b_1_1.A sg13cmos5l_nand2_1_9.Y 0.05642f
C1376 sg13cmos5l_buf_8_2.A sg13cmos5l_buf_1_9.A 0.0617f
C1377 a_1192_19020# sg13cmos5l_nand3b_1_3.C 0.15701f
C1378 sg13cmos5l_buf_1_26.A a_11489_17774# 0.05146f
C1379 a_20997_8447# a_21099_8447# 0.3643f
C1380 sg13cmos5l_nor4_1_2.Y bn5 0.01759f
C1381 sg13cmos5l_buf_1_26.A a_11770_17472# 0.03345f
C1382 sg13cmos5l_a21oi_1_27.A2 sg13cmos5l_dfrbpq_1_13.RESET_B 0.0683f
C1383 sg13cmos5l_inv_1_18.A sg13cmos5l_nor3_1_2.B 0.72408f
C1384 sg13cmos5l_dlygate4sd3_1_18.A sg13cmos5l_nor3_1_7.Y 0.08736f
C1385 a_8139_9959# VDD 0.20923f
C1386 a_18660_7992# a_19179_7796# 0.20773f
C1387 sg13cmos5l_mux2_1_0.A1 VDD 0.80921f
C1388 a_21920_17594# VDD 0.07894f
C1389 sg13cmos5l_a21oi_1_4.A2 sg13cmos5l_nand2b_1_0.B 0.01132f
C1390 a_21084_16710# a_21911_17137# 0.26205f
C1391 sg13cmos5l_a21oi_1_18.B1 a_16197_18237# 0.014f
C1392 sg13cmos5l_nand4_1_1.C sg13cmos5l_dlygate4sd3_1_76.A 0.03274f
C1393 sg13cmos5l_o21ai_1_18.A2 a_9290_17044# 0.01303f
C1394 VDD bn6 0.15971f
C1395 a_5412_7992# VDD 0.07935f
C1396 sg13cmos5l_inv_1_13.Y sg13cmos5l_a21oi_1_15.Y 0.06661f
C1397 sg13cmos5l_buf_1_13.X a_21839_10309# 0.10879f
C1398 sg13cmos5l_nor4_1_0.C sg13cmos5l_and4_1_0.D 0.13862f
C1399 a_8272_11702# a_8015_11821# 0.23043f
C1400 sg13cmos5l_inv_1_1.Y sg13cmos5l_dfrbpq_1_28.Q 0.01744f
C1401 sg13cmos5l_buf_1_15.A sg13cmos5l_buf_1_65.A 0.70522f
C1402 a_20682_17508# VDD 0.27705f
C1403 sg13cmos5l_a21oi_1_24.Y bn4 0.38161f
C1404 a_22330_10666# VDD 0.26512f
C1405 sg13cmos5l_o21ai_1_21.B1 a_4932_19024# 0.01252f
C1406 sg13cmos5l_buf_1_25.A sg13cmos5l_o21ai_1_25.B1 0.02108f
C1407 sg13cmos5l_nand4_1_3.B sg13cmos5l_nand2_1_15.Y 0.01318f
C1408 sg13cmos5l_inv_1_16.Y sg13cmos5l_dlygate4sd3_1_18.A 0.01767f
C1409 a_20406_6230# sg13cmos5l_buf_1_2.A 0.11554f
C1410 sg13cmos5l_dfrbpq_1_5.CLK bn8 0.05734f
C1411 sg13cmos5l_a22oi_1_1.B2 sg13cmos5l_dlygate4sd3_1_43.A 0.14916f
C1412 sg13cmos5l_o21ai_1_10.A2 sg13cmos5l_nand3_1_6.C 0.01241f
C1413 sg13cmos5l_a21oi_1_18.B1 bn8 0.05605f
C1414 sg13cmos5l_dfrbpq_1_24.RESET_B a_5334_17532# 0.02835f
C1415 sg13cmos5l_nand4_1_15.B sg13cmos5l_nand4_1_7.B 0.06761f
C1416 sg13cmos5l_dfrbpq_1_40.Q a_20974_19959# 0.01998f
C1417 sg13cmos5l_o21ai_1_28.A1 a_12406_15230# 0.05746f
C1418 a_20024_6166# a_20294_6166# 0.18796f
C1419 a_17290_8404# a_17733_8447# 0.02241f
C1420 sg13cmos5l_o21ai_1_9.Y a_6113_13912# 0.01651f
C1421 a_15607_9150# a_16188_9150# 0.01412f
C1422 a_21089_6352# VDD 0.20319f
C1423 sg13cmos5l_nand2_1_1.Y a_15597_12256# 0.06476f
C1424 sg13cmos5l_o21ai_1_21.B1 sg13cmos5l_dfrbpq_1_19.CLK 0.20848f
C1425 a_7726_10887# a_7841_10888# 0.3854f
C1426 sg13cmos5l_nand4_1_5.D a_16556_15960# 0.17409f
C1427 sg13cmos5l_or4_1_0.D sg13cmos5l_dlygate4sd3_1_42.A 0.16602f
C1428 sg13cmos5l_o21ai_1_23.B1 sg13cmos5l_buf_1_57.A 0.06359f
C1429 sg13cmos5l_a21oi_1_3.A2 sg13cmos5l_buf_1_5.A 0.02328f
C1430 a_16631_8065# VDD 0.52404f
C1431 sg13cmos5l_dfrbpq_1_9.D a_17030_8874# 0.04168f
C1432 sg13cmos5l_dfrbpq_1_13.RESET_B a_5124_9504# 0.30245f
C1433 sg13cmos5l_nand4_1_15.B sg13cmos5l_nand4_1_3.B 0.2277f
C1434 sg13cmos5l_a21oi_1_8.A2 a_7047_6380# 0.01619f
C1435 a_18593_10214# VDD 0.20735f
C1436 sg13cmos5l_inv_1_15.A sg13cmos5l_nand4_1_1.B 0.16901f
C1437 sg13cmos5l_inv_1_5.A sg13cmos5l_a21oi_1_3.Y 0.05506f
C1438 sg13cmos5l_nand3b_1_3.C sg13cmos5l_o21ai_1_20.A1 0.02553f
C1439 a_20716_18258# VDD 0.13699f
C1440 sg13cmos5l_nor2_1_2.B a_7736_7678# 0.0193f
C1441 sg13cmos5l_a21oi_1_3.Y a_17030_8874# 0.02926f
C1442 a_16566_8460# a_16454_8436# 0.3854f
C1443 a_22241_17774# sg13cmos5l_inv_1_25.Y 0.02815f
C1444 sg13cmos5l_dlygate4sd3_1_2.A VDD 0.1879f
C1445 sg13cmos5l_nand3b_1_3.C sg13cmos5l_buf_1_54.A 0.01439f
C1446 a_14446_11727# a_14561_11726# 0.3854f
C1447 sg13cmos5l_a21oi_1_24.Y VDD 0.15784f
C1448 sg13cmos5l_a21oi_1_3.Y a_16184_8477# 0.27737f
C1449 sg13cmos5l_inv_1_1.Y sg13cmos5l_buf_1_0.A 1.08612f
C1450 sg13cmos5l_nor2b_1_0.B_N a_14842_9154# 0.30173f
C1451 a_12239_18335# valid 0.01406f
C1452 a_20874_5412# VDD 0.27623f
C1453 sg13cmos5l_dfrbpq_1_24.RESET_B a_5451_19031# 0.33035f
C1454 a_19173_19031# sg13cmos5l_a21oi_1_19.Y 0.01618f
C1455 a_13478_17946# a_13738_17476# 0.45119f
C1456 sg13cmos5l_o21ai_1_3.A2 VDD 0.28463f
C1457 sg13cmos5l_a21o_1_2.A1 a_7446_14508# 0.1223f
C1458 sg13cmos5l_nand2_1_0.A sg13cmos5l_nand3_1_0.A 0.03553f
C1459 a_11388_14020# VDD 0.01158f
C1460 sg13cmos5l_buf_1_42.A a_15798_16754# 0.01859f
C1461 a_20580_14488# a_20997_14495# 0.28418f
C1462 a_20294_14922# a_21099_14495# 0.07916f
C1463 sg13cmos5l_o21ai_1_7.B1 a_5345_19960# 0.01495f
C1464 sg13cmos5l_nand4_1_18.B a_8043_19031# 0.0237f
C1465 a_14746_9912# VDD 0.26142f
C1466 sg13cmos5l_buf_1_25.A sg13cmos5l_dfrbpq_1_37.D 0.0269f
C1467 sg13cmos5l_buf_1_21.A sg13cmos5l_nand2_1_15.Y 0.05184f
C1468 sg13cmos5l_buf_1_66.X sg13cmos5l_nand3b_1_1.C 0.01185f
C1469 sg13cmos5l_dlygate4sd3_1_76.A a_20794_12936# 0.29657f
C1470 sg13cmos5l_dfrbpq_1_37.D a_21063_16964# 0.01398f
C1471 sg13cmos5l_inv_1_15.A sg13cmos5l_o21ai_1_28.Y 0.0161f
C1472 sg13cmos5l_dfrbpq_1_34.Q code1 0.02453f
C1473 sg13cmos5l_inv_1_17.A a_22096_10190# 0.04122f
C1474 sg13cmos5l_inv_1_32.Y sg13cmos5l_a21oi_1_4.A2 0.03677f
C1475 sg13cmos5l_nor4_1_0.Y a_12414_7996# 0.01305f
C1476 sg13cmos5l_buf_1_1.A bn8 0.0401f
C1477 sg13cmos5l_inv_1_6.Y bp5 0.08013f
C1478 sg13cmos5l_a21oi_1_0.A2 sg13cmos5l_dlygate4sd3_1_22.A 0.11511f
C1479 sg13cmos5l_dfrbpq_1_28.D sg13cmos5l_a21oi_1_5.A2 0.02135f
C1480 sg13cmos5l_dlygate4sd3_1_50.X sg13cmos5l_dfrbpq_1_23.Q 0.15169f
C1481 sg13cmos5l_a21oi_1_0.A2 a_18587_4948# 0.08116f
C1482 a_22096_8678# a_21839_8797# 0.23043f
C1483 sg13cmos5l_nand2b_1_5.Y VDD 0.34688f
C1484 sg13cmos5l_nor4_1_2.Y sg13cmos5l_dfrbpq_1_18.Q 0.13838f
C1485 sg13cmos5l_or4_1_0.C VDD 0.71468f
C1486 sg13cmos5l_nand4_1_3.B sg13cmos5l_a21oi_1_15.A2 0.02829f
C1487 sg13cmos5l_nand3b_1_3.C sg13cmos5l_buf_1_26.A 0.19095f
C1488 a_19179_7796# a_19919_7751# 0.17382f
C1489 a_21063_18476# sg13cmos5l_inv_1_25.Y 0.01157f
C1490 sg13cmos5l_inv_1_12.Y sg13cmos5l_a21oi_1_7.A2 0.02802f
C1491 sg13cmos5l_nand4_1_15.B sg13cmos5l_buf_1_21.A 0.02395f
C1492 sg13cmos5l_nand3b_1_1.C VDD 0.64489f
C1493 sg13cmos5l_inv_1_17.Y sg13cmos5l_a21oi_1_0.Y 0.07746f
C1494 sg13cmos5l_nand2_1_0.B sg13cmos5l_nand2b_1_3.B 0.01264f
C1495 sg13cmos5l_nor4_1_2.Y sg13cmos5l_buf_1_43.X 0.15168f
C1496 a_12929_19960# a_12837_19031# 0.01281f
C1497 a_7338_7972# VDD 0.27887f
C1498 sg13cmos5l_dfrbpq_1_24.Q a_11490_14020# 0.02258f
C1499 sg13cmos5l_buf_1_5.A a_19432_3900# 0.01948f
C1500 sg13cmos5l_buf_1_20.A sg13cmos5l_buf_1_22.A 0.11049f
C1501 sg13cmos5l_a21oi_1_25.Y sg13cmos5l_a21oi_1_26.A1 0.04188f
C1502 sg13cmos5l_nand3_1_5.Y sg13cmos5l_buf_1_66.X 0.04286f
C1503 sg13cmos5l_nand4_1_1.B sg13cmos5l_nand4_1_5.D 1.21497f
C1504 sg13cmos5l_dfrbpq_1_13.RESET_B a_10155_12332# 0.27997f
C1505 sg13cmos5l_dfrbpq_1_24.RESET_B a_11397_18237# 0.0353f
C1506 sg13cmos5l_dfrbpq_1_30.D VDD 0.26683f
C1507 sg13cmos5l_inv_1_1.Y sg13cmos5l_inv_1_17.A 0.0165f
C1508 sg13cmos5l_nand3_1_2.Y a_14264_10702# 0.02649f
C1509 a_14244_20088# a_14661_19749# 0.28324f
C1510 a_13958_19770# a_14763_19892# 0.07916f
C1511 sg13cmos5l_dfrbpq_1_41.CLK sg13cmos5l_o21ai_1_23.B1 0.04554f
C1512 sg13cmos5l_a21oi_1_25.Y sg13cmos5l_buf_1_25.A 0.02209f
C1513 a_10474_9916# a_10917_9959# 0.02241f
C1514 sg13cmos5l_mux2_1_1.A1 a_8734_12214# 0.31677f
C1515 sg13cmos5l_a21oi_1_3.A2 a_17109_9344# 0.0187f
C1516 sg13cmos5l_inv_1_36.A a_13210_12936# 0.01034f
C1517 a_19912_11460# VDD 0.18022f
C1518 sg13cmos5l_a21oi_1_18.B1 a_22096_13942# 0.01662f
C1519 sg13cmos5l_a21o_1_0.X a_10214_10386# 0.18091f
C1520 sg13cmos5l_o21ai_1_13.B1 bn3 0.35017f
C1521 sg13cmos5l_buf_1_16.A sg13cmos5l_buf_1_9.A 1.2177f
C1522 sg13cmos5l_dlygate4sd3_1_45.X sg13cmos5l_mux2_1_0.S 0.02206f
C1523 a_17316_8440# a_18575_8797# 0.01412f
C1524 sg13cmos5l_dfrbpq_1_28.RESET_B a_22126_17775# 0.05509f
C1525 bn8 bn9 0.04601f
C1526 sg13cmos5l_a21oi_1_27.B1 sg13cmos5l_mux2_1_1.A0 0.23926f
C1527 sg13cmos5l_o21ai_1_9.A2 sg13cmos5l_nand4_1_3.B 0.15746f
C1528 sg13cmos5l_dlygate4sd3_1_0.A a_22241_3328# 0.01734f
C1529 sg13cmos5l_buf_1_16.A a_18948_10711# 0.02141f
C1530 sg13cmos5l_nand3_1_5.Y VDD 0.80029f
C1531 sg13cmos5l_inv_1_5.A a_15935_7944# 0.24326f
C1532 a_20104_10034# VDD 0.14171f
C1533 a_15126_19044# a_15014_19020# 0.3854f
C1534 sg13cmos5l_inv_1_32.Y sg13cmos5l_buf_1_57.A 0.03614f
C1535 sg13cmos5l_o21ai_1_1.B1 VDD 1.06248f
C1536 sg13cmos5l_inv_1_32.Y a_13478_17946# 0.04443f
C1537 sg13cmos5l_a21oi_1_3.Y a_17604_8861# 0.01349f
C1538 sg13cmos5l_nor2_1_2.B sg13cmos5l_inv_1_19.Y 0.02822f
C1539 sg13cmos5l_o21ai_1_28.A1 sg13cmos5l_o21ai_1_28.Y 0.0169f
C1540 a_18497_6352# a_18778_6130# 0.18796f
C1541 sg13cmos5l_nand3_1_2.A a_14534_10702# 0.01134f
C1542 sg13cmos5l_a21oi_1_26.A2 VDD 0.62475f
C1543 sg13cmos5l_o21ai_1_5.A2 a_15597_12256# 0.02268f
C1544 sg13cmos5l_nand4_1_12.Y sg13cmos5l_buf_1_42.A 0.14528f
C1545 sg13cmos5l_nand2_1_11.B sg13cmos5l_nor2_1_4.Y 0.23265f
C1546 sg13cmos5l_buf_1_16.A a_17412_6928# 0.01141f
C1547 sg13cmos5l_dlygate4sd3_1_3.A bp8 0.02944f
C1548 sg13cmos5l_nand2b_1_1.A_N sg13cmos5l_dlygate4sd3_1_9.A 0.3136f
C1549 sg13cmos5l_dfrbpq_1_35.Q a_22030_19287# 0.0156f
C1550 sg13cmos5l_or4_1_0.D sg13cmos5l_dfrbpq_1_15.Q 0.02913f
C1551 sg13cmos5l_inv_1_8.A a_13749_9386# 0.1386f
C1552 sg13cmos5l_dfrbpq_1_41.CLK sg13cmos5l_a21oi_1_19.A2 0.0158f
C1553 sg13cmos5l_o21ai_1_8.B1 sg13cmos5l_o21ai_1_5.A2 0.08152f
C1554 sg13cmos5l_nand2_1_19.Y a_14240_12342# 0.02274f
C1555 a_20682_19020# sg13cmos5l_a21oi_1_19.Y 0.0299f
C1556 sg13cmos5l_dfrbpq_1_24.RESET_B a_7238_19458# 0.1048f
C1557 sg13cmos5l_nor2b_1_1.A sg13cmos5l_nor4_1_4.C 0.3774f
C1558 sg13cmos5l_a21oi_1_18.B1 a_18101_14020# 0.01531f
C1559 sg13cmos5l_dfrbpq_1_29.Q bn5 0.03556f
C1560 sg13cmos5l_nand2_1_19.A a_12597_11722# 0.13964f
C1561 sg13cmos5l_buf_8_2.A a_21745_12287# 0.0157f
C1562 a_20580_14488# a_21745_14845# 0.25046f
C1563 sg13cmos5l_inv_1_15.Y sg13cmos5l_and2_1_3.X 0.05443f
C1564 sg13cmos5l_buf_1_17.A rst_n 0.03363f
C1565 sg13cmos5l_o21ai_1_20.A1 sg13cmos5l_buf_1_65.A 1.1836f
C1566 sg13cmos5l_a21oi_1_27.B1 sg13cmos5l_nand4_1_3.B 0.78324f
C1567 sg13cmos5l_inv_1_18.A a_14446_9375# 0.01071f
C1568 sg13cmos5l_buf_1_45.X a_14218_18226# 0.06801f
C1569 sg13cmos5l_nand4_1_18.A a_19829_14020# 0.01589f
C1570 sg13cmos5l_nand2_1_18.A a_12987_12214# 0.05508f
C1571 sg13cmos5l_inv_1_1.A sg13cmos5l_dfrbpq_1_11.D 0.02306f
C1572 a_6958_19959# code6 0.02848f
C1573 sg13cmos5l_buf_1_1.A a_22096_13942# 0.03232f
C1574 sg13cmos5l_buf_1_21.A sg13cmos5l_nand2_1_0.A 0.02153f
C1575 sg13cmos5l_nand2_1_11.B a_9056_16878# 0.02084f
C1576 sg13cmos5l_o21ai_1_21.B1 a_4744_19808# 0.02532f
C1577 sg13cmos5l_a21oi_1_4.A2 sg13cmos5l_inv_1_12.A 0.03794f
C1578 a_22506_8436# sg13cmos5l_dlygate4sd3_1_24.A 0.08419f
C1579 sg13cmos5l_inv_1_17.Y sg13cmos5l_inv_1_12.Y 0.03523f
C1580 sg13cmos5l_buf_1_15.A sg13cmos5l_buf_1_14.A 0.04731f
C1581 sg13cmos5l_nor3_1_0.Y sg13cmos5l_a22oi_1_0.B2 0.1355f
C1582 a_4714_14452# a_5157_14495# 0.02241f
C1583 a_19919_7751# a_20586_7972# 0.09257f
C1584 sg13cmos5l_a21oi_1_14.Y sg13cmos5l_inv_1_25.Y 0.22342f
C1585 sg13cmos5l_dfrbpq_1_13.CLK sg13cmos5l_nand2_1_6.A 0.01797f
C1586 sg13cmos5l_a21o_1_2.X a_4454_14922# 0.17778f
C1587 sg13cmos5l_a21oi_1_6.Y a_20580_8440# 0.01955f
C1588 sg13cmos5l_inv_1_18.A sg13cmos5l_o21ai_1_0.A2 0.03747f
C1589 sg13cmos5l_dfrbpq_1_35.D sg13cmos5l_a21oi_1_19.Y 0.43956f
C1590 sg13cmos5l_o21ai_1_26.B1 a_12939_19031# 0.01359f
C1591 a_8118_7742# VDD 0.15928f
C1592 a_20794_3864# VDD 0.26391f
C1593 sg13cmos5l_o21ai_1_0.A1 a_12512_8522# 0.02022f
C1594 sg13cmos5l_nand4_1_17.Y a_18401_16936# 0.04507f
C1595 sg13cmos5l_nand3_1_0.B sg13cmos5l_nor3_1_7.Y 0.11294f
C1596 sg13cmos5l_nor3_1_6.Y sg13cmos5l_inv_1_36.A 0.13004f
C1597 a_5303_18649# a_5258_18416# 0.18486f
C1598 sg13cmos5l_inv_1_1.Y bp0 0.01597f
C1599 a_10500_9952# a_11019_9959# 0.20754f
C1600 a_9928_10034# a_10112_10034# 0.05762f
C1601 sg13cmos5l_buf_1_15.A sg13cmos5l_o21ai_1_14.A1 0.18934f
C1602 a_10917_9959# a_10788_10373# 0.01562f
C1603 a_15754_18481# a_16197_18237# 0.02241f
C1604 sg13cmos5l_buf_1_26.A sg13cmos5l_buf_1_65.A 0.15342f
C1605 sg13cmos5l_inv_1_32.Y sg13cmos5l_dfrbpq_1_41.CLK 0.10247f
C1606 sg13cmos5l_buf_1_63.A busy 0.02687f
C1607 sg13cmos5l_inv_1_1.Y a_20554_12433# 0.01795f
C1608 sg13cmos5l_inv_1_16.A a_17622_10766# 0.01686f
C1609 sg13cmos5l_buf_1_63.A a_12134_19458# 0.01884f
C1610 sg13cmos5l_a21o_1_0.X a_10112_10034# 0.03873f
C1611 sg13cmos5l_a21oi_1_4.A2 sg13cmos5l_nand2_1_13.A 1.05234f
C1612 sg13cmos5l_buf_1_63.A sg13cmos5l_nand4_1_7.B 0.08341f
C1613 a_9464_17549# a_9734_17508# 0.18796f
C1614 sg13cmos5l_a21oi_1_2.Y a_19365_5423# 0.02922f
C1615 sg13cmos5l_a21oi_1_2.A2 sg13cmos5l_buf_1_13.A 0.73805f
C1616 sg13cmos5l_nand4_1_1.B sg13cmos5l_dlygate4sd3_1_76.A 0.02197f
C1617 a_18832_8678# a_19242_8436# 0.07015f
C1618 a_16167_9404# a_16188_9150# 0.20754f
C1619 sg13cmos5l_a21oi_1_25.A2 sg13cmos5l_buf_1_54.A 0.0153f
C1620 a_20225_19960# a_20506_19738# 0.18796f
C1621 sg13cmos5l_nor3_1_2.B a_8321_9376# 0.01631f
C1622 sg13cmos5l_a21oi_1_2.B1 sg13cmos5l_dlygate4sd3_1_29.A 0.20164f
C1623 a_9846_17532# sg13cmos5l_buf_1_65.A 0.01989f
C1624 sg13cmos5l_buf_1_45.X sg13cmos5l_nand3_1_2.A 0.03756f
C1625 sg13cmos5l_o21ai_1_21.Y a_8338_16742# 0.02835f
C1626 sg13cmos5l_dfrbpq_1_11.Q a_19242_8436# 0.07596f
C1627 sg13cmos5l_inv_1_15.A a_20609_15424# 0.01676f
C1628 a_7841_10888# sg13cmos5l_dlygate4sd3_1_38.X 0.02427f
C1629 sg13cmos5l_nand2_1_11.B a_8844_15424# 0.13048f
C1630 sg13cmos5l_inv_1_32.Y a_14052_17933# 0.01553f
C1631 sg13cmos5l_inv_1_15.Y a_17030_8874# 0.01603f
C1632 sg13cmos5l_o21ai_1_6.Y sg13cmos5l_dfrbpq_1_17.Q 0.01385f
C1633 sg13cmos5l_a21oi_1_2.B1 sg13cmos5l_buf_1_13.X 0.65841f
C1634 a_21462_19044# sg13cmos5l_dfrbpq_1_37.D 0.10792f
C1635 a_7446_14508# a_7334_14484# 0.3854f
C1636 sg13cmos5l_buf_1_7.X a_17872_5654# 0.10422f
C1637 sg13cmos5l_o21ai_1_5.A1 sg13cmos5l_nand2_1_12.A 0.12349f
C1638 sg13cmos5l_nor2_1_2.B a_7726_8703# 0.01749f
C1639 sg13cmos5l_inv_1_7.A bp1 0.1691f
C1640 sg13cmos5l_a21oi_1_19.Y a_21080_19061# 0.27393f
C1641 a_15126_19044# code0 0.03441f
C1642 a_14181_17519# a_14929_17869# 0.01058f
C1643 sg13cmos5l_dfrbpq_1_28.RESET_B sg13cmos5l_nand3_1_8.Y 0.04794f
C1644 sg13cmos5l_o21ai_1_10.B1 sg13cmos5l_o21ai_1_12.Y 0.05179f
C1645 a_6490_19738# sg13cmos5l_o21ai_1_20.B1 0.05145f
C1646 sg13cmos5l_nand2_1_1.A sg13cmos5l_inv_1_12.A 0.04429f
C1647 a_7594_9916# a_7620_9952# 0.24169f
C1648 a_20580_14040# a_20997_13701# 0.28324f
C1649 a_20294_13722# a_21099_13844# 0.07916f
C1650 sg13cmos5l_inv_1_17.Y a_19923_13748# 0.01052f
C1651 a_21099_14495# bn7 0.03361f
C1652 sg13cmos5l_o21ai_1_25.B1 a_15041_16936# 0.02121f
C1653 sg13cmos5l_nand2b_1_0.B sg13cmos5l_and2_1_5.X 0.14098f
C1654 sg13cmos5l_buf_1_24.A sg13cmos5l_nor2_1_10.Y 0.0368f
C1655 a_11576_7972# VDD 0.01174f
C1656 sg13cmos5l_o21ai_1_3.Y a_14902_8814# 0.06016f
C1657 sg13cmos5l_buf_1_45.X a_16299_18380# 0.29663f
C1658 a_3782_9948# sg13cmos5l_dlygate4sd3_1_33.X 0.0105f
C1659 a_3208_10034# a_3392_10034# 0.05762f
C1660 sg13cmos5l_dlygate4sd3_1_43.X a_5126_7674# 0.18638f
C1661 a_5386_7897# a_5829_7653# 0.02241f
C1662 sg13cmos5l_nand2b_1_1.A_N sg13cmos5l_a21oi_1_9.A1 0.3355f
C1663 code2 code0 0.27572f
C1664 sg13cmos5l_buf_1_3.A comp_clk 0.1157f
C1665 sg13cmos5l_inv_1_16.A a_21160_12972# 0.19689f
C1666 a_8960_19902# VDD 0.07905f
C1667 a_18662_5850# a_19365_5423# 0.02431f
C1668 sg13cmos5l_o21ai_1_25.Y sg13cmos5l_o21ai_1_25.B1 0.1638f
C1669 sg13cmos5l_a21oi_1_6.Y a_21839_8797# 0.01589f
C1670 sg13cmos5l_o21ai_1_5.A1 sg13cmos5l_dfrbpq_1_13.RESET_B 0.04587f
C1671 sg13cmos5l_nand4_1_18.A sg13cmos5l_dfrbpq_1_28.D 0.02542f
C1672 sg13cmos5l_nor2_1_7.Y a_7858_16742# 0.07457f
C1673 sg13cmos5l_nand3_1_2.Y sg13cmos5l_nand3_1_2.A 0.17986f
C1674 a_18756_17512# a_20015_17869# 0.01412f
C1675 sg13cmos5l_a21oi_1_2.Y a_21089_6352# 0.01234f
C1676 sg13cmos5l_dfrbpq_1_30.Q sg13cmos5l_buf_1_53.A 0.01064f
C1677 sg13cmos5l_nand2b_1_1.A_N sg13cmos5l_a21oi_1_9.Y 0.04092f
C1678 sg13cmos5l_buf_1_47.X valid 0.03237f
C1679 a_22126_4167# VDD 0.15941f
C1680 a_14244_20088# bn2 0.0229f
C1681 sg13cmos5l_nor2_1_3.Y sg13cmos5l_a22oi_1_0.B2 0.12098f
C1682 sg13cmos5l_buf_1_7.X a_20580_8440# 0.29959f
C1683 sg13cmos5l_buf_1_15.A sg13cmos5l_o21ai_1_10.A2 0.02325f
C1684 sg13cmos5l_buf_1_66.X a_4594_17886# 0.05708f
C1685 sg13cmos5l_inv_1_16.A sg13cmos5l_nor3_1_7.Y 0.01645f
C1686 sg13cmos5l_dlygate4sd3_1_65.A sg13cmos5l_buf_8_2.A 0.02097f
C1687 sg13cmos5l_dfrbpq_1_20.D sg13cmos5l_inv_1_29.Y 0.11517f
C1688 sg13cmos5l_buf_1_63.A a_12239_18335# 0.05164f
C1689 sg13cmos5l_o21ai_1_9.A2 a_5660_14040# 0.01039f
C1690 a_13294_16935# a_13409_16936# 0.3854f
C1691 sg13cmos5l_o21ai_1_21.B1 a_3895_18222# 0.02596f
C1692 sg13cmos5l_buf_1_29.A start 0.05774f
C1693 sg13cmos5l_buf_1_63.A a_18352_19990# 0.01188f
C1694 sg13cmos5l_nand3_1_2.Y a_13590_11484# 0.04913f
C1695 sg13cmos5l_buf_1_7.X sg13cmos5l_inv_1_5.A 0.12632f
C1696 sg13cmos5l_o21ai_1_25.Y sg13cmos5l_inv_1_35.Y 0.01725f
C1697 sg13cmos5l_dfrbpq_1_28.RESET_B a_19035_16750# 0.0597f
C1698 sg13cmos5l_o21ai_1_22.Y a_9624_17064# 0.01087f
C1699 sg13cmos5l_nor3_1_2.B sg13cmos5l_o21ai_1_0.A1 0.02872f
C1700 a_14181_17519# bn2 0.02873f
C1701 sg13cmos5l_a21oi_1_25.Y a_15780_18576# 0.03498f
C1702 sg13cmos5l_inv_1_16.Y sg13cmos5l_inv_1_16.A 0.43976f
C1703 sg13cmos5l_buf_1_20.A a_10895_12287# 0.02445f
C1704 sg13cmos5l_buf_1_10.A bp1 0.10598f
C1705 sg13cmos5l_nand4_1_1.A sg13cmos5l_inv_1_12.A 0.02206f
C1706 sg13cmos5l_nand4_1_18.B sg13cmos5l_buf_1_24.A 0.10673f
C1707 sg13cmos5l_o21ai_1_17.B1 sg13cmos5l_nor2_1_10.Y 0.04889f
C1708 sg13cmos5l_a21o_1_1.A2 a_8955_9228# 0.03381f
C1709 sg13cmos5l_dfrbpq_1_24.Q sg13cmos5l_mux2_1_1.X 0.01141f
C1710 sg13cmos5l_nand2b_1_4.Y sg13cmos5l_dlygate4sd3_1_43.A 0.52077f
C1711 a_1192_14484# VDD 0.18157f
C1712 sg13cmos5l_inv_1_11.Y a_15223_7638# 0.01402f
C1713 sg13cmos5l_o21ai_1_23.B1 sg13cmos5l_nor4_1_2.Y 0.77343f
C1714 sg13cmos5l_dfrbpq_1_28.RESET_B a_20794_12936# 0.04595f
C1715 sg13cmos5l_a21oi_1_2.A2 sg13cmos5l_buf_1_5.A 0.08856f
C1716 sg13cmos5l_dfrbpq_1_13.CLK a_18123_11471# 0.0174f
C1717 sg13cmos5l_o21ai_1_18.B1 sg13cmos5l_o21ai_1_15.B1 0.01777f
C1718 sg13cmos5l_nand4_1_15.B sg13cmos5l_a21oi_1_5.A2 0.03585f
C1719 sg13cmos5l_inv_1_13.Y sg13cmos5l_a21oi_1_2.B1 0.0245f
C1720 sg13cmos5l_a21oi_1_4.A1 sg13cmos5l_a21oi_1_4.B1 0.08989f
C1721 a_21761_15424# VDD 0.20424f
C1722 a_10042_6130# clk 0.01293f
C1723 sg13cmos5l_dlygate4sd3_1_38.X a_8139_9959# 0.02445f
C1724 sg13cmos5l_buf_1_26.A bn2 0.02276f
C1725 a_19342_10215# a_19457_10214# 0.3854f
C1726 sg13cmos5l_nand4_1_3.D sg13cmos5l_inv_1_13.Y 0.02953f
C1727 sg13cmos5l_and2_1_5.X a_15872_11546# 0.01752f
C1728 a_15223_7638# a_15783_7892# 0.17382f
C1729 sg13cmos5l_buf_1_24.A code0 0.01549f
C1730 sg13cmos5l_nand2_1_1.A a_19530_11460# 0.08295f
C1731 sg13cmos5l_nand3_1_0.C a_15804_7638# 0.02643f
C1732 sg13cmos5l_a21oi_1_24.Y sg13cmos5l_a21oi_1_24.A2 0.01035f
C1733 a_18660_11016# VDD 0.07272f
C1734 sg13cmos5l_dlygate4sd3_1_82.X sg13cmos5l_a21oi_1_18.B1 0.01123f
C1735 sg13cmos5l_dfrbpq_1_17.Q sg13cmos5l_nand2b_1_4.Y 0.02406f
C1736 sg13cmos5l_dfrbpq_1_24.RESET_B a_4455_18476# 0.32355f
C1737 sg13cmos5l_dlygate4sd3_1_2.A sg13cmos5l_inv_1_6.Y 0.06427f
C1738 sg13cmos5l_inv_1_15.A sg13cmos5l_buf_1_5.A 0.02286f
C1739 a_8037_9959# a_8139_9959# 0.3643f
C1740 sg13cmos5l_inv_1_1.Y a_20494_15423# 0.04554f
C1741 sg13cmos5l_a21oi_1_1.A2 bp7 0.28337f
C1742 a_17240_10702# VDD 0.28666f
C1743 sg13cmos5l_nand3_1_2.A sg13cmos5l_nand3_1_1.Y 0.07999f
C1744 a_15790_7191# VDD 0.1592f
C1745 a_13228_13722# a_13575_13940# 0.03546f
C1746 sg13cmos5l_dfrbpq_1_15.Q a_6766_7191# 0.02018f
C1747 sg13cmos5l_dlygate4sd3_1_9.A VDD 0.33781f
C1748 sg13cmos5l_o21ai_1_25.B1 valid 0.0184f
C1749 sg13cmos5l_dfrbpq_1_15.CLK a_8139_9959# 0.01485f
C1750 sg13cmos5l_dfrbpq_1_15.CLK sg13cmos5l_mux2_1_0.A1 0.21422f
C1751 sg13cmos5l_o21ai_1_20.A1 sg13cmos5l_o21ai_1_14.A1 0.12918f
C1752 sg13cmos5l_nor2_1_7.Y sg13cmos5l_o21ai_1_11.A2 0.04436f
C1753 sg13cmos5l_inv_1_9.Y sg13cmos5l_nand3_1_0.A 0.02687f
C1754 sg13cmos5l_inv_1_36.A sg13cmos5l_dfrbpq_1_24.Q 0.8442f
C1755 sg13cmos5l_inv_1_15.A a_21866_16904# 0.01508f
C1756 sg13cmos5l_nor4_1_2.Y sg13cmos5l_a21oi_1_19.A2 0.03173f
C1757 a_3900_16357# a_4727_16043# 0.26205f
C1758 sg13cmos5l_dfrbpq_1_15.CLK a_5412_7992# 0.06941f
C1759 sg13cmos5l_nand4_1_3.B sg13cmos5l_nand2_1_15.B 0.13937f
C1760 a_15322_16714# code0 0.02509f
C1761 a_9557_11460# VDD 0.1609f
C1762 a_19365_5423# a_19236_5837# 0.01562f
C1763 a_18948_5416# a_19467_5423# 0.20754f
C1764 sg13cmos5l_buf_1_6.A a_19432_3900# 0.01735f
C1765 sg13cmos5l_inv_1_0.Y sg13cmos5l_inv_1_0.A 0.32258f
C1766 a_3319_15960# sg13cmos5l_dlygate4sd3_1_50.A 0.01554f
C1767 a_19275_17519# a_20015_17869# 0.17382f
C1768 sg13cmos5l_a21oi_1_15.A2 sg13cmos5l_a21oi_1_5.A2 0.02843f
C1769 a_6490_16714# VDD 0.26248f
C1770 a_13409_16936# bn0 0.03999f
C1771 a_20488_3176# VDD 0.17954f
C1772 sg13cmos5l_dfrbpq_1_28.RESET_B sg13cmos5l_dlygate4sd3_1_81.X 0.21941f
C1773 sg13cmos5l_a21oi_1_9.A2 a_14938_6888# 0.01526f
C1774 sg13cmos5l_dlygate4sd3_1_64.X a_4952_17549# 0.01253f
C1775 sg13cmos5l_buf_1_7.X a_21839_8797# 0.10879f
C1776 sg13cmos5l_a22oi_1_0.B2 sg13cmos5l_dlygate4sd3_1_8.X 0.12422f
C1777 a_14181_16007# VDD 0.24713f
C1778 sg13cmos5l_o21ai_1_5.A1 a_13478_16434# 0.03701f
C1779 sg13cmos5l_buf_1_63.A a_12145_18335# 0.01644f
C1780 sg13cmos5l_buf_1_43.X a_17608_13760# 0.03978f
C1781 a_18401_16936# VDD 0.21065f
C1782 sg13cmos5l_o21ai_1_21.A2 sg13cmos5l_dfrbpq_1_23.Q 0.01073f
C1783 a_17039_18335# a_17296_18478# 0.23043f
C1784 sg13cmos5l_buf_1_7.X sg13cmos5l_dlygate4sd3_1_29.X 0.09037f
C1785 a_16197_18237# a_16068_18271# 0.01562f
C1786 sg13cmos5l_a21oi_1_27.A1 a_10124_11424# 0.06572f
C1787 sg13cmos5l_buf_1_63.A sg13cmos5l_dfrbpq_1_40.Q 0.2707f
C1788 sg13cmos5l_inv_1_32.Y bn3 0.01702f
C1789 sg13cmos5l_a21oi_1_1.A2 sg13cmos5l_a21oi_1_0.Y 0.27168f
C1790 sg13cmos5l_inv_1_2.A a_21099_8447# 0.04014f
C1791 sg13cmos5l_nand3_1_0.A sg13cmos5l_nor4_1_0.C 0.02831f
C1792 sg13cmos5l_buf_1_16.A a_16840_16878# 0.01711f
C1793 sg13cmos5l_nand2b_1_3.Y sg13cmos5l_a21oi_1_9.B1 0.06283f
C1794 sg13cmos5l_o21ai_1_24.Y a_13690_16714# 0.27703f
C1795 a_6700_6162# VDD 0.14074f
C1796 a_17318_11898# a_17892_11885# 0.18486f
C1797 sg13cmos5l_a21oi_1_2.A2 a_17109_9344# 0.0305f
C1798 sg13cmos5l_a21oi_1_6.A2 sg13cmos5l_inv_1_12.Y 0.04648f
C1799 sg13cmos5l_a21oi_1_10.A2 a_8993_7190# 0.04044f
C1800 sg13cmos5l_nor3_1_6.Y sg13cmos5l_nand4_1_3.B 0.05129f
C1801 sg13cmos5l_o21ai_1_15.Y a_10268_17064# 0.01459f
C1802 sg13cmos5l_dlygate4sd3_1_98.A a_20682_17508# 0.03498f
C1803 sg13cmos5l_nand4_1_8.B busy 0.03001f
C1804 sg13cmos5l_nand3_1_2.Y sg13cmos5l_nand3_1_1.Y 0.04736f
C1805 sg13cmos5l_a21oi_1_1.A2 sg13cmos5l_buf_1_5.A 1.18638f
C1806 a_9885_7194# sg13cmos5l_a21oi_1_10.A1 0.20625f
C1807 sg13cmos5l_o21ai_1_18.B1 sg13cmos5l_o21ai_1_15.Y 0.26327f
C1808 sg13cmos5l_inv_1_15.A sg13cmos5l_inv_1_12.Y 0.67332f
C1809 sg13cmos5l_a21oi_1_6.A2 a_15976_12972# 0.01331f
C1810 a_16167_9404# a_16970_9344# 0.07823f
C1811 sg13cmos5l_buf_1_47.X sg13cmos5l_nor2_1_16.Y 0.21897f
C1812 sg13cmos5l_nand4_1_8.B sg13cmos5l_nand4_1_7.B 0.02286f
C1813 a_8671_7996# sg13cmos5l_dlygate4sd3_1_43.A 0.111f
C1814 sg13cmos5l_mux2_1_0.S a_8200_12342# 0.02549f
C1815 sg13cmos5l_nand2_1_15.B sg13cmos5l_buf_1_21.A 0.06348f
C1816 sg13cmos5l_a21oi_1_2.B1 sg13cmos5l_buf_1_9.A 0.06146f
C1817 a_10906_18984# VDD 0.26232f
C1818 sg13cmos5l_dfrbpq_1_28.RESET_B a_20997_12189# 0.03808f
C1819 sg13cmos5l_inv_1_32.Y sg13cmos5l_nor4_1_2.Y 0.01606f
C1820 sg13cmos5l_nand2_1_3.Y sg13cmos5l_nand2b_1_4.B 0.06686f
C1821 sg13cmos5l_a21oi_1_15.A2 sg13cmos5l_nor3_1_0.Y 0.04755f
C1822 sg13cmos5l_dlygate4sd3_1_38.X sg13cmos5l_or4_1_0.C 0.02563f
C1823 sg13cmos5l_nor4_1_4.C a_11772_14484# 0.01829f
C1824 sg13cmos5l_inv_1_15.Y sg13cmos5l_a21oi_1_25.A2 0.19751f
C1825 sg13cmos5l_nand4_1_8.B sg13cmos5l_nand4_1_3.B 0.04414f
C1826 a_15783_7892# a_16631_8065# 0.07916f
C1827 sg13cmos5l_o21ai_1_13.B1 a_9824_19106# 0.01941f
C1828 sg13cmos5l_nand4_1_1.B sg13cmos5l_a21oi_1_4.A1 0.01782f
C1829 a_11274_20068# code4 0.01314f
C1830 a_19919_10775# VDD 0.17306f
C1831 sg13cmos5l_buf_1_8.A VDD 0.61422f
C1832 sg13cmos5l_inv_1_15.A sg13cmos5l_inv_1_24.A 0.18182f
C1833 a_9136_10190# a_8879_10309# 0.23043f
C1834 sg13cmos5l_a21oi_1_2.B1 a_17412_6928# 0.02085f
C1835 a_13596_13686# a_13486_13722# 0.25046f
C1836 a_14423_14113# a_14378_13880# 0.18486f
C1837 sg13cmos5l_a21oi_1_17.Y sg13cmos5l_inv_1_12.Y 0.0164f
C1838 a_20580_14040# a_21745_13799# 0.25046f
C1839 a_21099_13844# a_20868_13735# 0.07823f
C1840 sg13cmos5l_dfrbpq_1_13.CLK sg13cmos5l_dlygate4sd3_1_13.X 0.01854f
C1841 sg13cmos5l_dfrbpq_1_25.Q sg13cmos5l_o21ai_1_7.Y 0.06112f
C1842 sg13cmos5l_inv_1_8.A sg13cmos5l_inv_1_20.Y 0.06157f
C1843 a_13596_13686# a_14423_14113# 0.26205f
C1844 a_8844_15424# a_8879_15238# 0.19075f
C1845 sg13cmos5l_inv_1_20.Y sg13cmos5l_dlygate4sd3_1_25.A 0.02012f
C1846 sg13cmos5l_a21oi_1_21.A1 sg13cmos5l_a21oi_1_19.Y 0.01089f
C1847 sg13cmos5l_buf_1_66.X sg13cmos5l_nor2_1_7.Y 0.45631f
C1848 sg13cmos5l_o21ai_1_21.A2 sg13cmos5l_dlygate4sd3_1_62.A 0.01949f
C1849 sg13cmos5l_a21oi_1_25.Y valid 0.04061f
C1850 sg13cmos5l_dfrbpq_1_34.Q a_20506_19738# 0.01115f
C1851 sg13cmos5l_buf_1_24.A sg13cmos5l_buf_8_2.A 0.24931f
C1852 a_4932_19024# VDD 0.07272f
C1853 sg13cmos5l_inv_1_7.A a_19432_3900# 0.18019f
C1854 sg13cmos5l_nor3_1_2.A a_5600_8522# 0.02193f
C1855 a_13749_9386# a_13808_9194# 0.01251f
C1856 sg13cmos5l_buf_1_13.X a_17521_5773# 0.01558f
C1857 a_16550_19770# a_17124_19783# 0.18486f
C1858 sg13cmos5l_o21ai_1_0.B1 VDD 0.57061f
C1859 a_5829_7653# a_5931_7796# 0.36168f
C1860 sg13cmos5l_a21oi_1_3.A2 sg13cmos5l_buf_1_10.A 0.21172f
C1861 sg13cmos5l_nor3_1_6.Y sg13cmos5l_buf_1_21.A 0.22482f
C1862 a_19467_5423# a_20207_5773# 0.17382f
C1863 sg13cmos5l_buf_1_15.A sg13cmos5l_nand4_1_1.C 0.01536f
C1864 sg13cmos5l_o21ai_1_17.Y sg13cmos5l_inv_1_25.Y 0.02786f
C1865 sg13cmos5l_o21ai_1_20.B1 a_6785_18448# 0.04794f
C1866 a_11840_9389# VDD 0.29016f
C1867 sg13cmos5l_o21ai_1_3.A2 sg13cmos5l_o21ai_1_3.Y 0.2086f
C1868 sg13cmos5l_dlygate4sd3_1_42.X a_6286_8703# 0.1126f
C1869 a_12614_6166# VDD 0.2123f
C1870 sg13cmos5l_nand2_1_0.B a_13786_7642# 0.01686f
C1871 sg13cmos5l_dfrbpq_1_5.CLK a_21063_16083# 0.06486f
C1872 sg13cmos5l_dfrbpq_1_19.CLK VDD 1.80617f
C1873 sg13cmos5l_dlygate4sd3_1_50.X sg13cmos5l_dfrbpq_1_20.Q 0.05075f
C1874 sg13cmos5l_dfrbpq_1_28.RESET_B sg13cmos5l_nand4_1_1.B 0.03874f
C1875 sg13cmos5l_nand2_1_13.A sg13cmos5l_and2_1_5.X 0.03576f
C1876 sg13cmos5l_a21oi_1_18.B1 sg13cmos5l_nand4_1_6.B 0.03472f
C1877 sg13cmos5l_nor4_1_4.C a_10389_16258# 0.10523f
C1878 sg13cmos5l_nor2_1_7.Y VDD 0.41697f
C1879 a_15610_9912# a_15329_10214# 0.18796f
C1880 sg13cmos5l_inv_1_8.A sg13cmos5l_inv_1_8.Y 0.09103f
C1881 sg13cmos5l_a21oi_1_11.Y VDD 0.33272f
C1882 sg13cmos5l_dlygate4sd3_1_8.X a_14061_8784# 0.01634f
C1883 sg13cmos5l_buf_1_8.A bp6 0.03216f
C1884 a_21185_7864# a_20997_6935# 0.01281f
C1885 sg13cmos5l_a21oi_1_9.A1 VDD 1.58193f
C1886 sg13cmos5l_dfrbpq_1_27.Q a_21839_14845# 0.01492f
C1887 sg13cmos5l_a21oi_1_1.A2 sg13cmos5l_inv_1_12.Y 0.02363f
C1888 sg13cmos5l_nand4_1_8.B sg13cmos5l_buf_1_21.A 0.02374f
C1889 a_15690_15996# VDD 0.27688f
C1890 a_12987_10318# a_12808_10034# 0.01093f
C1891 sg13cmos5l_nor3_1_1.Y VDD 0.21679f
C1892 sg13cmos5l_buf_1_7.X a_18948_7687# 0.02232f
C1893 a_13014_8460# sg13cmos5l_dlygate4sd3_1_8.X 0.10819f
C1894 sg13cmos5l_dfrbpq_1_13.CLK sg13cmos5l_dfrbpq_1_13.RESET_B 0.25521f
C1895 sg13cmos5l_buf_1_26.A sg13cmos5l_o21ai_1_10.A2 0.02594f
C1896 sg13cmos5l_o21ai_1_21.B1 code6 0.12887f
C1897 sg13cmos5l_buf_8_2.A sg13cmos5l_nor2_1_15.Y 0.01639f
C1898 sg13cmos5l_buf_1_59.A code0 0.17383f
C1899 a_15503_19847# a_15760_19990# 0.23043f
C1900 sg13cmos5l_a21oi_1_9.Y VDD 0.31795f
C1901 sg13cmos5l_buf_8_2.A sg13cmos5l_dfrbpq_1_11.D 0.05172f
C1902 sg13cmos5l_nand4_1_5.D sg13cmos5l_inv_1_24.A 0.02302f
C1903 sg13cmos5l_dfrbpq_1_39.Q sg13cmos5l_dfrbpq_1_28.RESET_B 0.05734f
C1904 sg13cmos5l_inv_1_15.A bn0 0.07724f
C1905 a_20503_16710# a_20503_15960# 0.01715f
C1906 a_9322_19993# a_9062_19770# 0.45119f
C1907 a_20513_13238# VDD 0.2054f
C1908 sg13cmos5l_dfrbpq_1_30.Q a_20384_16283# 0.07679f
C1909 sg13cmos5l_a21oi_1_19.Y sg13cmos5l_nand4_1_5.D 0.01585f
C1910 a_20294_12210# VDD 0.52297f
C1911 sg13cmos5l_a21oi_1_21.A1 bn0 0.01863f
C1912 sg13cmos5l_o21ai_1_0.A2 sg13cmos5l_o21ai_1_0.A1 0.40161f
C1913 a_9466_18226# VDD 0.26281f
C1914 sg13cmos5l_nand4_1_1.B bn1 0.01835f
C1915 sg13cmos5l_o21ai_1_17.B1 sg13cmos5l_buf_8_2.A 0.02719f
C1916 a_11558_19020# VDD 0.20755f
C1917 a_6394_17472# VDD 0.26746f
C1918 sg13cmos5l_a21oi_1_3.A2 sg13cmos5l_nand3_1_0.B 0.01913f
C1919 sg13cmos5l_o21ai_1_1.B1 sg13cmos5l_inv_1_11.Y 0.03458f
C1920 sg13cmos5l_buf_1_15.A a_19035_16750# 0.02806f
C1921 a_16954_11424# a_17318_11898# 0.01503f
C1922 sg13cmos5l_inv_1_1.Y sg13cmos5l_dfrbpq_1_6.D 0.02906f
C1923 sg13cmos5l_buf_1_0.A a_18660_7992# 0.01323f
C1924 sg13cmos5l_dfrbpq_1_13.RESET_B a_7841_10888# 0.01051f
C1925 bp8 bp7 0.08198f
C1926 sg13cmos5l_nand2_1_1.A sg13cmos5l_dfrbpq_1_28.Q 0.20675f
C1927 sg13cmos5l_buf_1_20.A sg13cmos5l_mux2_1_0.S 0.04849f
C1928 sg13cmos5l_buf_1_4.A sg13cmos5l_dlygate4sd3_1_2.A 0.14733f
C1929 a_4950_15302# VDD 0.15989f
C1930 sg13cmos5l_buf_1_13.X a_17316_8440# 0.30621f
C1931 a_21215_18528# a_20974_18258# 0.01058f
C1932 a_21063_18476# a_21866_18416# 0.07823f
C1933 a_9546_9948# sg13cmos5l_or4_1_0.C 0.08799f
C1934 sg13cmos5l_nand4_1_15.B sg13cmos5l_nand4_1_18.A 0.23671f
C1935 sg13cmos5l_buf_1_63.A sg13cmos5l_buf_1_47.X 0.54266f
C1936 sg13cmos5l_a21oi_1_2.B1 a_18671_7285# 0.01368f
C1937 a_7736_7678# sg13cmos5l_dlygate4sd3_1_43.A 0.01637f
C1938 sg13cmos5l_o21ai_1_0.A1 a_12631_5376# 0.0392f
C1939 a_8878_7191# a_8993_7190# 0.3854f
C1940 sg13cmos5l_inv_1_17.Y sg13cmos5l_buf_1_10.A 0.02622f
C1941 a_13210_19738# sg13cmos5l_o21ai_1_25.Y 0.27767f
C1942 a_20503_18222# a_20974_18258# 0.16704f
C1943 a_17024_7010# VDD 0.08174f
C1944 sg13cmos5l_inv_1_5.A a_16186_6888# 0.07341f
C1945 a_4127_17016# a_3975_16964# 0.3643f
C1946 sg13cmos5l_inv_1_2.A a_19365_5423# 0.21205f
C1947 sg13cmos5l_o21ai_1_28.Y bn1 0.09895f
C1948 sg13cmos5l_nand3_1_5.Y sg13cmos5l_o21ai_1_8.B1 0.46954f
C1949 sg13cmos5l_o21ai_1_5.A1 sg13cmos5l_nand2_1_9.Y 0.54672f
C1950 a_6858_19020# VDD 0.27882f
C1951 sg13cmos5l_dfrbpq_1_17.Q a_7736_7678# 0.34353f
C1952 sg13cmos5l_buf_1_15.A sg13cmos5l_o21ai_1_15.B1 0.0149f
C1953 a_5412_7992# a_5700_7687# 0.24435f
C1954 sg13cmos5l_nand2b_1_0.B a_14144_7806# 0.03351f
C1955 sg13cmos5l_inv_1_25.Y busy 0.03136f
C1956 sg13cmos5l_inv_1_8.A sg13cmos5l_nand2_1_0.B 0.0498f
C1957 a_4031_15967# a_4727_16043# 0.02453f
C1958 a_12134_19458# sg13cmos5l_inv_1_25.Y 0.01554f
C1959 sg13cmos5l_nand4_1_3.B sg13cmos5l_dfrbpq_1_24.Q 0.45762f
C1960 sg13cmos5l_a21oi_1_20.A2 VDD 0.5172f
C1961 a_21080_17549# a_21350_17508# 0.18796f
C1962 a_10389_16258# a_10448_16362# 0.01251f
C1963 sg13cmos5l_dlygate4sd3_1_76.A a_20580_14040# 0.02857f
C1964 a_3900_16357# a_3879_16083# 0.20773f
C1965 sg13cmos5l_nand2_1_0.B sg13cmos5l_a22oi_1_2.Y 0.05157f
C1966 sg13cmos5l_dfrbpq_1_24.RESET_B sg13cmos5l_dlygate4sd3_1_50.A 0.12757f
C1967 sg13cmos5l_o21ai_1_21.B1 sg13cmos5l_o21ai_1_7.B1 0.0437f
C1968 sg13cmos5l_buf_1_15.A sg13cmos5l_a21oi_1_4.B1 0.03193f
C1969 sg13cmos5l_nor4_1_4.C sg13cmos5l_nor4_1_1.D 0.71191f
C1970 sg13cmos5l_nand4_1_18.A sg13cmos5l_a21oi_1_15.A2 0.02728f
C1971 a_21370_19738# VDD 0.25769f
C1972 sg13cmos5l_buf_8_2.A a_19995_9190# 0.37631f
C1973 sg13cmos5l_dfrbpq_1_28.RESET_B a_18756_19024# 0.27117f
C1974 sg13cmos5l_nand4_1_1.B sg13cmos5l_nor3_1_4.A 0.08502f
C1975 sg13cmos5l_a21oi_1_4.A2 sg13cmos5l_inv_1_8.A 0.03514f
C1976 a_11464_15366# VDD 0.13101f
C1977 sg13cmos5l_o21ai_1_21.A2 sg13cmos5l_o21ai_1_11.Y 0.02092f
C1978 sg13cmos5l_dlygate4sd3_1_74.A VDD 0.38461f
C1979 sg13cmos5l_nand4_1_6.B sg13cmos5l_inv_1_1.A 0.21928f
C1980 sg13cmos5l_nand4_1_15.B sg13cmos5l_a21oi_1_27.A1 0.06038f
C1981 sg13cmos5l_o21ai_1_21.B1 a_4366_18258# 0.01576f
C1982 sg13cmos5l_buf_1_5.A bp8 0.03584f
C1983 sg13cmos5l_nand3b_1_3.C sg13cmos5l_dlygate4sd3_1_62.A 0.02257f
C1984 sg13cmos5l_a21oi_1_4.A2 sg13cmos5l_dlygate4sd3_1_25.A 0.05319f
C1985 a_19120_11702# a_19530_11460# 0.07015f
C1986 sg13cmos5l_nand4_1_3.B a_5782_15230# 0.01471f
C1987 sg13cmos5l_buf_1_10.A a_11648_10830# 0.01821f
C1988 a_19534_4839# a_19649_4840# 0.3854f
C1989 sg13cmos5l_nand3b_1_3.C a_6958_16935# 0.04834f
C1990 sg13cmos5l_a21oi_1_2.A2 sg13cmos5l_buf_1_6.A 0.02053f
C1991 sg13cmos5l_dlygate4sd3_1_18.A sg13cmos5l_a21oi_1_2.A2 0.02216f
C1992 a_22096_12430# VDD 0.13543f
C1993 sg13cmos5l_o21ai_1_26.B1 bn0 0.15716f
C1994 a_18095_19847# VDD 0.16826f
C1995 sg13cmos5l_dfrbpq_1_7.D a_20580_9952# 0.0419f
C1996 sg13cmos5l_dfrbpq_1_28.RESET_B a_21215_17016# 0.03611f
C1997 sg13cmos5l_buf_8_2.A sg13cmos5l_buf_1_59.A 0.02497f
C1998 sg13cmos5l_dfrbpq_1_13.RESET_B a_11759_10309# 0.10905f
C1999 a_6113_17774# VDD 0.20783f
C2000 sg13cmos5l_buf_1_7.X a_20294_10386# 0.01959f
C2001 sg13cmos5l_a21oi_1_6.A2 sg13cmos5l_dlygate4sd3_1_18.A 0.01242f
C2002 a_4744_19808# VDD 0.17862f
C2003 sg13cmos5l_nand4_1_1.A sg13cmos5l_nand4_1_18.C 0.03091f
C2004 sg13cmos5l_buf_1_0.A a_19919_7751# 0.02394f
C2005 sg13cmos5l_nor2_1_16.Y sg13cmos5l_o21ai_1_24.Y 0.02312f
C2006 sg13cmos5l_inv_1_15.A sg13cmos5l_dlygate4sd3_1_18.A 0.01712f
C2007 a_9292_15996# VDD 0.01019f
C2008 sg13cmos5l_inv_1_17.A sg13cmos5l_nand2_1_1.A 0.02158f
C2009 sg13cmos5l_buf_1_65.A sg13cmos5l_mux2_1_1.X 0.11885f
C2010 sg13cmos5l_buf_1_13.X a_18575_8797# 0.10891f
C2011 a_20554_9916# a_20997_9959# 0.02241f
C2012 sg13cmos5l_a21oi_1_4.A1 sg13cmos5l_nand2_1_2.Y 0.13268f
C2013 sg13cmos5l_mux2_1_0.S a_7416_12404# 0.11063f
C2014 sg13cmos5l_inv_1_19.Y sg13cmos5l_dlygate4sd3_1_43.A 0.19796f
C2015 sg13cmos5l_dfrbpq_1_13.RESET_B a_8139_9959# 0.29982f
C2016 sg13cmos5l_o21ai_1_0.A1 a_13102_5850# 0.02171f
C2017 sg13cmos5l_nand2_1_11.B sg13cmos5l_a21oi_1_12.A2 0.1083f
C2018 a_3996_16710# a_4823_17137# 0.26205f
C2019 sg13cmos5l_nand2_1_19.A a_14253_13320# 0.13504f
C2020 sg13cmos5l_dfrbpq_1_33.D sg13cmos5l_inv_1_25.Y 0.34374f
C2021 sg13cmos5l_nand2_1_9.Y sg13cmos5l_o21ai_1_5.A2 0.18326f
C2022 sg13cmos5l_buf_1_13.X sg13cmos5l_nand3_1_0.C 0.03661f
C2023 sg13cmos5l_mux2_1_0.A1 a_7482_12214# 0.02174f
C2024 a_15400_15272# code1 0.1552f
C2025 a_7822_19959# sg13cmos5l_dfrbpq_1_21.D 0.10634f
C2026 sg13cmos5l_dfrbpq_1_13.RESET_B a_5412_7992# 0.33691f
C2027 sg13cmos5l_dfrbpq_1_5.CLK bn4 0.02598f
C2028 sg13cmos5l_dfrbpq_1_29.D VDD 0.20986f
C2029 a_7524_19024# VDD 0.07272f
C2030 sg13cmos5l_a21oi_1_18.B1 bn4 0.01966f
C2031 a_7050_9484# sg13cmos5l_dlygate4sd3_1_42.A 0.02844f
C2032 a_6671_7751# a_6577_7751# 0.16704f
C2033 sg13cmos5l_a21oi_1_4.A2 bp0 0.07276f
C2034 sg13cmos5l_nand2b_1_1.A_N a_14646_10766# 0.01425f
C2035 sg13cmos5l_buf_1_15.A a_9096_15996# 0.05286f
C2036 a_22126_17775# a_22241_17774# 0.3854f
C2037 sg13cmos5l_nand3_1_0.A sg13cmos5l_inv_1_5.A 0.6071f
C2038 sg13cmos5l_dfrbpq_1_28.RESET_B a_20609_15424# 0.01372f
C2039 sg13cmos5l_buf_1_65.A sg13cmos5l_inv_1_36.A 0.05929f
C2040 a_17547_15356# VDD 0.20667f
C2041 sg13cmos5l_nand2_1_0.A sg13cmos5l_dlygate4sd3_1_8.X 0.02328f
C2042 a_14698_6385# VDD 0.0945f
C2043 sg13cmos5l_dlygate4sd3_1_22.A bp2 0.11506f
C2044 sg13cmos5l_nand2_1_19.A sg13cmos5l_a22oi_1_0.B2 0.02152f
C2045 sg13cmos5l_nor2b_1_0.B_N a_12545_9376# 0.01363f
C2046 sg13cmos5l_nand2b_1_0.B a_12957_7194# 0.20047f
C2047 sg13cmos5l_dfrbpq_1_41.CLK a_13764_16000# 0.06694f
C2048 sg13cmos5l_nand3b_1_0.C a_14446_11727# 0.10973f
C2049 sg13cmos5l_dfrbpq_1_28.RESET_B a_19630_15423# 0.06468f
C2050 sg13cmos5l_buf_1_4.A a_20794_3864# 0.01077f
C2051 a_22523_15532# bn7 0.0106f
C2052 sg13cmos5l_dfrbpq_1_5.CLK VDD 1.79436f
C2053 sg13cmos5l_a22oi_1_0.B2 sg13cmos5l_nor2_1_0.Y 0.0325f
C2054 sg13cmos5l_dfrbpq_1_28.RESET_B a_20015_19381# 0.10879f
C2055 sg13cmos5l_a21oi_1_2.A2 sg13cmos5l_inv_1_7.A 0.08342f
C2056 sg13cmos5l_a21oi_1_18.B1 VDD 1.30056f
C2057 sg13cmos5l_nand3_1_8.Y a_22506_14484# 0.04815f
C2058 sg13cmos5l_buf_1_15.A sg13cmos5l_nand4_1_1.B 0.06229f
C2059 a_20294_4650# a_21099_4772# 0.07916f
C2060 a_20580_4968# a_20997_4629# 0.28324f
C2061 sg13cmos5l_a21oi_1_27.B1 sg13cmos5l_o21ai_1_12.Y 0.03173f
C2062 sg13cmos5l_dlygate4sd3_1_82.A VDD 0.17887f
C2063 sg13cmos5l_nand3_1_0.Y sg13cmos5l_inv_1_4.Y 0.03734f
C2064 sg13cmos5l_o21ai_1_20.A1 sg13cmos5l_dfrbpq_1_23.D 0.03137f
C2065 sg13cmos5l_a21oi_1_2.Y sg13cmos5l_buf_1_8.A 0.01193f
C2066 sg13cmos5l_nor3_1_2.C VDD 0.56469f
C2067 sg13cmos5l_buf_8_2.A a_18490_9154# 0.01772f
C2068 sg13cmos5l_inv_1_12.A a_19534_13239# 0.11853f
C2069 a_6470_11898# VDD 0.52782f
C2070 sg13cmos5l_buf_1_63.A sg13cmos5l_a21oi_1_25.Y 0.08605f
C2071 sg13cmos5l_nor3_1_6.Y sg13cmos5l_a21oi_1_5.A2 0.01445f
C2072 sg13cmos5l_o21ai_1_15.B1 sg13cmos5l_o21ai_1_20.A1 0.01024f
C2073 sg13cmos5l_nand4_1_18.B a_9147_13028# 0.05039f
C2074 a_7354_19738# sg13cmos5l_dfrbpq_1_24.RESET_B 0.01169f
C2075 a_6094_19959# VDD 0.15839f
C2076 sg13cmos5l_a21oi_1_27.B1 sg13cmos5l_a21oi_1_27.A1 0.53969f
C2077 a_13738_15964# sg13cmos5l_inv_1_24.Y 0.0103f
C2078 sg13cmos5l_o21ai_1_5.A1 sg13cmos5l_nor4_1_4.C 0.06826f
C2079 sg13cmos5l_buf_1_13.X a_18021_11471# 0.04556f
C2080 sg13cmos5l_nand2_1_11.B sg13cmos5l_dlygate4sd3_1_45.X 0.05076f
C2081 a_21269_9484# VDD 0.20291f
C2082 sg13cmos5l_o21ai_1_23.A2 a_14761_15238# 0.02163f
C2083 sg13cmos5l_nand2_1_1.A a_19649_13238# 0.03688f
C2084 sg13cmos5l_nand2_1_1.A bp0 0.03507f
C2085 sg13cmos5l_a21oi_1_4.A2 sg13cmos5l_nand4_1_16.D 0.1673f
C2086 sg13cmos5l_buf_1_20.A sg13cmos5l_inv_1_24.Y 0.63622f
C2087 sg13cmos5l_dfrbpq_1_13.RESET_B sg13cmos5l_or4_1_0.C 0.18155f
C2088 a_5318_13410# a_5578_12940# 0.45119f
C2089 sg13cmos5l_inv_1_1.Y sg13cmos5l_buf_1_42.A 0.02389f
C2090 sg13cmos5l_nand3b_1_3.C busy 0.02671f
C2091 sg13cmos5l_buf_1_13.X a_15804_7638# 0.01407f
C2092 sg13cmos5l_a22oi_1_1.B2 sg13cmos5l_nand2b_1_4.B 0.27226f
C2093 sg13cmos5l_dfrbpq_1_13.CLK sg13cmos5l_nor3_1_7.Y 1.48962f
C2094 sg13cmos5l_buf_1_8.A sg13cmos5l_inv_1_6.Y 0.01862f
C2095 sg13cmos5l_nand3b_1_3.C sg13cmos5l_nand4_1_7.B 2.15188f
C2096 sg13cmos5l_nand3b_1_3.C sg13cmos5l_o21ai_1_11.Y 0.06798f
C2097 sg13cmos5l_dlygate4sd3_1_50.X a_3319_15960# 0.02579f
C2098 sg13cmos5l_buf_1_1.A VDD 1.08426f
C2099 sg13cmos5l_inv_1_11.Y sg13cmos5l_dlygate4sd3_1_9.A 0.05453f
C2100 a_8783_19381# VDD 0.1702f
C2101 a_13676_19734# sg13cmos5l_o21ai_1_26.B1 0.19314f
C2102 sg13cmos5l_dfrbpq_1_9.D a_17126_7362# 0.16725f
C2103 a_3895_18222# VDD 0.17678f
C2104 a_9765_19749# code5 0.02204f
C2105 sg13cmos5l_nor3_1_6.Y sg13cmos5l_nor3_1_0.Y 0.15309f
C2106 sg13cmos5l_o21ai_1_22.Y a_9464_17549# 0.01439f
C2107 a_15208_11546# VDD 0.13665f
C2108 sg13cmos5l_buf_1_54.A sg13cmos5l_dlygate4sd3_1_81.X 0.01044f
C2109 sg13cmos5l_nand4_1_6.B sg13cmos5l_nand4_1_18.D 0.07076f
C2110 sg13cmos5l_dfrbpq_1_17.Q a_7726_8703# 0.01731f
C2111 sg13cmos5l_a21oi_1_2.A2 sg13cmos5l_buf_1_10.A 0.02604f
C2112 sg13cmos5l_inv_1_16.Y sg13cmos5l_dfrbpq_1_13.CLK 0.01461f
C2113 sg13cmos5l_nand2b_1_1.A_N a_14446_11727# 0.0158f
C2114 sg13cmos5l_dlygate4sd3_1_25.A a_16568_9989# 0.03473f
C2115 a_18544_15454# VDD 0.13638f
C2116 a_15983_6239# VDD 0.1733f
C2117 a_19275_19031# VDD 0.20515f
C2118 a_20294_11898# bn8 0.0691f
C2119 sg13cmos5l_o21ai_1_15.B1 a_9846_17532# 0.03509f
C2120 sg13cmos5l_buf_1_7.X a_20513_4166# 0.01525f
C2121 sg13cmos5l_a21oi_1_6.A2 sg13cmos5l_buf_1_10.A 0.02093f
C2122 sg13cmos5l_dfrbpq_1_23.Q a_3296_16921# 0.08713f
C2123 sg13cmos5l_dlygate4sd3_1_50.X sg13cmos5l_o21ai_1_20.B1 0.01048f
C2124 a_3879_16083# a_4031_15967# 0.36168f
C2125 sg13cmos5l_inv_1_15.A sg13cmos5l_buf_1_10.A 0.02399f
C2126 sg13cmos5l_dfrbpq_1_24.RESET_B sg13cmos5l_o21ai_1_9.A2 0.11829f
C2127 sg13cmos5l_dfrbpq_1_13.RESET_B sg13cmos5l_o21ai_1_1.B1 0.02146f
C2128 sg13cmos5l_inv_1_16.A a_20997_13701# 0.01406f
C2129 sg13cmos5l_buf_1_1.A bp6 0.03285f
C2130 sg13cmos5l_buf_1_13.A a_16070_5850# 0.05524f
C2131 a_21099_4772# a_22096_4870# 0.03412f
C2132 a_20294_4650# a_20868_4663# 0.18486f
C2133 sg13cmos5l_nand4_1_16.D sg13cmos5l_buf_1_57.A 0.02854f
C2134 sg13cmos5l_nand2b_1_1.A_N sg13cmos5l_a21oi_1_9.B1 0.63923f
C2135 VDD bn9 0.48439f
C2136 sg13cmos5l_o21ai_1_15.Y sg13cmos5l_o21ai_1_20.A1 0.01246f
C2137 sg13cmos5l_inv_1_18.Y sg13cmos5l_a22oi_1_2.Y 0.87071f
C2138 sg13cmos5l_nand4_1_1.A bp0 0.10357f
C2139 sg13cmos5l_buf_1_7.X a_20580_6928# 0.28987f
C2140 sg13cmos5l_dlygate4sd3_1_4.A a_21152_3986# 0.03955f
C2141 sg13cmos5l_nand4_1_18.B sg13cmos5l_nand4_1_17.Y 0.04294f
C2142 sg13cmos5l_nand3_1_2.Y sg13cmos5l_and2_1_6.A 0.1399f
C2143 sg13cmos5l_inv_1_1.A VDD 0.98859f
C2144 sg13cmos5l_o21ai_1_0.A2 a_12902_8436# 0.03975f
C2145 sg13cmos5l_buf_8_2.A a_21099_9959# 0.01139f
C2146 sg13cmos5l_o21ai_1_9.Y VDD 0.29127f
C2147 sg13cmos5l_nand3b_1_3.C sg13cmos5l_buf_1_21.A 0.1389f
C2148 sg13cmos5l_a21oi_1_27.B1 sg13cmos5l_dfrbpq_1_24.RESET_B 0.08116f
C2149 sg13cmos5l_inv_1_31.A sg13cmos5l_dfrbpq_1_37.D 0.07924f
C2150 sg13cmos5l_nand3_1_0.B sg13cmos5l_a21oi_1_2.A2 0.05492f
C2151 sg13cmos5l_dlygate4sd3_1_74.A a_19930_15960# 0.02409f
C2152 sg13cmos5l_o21ai_1_5.A2 sg13cmos5l_nor4_1_4.C 0.16439f
C2153 sg13cmos5l_buf_1_13.X sg13cmos5l_dfrbpq_1_7.D 0.12574f
C2154 a_12812_15960# VDD 0.18237f
C2155 a_19077_7653# a_18671_7285# 0.0215f
C2156 sg13cmos5l_buf_1_13.X a_18863_11821# 0.11197f
C2157 a_6682_8400# VDD 0.27288f
C2158 sg13cmos5l_inv_1_13.Y a_18021_11471# 0.042f
C2159 sg13cmos5l_dlygate4sd3_1_50.X sg13cmos5l_o21ai_1_12.Y 0.13355f
C2160 sg13cmos5l_dfrbpq_1_35.Q bn4 0.01154f
C2161 sg13cmos5l_a21oi_1_6.A2 sg13cmos5l_nand3_1_0.B 0.1644f
C2162 sg13cmos5l_inv_1_15.Y sg13cmos5l_nand3_1_8.Y 0.02425f
C2163 sg13cmos5l_buf_1_9.A sg13cmos5l_nand3_1_0.C 0.0209f
C2164 sg13cmos5l_buf_1_13.X a_20580_9952# 0.28277f
C2165 a_10461_11730# clk 0.01222f
C2166 sg13cmos5l_nand3b_1_3.C a_6968_17549# 0.30384f
C2167 sg13cmos5l_inv_1_1.Y sg13cmos5l_inv_1_4.Y 0.02426f
C2168 sg13cmos5l_dfrbpq_1_28.RESET_B a_20580_14040# 0.29468f
C2169 sg13cmos5l_a21oi_1_12.Y a_7378_16374# 0.05494f
C2170 sg13cmos5l_a21oi_1_4.A1 sg13cmos5l_inv_1_24.A 0.01979f
C2171 bp6 bn9 0.02668f
C2172 bp1 bp5 0.18153f
C2173 bp2 bp3 0.07106f
C2174 sg13cmos5l_and4_1_1.A a_9446_13726# 0.0386f
C2175 a_4823_17137# a_4778_16904# 0.18486f
C2176 sg13cmos5l_inv_1_15.Y sg13cmos5l_nand4_1_1.C 0.03102f
C2177 sg13cmos5l_buf_8_2.A sg13cmos5l_nand3b_1_0.C 0.01399f
C2178 sg13cmos5l_buf_1_65.A sg13cmos5l_mux2_1_1.A0 0.02329f
C2179 a_8411_12252# a_8734_12214# 0.28837f
C2180 a_5303_18649# VDD 0.52442f
C2181 a_7937_19960# a_8218_19738# 0.18796f
C2182 sg13cmos5l_or4_1_0.C a_8520_8436# 0.1094f
C2183 sg13cmos5l_buf_1_54.A sg13cmos5l_nand4_1_1.B 0.07162f
C2184 sg13cmos5l_a21oi_1_1.A2 sg13cmos5l_buf_1_10.A 0.02018f
C2185 a_20794_3864# a_21256_3900# 0.02045f
C2186 sg13cmos5l_a21oi_1_4.A1 sg13cmos5l_nor2b_1_0.B_N 0.01631f
C2187 sg13cmos5l_buf_1_2.A VDD 0.67515f
C2188 sg13cmos5l_inv_1_1.A bp6 0.02213f
C2189 a_19642_6130# VDD 0.26245f
C2190 sg13cmos5l_o21ai_1_15.Y a_9846_17532# 0.03392f
C2191 sg13cmos5l_inv_1_31.A sg13cmos5l_a21oi_1_25.Y 2.15358f
C2192 a_7507_9380# sg13cmos5l_or4_1_0.D 0.03063f
C2193 sg13cmos5l_dlygate4sd3_1_77.A VDD 0.26127f
C2194 sg13cmos5l_nand3_1_2.Y clk 0.03048f
C2195 sg13cmos5l_buf_1_63.A a_13210_19738# 0.01457f
C2196 sg13cmos5l_a21oi_1_12.A2 a_8879_15238# 0.01112f
C2197 sg13cmos5l_a21oi_1_17.Y sg13cmos5l_nand3_1_0.B 0.13127f
C2198 sg13cmos5l_dfrbpq_1_35.Q VDD 0.32151f
C2199 sg13cmos5l_dfrbpq_1_41.CLK sg13cmos5l_nand4_1_16.D 0.01396f
C2200 a_20580_4968# bp8 0.01435f
C2201 a_14646_10766# VDD 0.15741f
C2202 sg13cmos5l_a21oi_1_18.B1 a_16064_17594# 0.02106f
C2203 sg13cmos5l_nand4_1_15.B sg13cmos5l_nand2_1_19.A 0.01577f
C2204 sg13cmos5l_buf_1_4.A a_20488_3176# 0.18811f
C2205 sg13cmos5l_buf_1_65.A sg13cmos5l_nand4_1_3.B 0.1002f
C2206 sg13cmos5l_buf_1_57.A a_17445_15213# 0.01148f
C2207 sg13cmos5l_nand2b_1_1.A_N sg13cmos5l_a21oi_1_10.A2 0.20574f
C2208 sg13cmos5l_o21ai_1_21.Y a_4127_17016# 0.03533f
C2209 sg13cmos5l_inv_1_32.Y a_13400_15238# 0.01045f
C2210 sg13cmos5l_dfrbpq_1_28.RESET_B sg13cmos5l_inv_1_24.A 0.18967f
C2211 sg13cmos5l_buf_1_63.A sg13cmos5l_dfrbpq_1_24.RESET_B 0.02495f
C2212 sg13cmos5l_buf_1_13.A a_16875_5423# 0.04285f
C2213 sg13cmos5l_dfrbpq_1_28.RESET_B sg13cmos5l_a21oi_1_19.Y 0.03777f
C2214 sg13cmos5l_o21ai_1_23.B1 sg13cmos5l_o21ai_1_23.A2 0.23102f
C2215 a_22005_16904# VDD 0.09435f
C2216 sg13cmos5l_buf_1_15.A sg13cmos5l_buf_1_13.A 0.01648f
C2217 a_16836_20088# valid 0.02911f
C2218 sg13cmos5l_buf_1_26.A sg13cmos5l_nand4_1_1.B 0.06571f
C2219 sg13cmos5l_buf_1_47.X sg13cmos5l_inv_1_25.Y 0.09294f
C2220 a_9062_5850# a_9867_5423# 0.07916f
C2221 a_9348_5416# a_9765_5423# 0.28418f
C2222 sg13cmos5l_nand2_1_0.B a_14264_10702# 0.28614f
C2223 sg13cmos5l_buf_1_2.A bp6 0.02624f
C2224 sg13cmos5l_nor4_1_2.Y a_13764_16000# 0.02046f
C2225 a_1409_9376# a_1690_9154# 0.18796f
C2226 sg13cmos5l_buf_1_7.X a_21099_6935# 0.27973f
C2227 sg13cmos5l_buf_1_9.A sg13cmos5l_dlygate4sd3_1_28.A 0.0322f
C2228 sg13cmos5l_inv_1_18.A a_12987_10318# 0.02233f
C2229 a_15754_18481# VDD 0.09642f
C2230 sg13cmos5l_nor2_1_7.Y sg13cmos5l_o21ai_1_8.B1 0.02555f
C2231 a_21934_10887# a_22049_10888# 0.3854f
C2232 sg13cmos5l_nand2_1_15.B a_14517_13880# 0.01046f
C2233 sg13cmos5l_a21oi_1_4.A1 bn0 0.02523f
C2234 a_6835_13916# VDD 0.25548f
C2235 a_20554_6892# a_20580_6928# 0.24169f
C2236 sg13cmos5l_buf_1_0.A bp9 0.04348f
C2237 sg13cmos5l_o21ai_1_14.Y sg13cmos5l_o21ai_1_20.A1 0.03781f
C2238 a_15014_19020# VDD 0.20748f
C2239 sg13cmos5l_nand3b_1_0.C sg13cmos5l_nor3_1_2.B 0.0418f
C2240 sg13cmos5l_inv_1_16.A sg13cmos5l_a21oi_1_2.A2 0.33079f
C2241 sg13cmos5l_nor3_1_7.Y a_16215_11460# 0.02677f
C2242 sg13cmos5l_nor3_1_6.Y sg13cmos5l_nand4_1_18.A 0.41411f
C2243 sg13cmos5l_o21ai_1_7.B1 sg13cmos5l_o21ai_1_11.A2 0.01127f
C2244 sg13cmos5l_buf_1_20.A sg13cmos5l_nand2_1_18.A 0.04691f
C2245 sg13cmos5l_a21oi_1_21.A1 a_17253_19749# 0.01138f
C2246 sg13cmos5l_a21oi_1_12.Y sg13cmos5l_nor4_1_1.D 0.07183f
C2247 sg13cmos5l_o21ai_1_0.A2 sg13cmos5l_or2_1_1.X 0.30447f
C2248 sg13cmos5l_inv_1_16.A sg13cmos5l_a21oi_1_6.A2 0.01852f
C2249 a_5604_12976# a_6769_13333# 0.25046f
C2250 sg13cmos5l_buf_1_8.A sg13cmos5l_buf_1_4.A 0.04237f
C2251 sg13cmos5l_nor3_1_2.B a_10330_9154# 0.01279f
C2252 sg13cmos5l_buf_8_2.A sg13cmos5l_nand4_1_6.B 0.02591f
C2253 sg13cmos5l_inv_1_15.A sg13cmos5l_inv_1_16.A 0.21558f
C2254 sg13cmos5l_inv_1_3.Y sg13cmos5l_buf_1_8.A 0.02778f
C2255 a_6094_16935# a_5800_16878# 0.01555f
C2256 sg13cmos5l_dfrbpq_1_20.Q sg13cmos5l_nand3b_1_3.C 0.063f
C2257 a_14136_17064# VDD 0.01784f
C2258 sg13cmos5l_a21oi_1_10.A1 clk 0.15033f
C2259 sg13cmos5l_a21oi_1_0.A2 a_18948_5416# 0.02061f
C2260 a_8734_12214# sg13cmos5l_mux2_1_1.X 0.14366f
C2261 VDD code6 0.30324f
C2262 sg13cmos5l_a21o_1_1.A2 a_8602_9154# 0.02076f
C2263 sg13cmos5l_buf_8_2.A sg13cmos5l_nand4_1_17.Y 0.05007f
C2264 sg13cmos5l_dfrbpq_1_24.Q a_7736_13726# 0.28854f
C2265 sg13cmos5l_buf_1_13.A sg13cmos5l_buf_1_3.A 0.01184f
C2266 a_20513_4166# bp4 0.03749f
C2267 sg13cmos5l_dlygate4sd3_1_50.X sg13cmos5l_dfrbpq_1_24.RESET_B 0.07981f
C2268 sg13cmos5l_nor2_1_10.Y VDD 0.40845f
C2269 sg13cmos5l_a21oi_1_2.B1 sg13cmos5l_dfrbpq_1_11.D 0.29176f
C2270 sg13cmos5l_nand2_1_3.Y a_7520_7010# 0.02559f
C2271 a_6682_15960# sg13cmos5l_o21ai_1_11.A2 0.04586f
C2272 sg13cmos5l_inv_1_15.A a_22005_16043# 0.01384f
C2273 a_16188_9150# VDD 0.0721f
C2274 sg13cmos5l_buf_1_13.A a_16319_9456# 0.04315f
C2275 sg13cmos5l_dfrbpq_1_41.CLK a_17445_15213# 0.19983f
C2276 sg13cmos5l_inv_1_14.Y a_18948_5416# 0.01841f
C2277 sg13cmos5l_o21ai_1_25.B1 sg13cmos5l_inv_1_25.Y 0.0289f
C2278 sg13cmos5l_inv_1_7.A bp8 0.01569f
C2279 sg13cmos5l_o21ai_1_7.A2 sg13cmos5l_a21oi_1_24.A1 0.02628f
C2280 sg13cmos5l_mux2_1_0.A1 a_7310_12400# 0.32691f
C2281 sg13cmos5l_inv_1_5.A a_16240_6382# 0.01468f
C2282 a_21350_19020# VDD 0.20749f
C2283 sg13cmos5l_buf_1_47.X a_11770_17472# 0.0135f
C2284 sg13cmos5l_o21ai_1_22.Y sg13cmos5l_nand3b_1_1.C 0.01353f
C2285 sg13cmos5l_nand4_1_18.D VDD 1.24953f
C2286 sg13cmos5l_inv_1_15.Y sg13cmos5l_dlygate4sd3_1_81.X 0.02801f
C2287 sg13cmos5l_nand2_1_0.A sg13cmos5l_nor2_1_0.Y 0.10141f
C2288 a_20580_6928# bp4 0.01856f
C2289 sg13cmos5l_nor3_1_6.Y sg13cmos5l_a21oi_1_27.A1 0.23414f
C2290 a_13420_9484# sg13cmos5l_a22oi_1_0.A2 0.01423f
C2291 a_14446_11727# VDD 0.15907f
C2292 sg13cmos5l_nand4_1_18.B sg13cmos5l_buf_1_66.X 0.13735f
C2293 a_10607_19847# sg13cmos5l_dlygate4sd3_1_54.A 0.01364f
C2294 sg13cmos5l_nand4_1_12.Y a_17710_17775# 0.05533f
C2295 a_3200_16283# VDD 0.28997f
C2296 bn4 code0 0.02156f
C2297 bn1 bn0 0.11219f
C2298 bn2 busy 0.06706f
C2299 a_9348_5416# a_10513_5773# 0.25046f
C2300 sg13cmos5l_nand4_1_1.B a_10245_14020# 0.02331f
C2301 sg13cmos5l_nand4_1_7.B bn2 0.01535f
C2302 sg13cmos5l_inv_1_32.Y sg13cmos5l_o21ai_1_23.A2 0.0235f
C2303 sg13cmos5l_dfrbpq_1_34.Q a_17355_19892# 0.02791f
C2304 a_9640_7010# VDD 0.13612f
C2305 sg13cmos5l_nand2b_1_1.A_N sg13cmos5l_nor3_1_2.B 0.23037f
C2306 sg13cmos5l_inv_1_24.A sg13cmos5l_nor3_1_4.A 0.02355f
C2307 sg13cmos5l_buf_1_10.A sg13cmos5l_a22oi_1_0.A2 0.01444f
C2308 sg13cmos5l_inv_1_16.A sg13cmos5l_a21oi_1_1.A2 0.25514f
C2309 sg13cmos5l_and2_1_3.X sg13cmos5l_nor3_1_0.Y 0.02825f
C2310 a_8006_13726# VDD 0.21f
C2311 a_20580_6928# a_20868_7349# 0.24435f
C2312 sg13cmos5l_nand2_1_19.Y sg13cmos5l_a22oi_1_0.B2 0.02464f
C2313 a_3296_19902# code8 0.01246f
C2314 sg13cmos5l_buf_1_10.A a_12545_9376# 0.01336f
C2315 sg13cmos5l_inv_1_32.Y a_13679_19381# 0.02141f
C2316 sg13cmos5l_buf_1_43.X sg13cmos5l_dlygate4sd3_1_13.A 0.01507f
C2317 sg13cmos5l_buf_1_1.A sg13cmos5l_a21oi_1_2.Y 0.15554f
C2318 sg13cmos5l_nand4_1_18.B VDD 1.55285f
C2319 sg13cmos5l_a21oi_1_9.B1 VDD 0.76182f
C2320 sg13cmos5l_buf_1_9.A sg13cmos5l_dfrbpq_1_7.D 0.15871f
C2321 sg13cmos5l_o21ai_1_7.B1 sg13cmos5l_buf_1_66.X 0.65269f
C2322 sg13cmos5l_nand2b_1_1.A_N a_8878_7191# 0.04523f
C2323 sg13cmos5l_nand3b_1_1.C sg13cmos5l_nand2_1_9.Y 0.01384f
C2324 a_20110_19959# VDD 0.15833f
C2325 sg13cmos5l_dlygate4sd3_1_29.A a_19733_6924# 0.1077f
C2326 sg13cmos5l_dfrbpq_1_37.D sg13cmos5l_inv_1_25.Y 0.05644f
C2327 sg13cmos5l_inv_1_12.A sg13cmos5l_a21oi_1_0.A2 0.05372f
C2328 sg13cmos5l_nand3_1_5.Y a_4952_17549# 0.01765f
C2329 sg13cmos5l_buf_1_7.X a_20586_10996# 0.06017f
C2330 sg13cmos5l_o21ai_1_18.B1 sg13cmos5l_nor2b_1_1.A 0.01035f
C2331 a_21099_9959# a_21839_10309# 0.17382f
C2332 sg13cmos5l_dlygate4sd3_1_1.A bp7 0.01922f
C2333 a_6863_13333# a_6769_13333# 0.16704f
C2334 sg13cmos5l_buf_8_2.A sg13cmos5l_o21ai_1_11.A2 0.01178f
C2335 VDD code0 0.41723f
C2336 sg13cmos5l_a21oi_1_5.A2 sg13cmos5l_inv_1_5.A 0.03043f
C2337 sg13cmos5l_buf_1_9.A a_20580_9952# 0.01807f
C2338 sg13cmos5l_buf_1_7.X a_17126_7362# 0.08545f
C2339 sg13cmos5l_buf_1_10.A bp8 0.13478f
C2340 sg13cmos5l_a21oi_1_24.A1 sg13cmos5l_a21oi_1_24.Y 0.15162f
C2341 sg13cmos5l_inv_1_2.A sg13cmos5l_buf_1_8.A 0.02285f
C2342 sg13cmos5l_o21ai_1_7.B1 VDD 0.62915f
C2343 sg13cmos5l_inv_1_9.Y a_17429_12508# 0.0273f
C2344 a_22522_3106# bp9 0.0191f
C2345 a_22522_3864# a_22241_4166# 0.18796f
C2346 sg13cmos5l_nand2_1_1.A sg13cmos5l_dlygate4sd3_1_76.X 0.05199f
C2347 sg13cmos5l_and4_1_1.A a_10833_14874# 0.14507f
C2348 sg13cmos5l_nand4_1_15.B a_9716_15202# 0.02181f
C2349 sg13cmos5l_buf_1_1.A sg13cmos5l_inv_1_6.Y 0.01899f
C2350 sg13cmos5l_nand2b_1_1.A_N a_14548_12236# 0.01663f
C2351 sg13cmos5l_nand2b_1_4.Y sg13cmos5l_nand2b_1_4.B 0.24827f
C2352 a_12792_17064# VDD 0.01784f
C2353 sg13cmos5l_dfrbpq_1_13.RESET_B a_6700_6162# 0.0963f
C2354 sg13cmos5l_nand2_1_12.Y a_12058_16750# 0.01602f
C2355 sg13cmos5l_buf_1_16.A a_18188_4614# 0.18943f
C2356 sg13cmos5l_dlygate4sd3_1_64.X sg13cmos5l_o21ai_1_20.Y 0.02346f
C2357 sg13cmos5l_nand4_1_3.B a_12381_13912# 0.01138f
C2358 sg13cmos5l_a21oi_1_26.A1 a_16283_17508# 0.02731f
C2359 sg13cmos5l_a21oi_1_2.Y bn9 0.03945f
C2360 sg13cmos5l_a21oi_1_25.Y sg13cmos5l_inv_1_25.Y 0.44961f
C2361 sg13cmos5l_inv_1_5.A a_15889_6239# 0.02329f
C2362 sg13cmos5l_dfrbpq_1_13.CLK sg13cmos5l_a21oi_1_3.A2 0.01513f
C2363 sg13cmos5l_buf_1_13.A sg13cmos5l_dfrbpq_1_9.D 0.54466f
C2364 sg13cmos5l_inv_1_15.Y sg13cmos5l_nand4_1_1.B 0.02205f
C2365 sg13cmos5l_inv_1_8.A sg13cmos5l_dlygate4sd3_1_7.X 0.02478f
C2366 sg13cmos5l_dfrbpq_1_24.RESET_B sg13cmos5l_nor3_1_6.Y 0.10734f
C2367 a_6682_15960# VDD 0.27027f
C2368 sg13cmos5l_buf_1_13.A sg13cmos5l_a21oi_1_3.Y 0.0133f
C2369 sg13cmos5l_dfrbpq_1_15.CLK sg13cmos5l_nor3_1_2.C 0.24785f
C2370 a_14423_14113# VDD 0.524f
C2371 a_21099_6935# bp4 0.01853f
C2372 sg13cmos5l_inv_1_1.A sg13cmos5l_a21oi_1_2.Y 0.0151f
C2373 sg13cmos5l_dfrbpq_1_15.CLK a_6470_11898# 0.07811f
C2374 sg13cmos5l_nand3_1_2.A sg13cmos5l_nand2_1_0.B 0.04789f
C2375 sg13cmos5l_a21oi_1_0.Y sg13cmos5l_dlygate4sd3_1_1.A 0.12988f
C2376 sg13cmos5l_a21oi_1_26.Y a_16283_17508# 0.10035f
C2377 sg13cmos5l_inv_1_32.Y sg13cmos5l_buf_1_25.A 0.01685f
C2378 sg13cmos5l_dfrbpq_1_28.Q sg13cmos5l_dlygate4sd3_1_71.X 0.02912f
C2379 sg13cmos5l_buf_1_22.A a_11072_13058# 0.01436f
C2380 sg13cmos5l_inv_1_20.Y sg13cmos5l_nand3_1_1.Y 0.10432f
C2381 a_12826_9154# sg13cmos5l_nor2_1_0.Y 0.27505f
C2382 sg13cmos5l_nand4_1_17.Y sg13cmos5l_buf_1_16.A 0.15604f
C2383 sg13cmos5l_o21ai_1_4.Y a_14938_6888# 0.29207f
C2384 a_9062_5850# clk 0.05371f
C2385 a_12512_8522# VDD 0.07862f
C2386 sg13cmos5l_buf_8_2.A a_21745_11821# 0.01566f
C2387 sg13cmos5l_buf_1_5.A sg13cmos5l_dlygate4sd3_1_1.A 0.01754f
C2388 sg13cmos5l_dfrbpq_1_39.Q a_21063_18476# 0.01336f
C2389 sg13cmos5l_a21oi_1_10.A2 VDD 0.38089f
C2390 sg13cmos5l_buf_1_15.A sg13cmos5l_inv_1_24.A 0.02359f
C2391 a_19054_18447# sg13cmos5l_nand4_1_17.Y 0.01162f
C2392 sg13cmos5l_dlygate4sd3_1_82.X a_16550_19770# 0.17726f
C2393 a_16810_19993# a_16836_20088# 0.24169f
C2394 a_5098_9409# a_4838_9186# 0.45119f
C2395 a_9558_13790# VDD 0.16244f
C2396 sg13cmos5l_inv_1_6.Y bn9 0.02866f
C2397 sg13cmos5l_buf_1_15.A sg13cmos5l_a21oi_1_19.Y 0.01644f
C2398 a_20868_7349# a_21099_6935# 0.07823f
C2399 sg13cmos5l_buf_1_21.A sg13cmos5l_buf_1_14.A 0.01797f
C2400 sg13cmos5l_a21o_1_2.B1 a_7805_15532# 0.02779f
C2401 sg13cmos5l_buf_8_2.A bn4 0.06203f
C2402 sg13cmos5l_a21oi_1_4.A2 sg13cmos5l_nand3_1_2.A 0.07254f
C2403 sg13cmos5l_buf_1_45.X sg13cmos5l_a21oi_1_4.A2 0.27354f
C2404 sg13cmos5l_buf_1_15.A sg13cmos5l_nor2b_1_0.B_N 0.05783f
C2405 sg13cmos5l_inv_1_1.A sg13cmos5l_inv_1_6.Y 1.09145f
C2406 sg13cmos5l_inv_1_16.A sg13cmos5l_dlygate4sd3_1_76.A 0.32851f
C2407 sg13cmos5l_a21oi_1_27.A1 a_9924_12223# 0.01252f
C2408 sg13cmos5l_dlygate4sd3_1_2.A bp1 0.08409f
C2409 sg13cmos5l_a21oi_1_2.Y sg13cmos5l_buf_1_2.A 0.01172f
C2410 sg13cmos5l_a21oi_1_5.A2 sg13cmos5l_dlygate4sd3_1_29.X 0.12905f
C2411 sg13cmos5l_buf_8_2.A sg13cmos5l_buf_1_66.X 0.07718f
C2412 sg13cmos5l_dfrbpq_1_21.D VDD 0.22838f
C2413 sg13cmos5l_buf_1_66.X sg13cmos5l_a21o_1_2.B1 0.02161f
C2414 sg13cmos5l_buf_1_43.X sg13cmos5l_nand2_1_15.Y 0.05912f
C2415 sg13cmos5l_buf_1_7.X a_17700_7349# 0.02278f
C2416 sg13cmos5l_a21oi_1_26.A2 code1 0.07671f
C2417 a_6490_16714# sg13cmos5l_o21ai_1_11.B1 0.04907f
C2418 sg13cmos5l_dfrbpq_1_13.RESET_B sg13cmos5l_a21oi_1_9.A1 0.01546f
C2419 sg13cmos5l_nand4_1_15.B sg13cmos5l_dfrbpq_1_18.Q 0.02343f
C2420 a_10508_10662# a_10304_10830# 0.01689f
C2421 sg13cmos5l_dfrbpq_1_24.Q sg13cmos5l_a21oi_1_27.A1 0.33508f
C2422 sg13cmos5l_nand3_1_2.Y sg13cmos5l_nand2_1_0.B 0.02023f
C2423 sg13cmos5l_o21ai_1_12.Y a_5782_15230# 0.06752f
C2424 sg13cmos5l_buf_1_63.A a_16836_20088# 0.01751f
C2425 sg13cmos5l_a21oi_1_13.A2 VDD 0.5989f
C2426 sg13cmos5l_inv_1_13.Y sg13cmos5l_buf_1_13.X 0.1212f
C2427 sg13cmos5l_buf_8_2.A VDD 4.95419f
C2428 a_20554_4873# VDD 0.0959f
C2429 a_19077_10677# a_19179_10820# 0.36168f
C2430 a_19160_9190# VDD 0.28424f
C2431 sg13cmos5l_o21ai_1_11.Y sg13cmos5l_o21ai_1_10.A2 0.02537f
C2432 a_16319_9456# a_17109_9344# 0.02241f
C2433 a_7904_5498# VDD 0.08224f
C2434 sg13cmos5l_nand4_1_15.B sg13cmos5l_buf_1_43.X 1.1789f
C2435 sg13cmos5l_buf_1_13.X sg13cmos5l_dlygate4sd3_1_18.X 0.07081f
C2436 sg13cmos5l_a21o_1_2.B1 VDD 0.56958f
C2437 sg13cmos5l_dfrbpq_1_13.RESET_B sg13cmos5l_a21oi_1_9.Y 0.06395f
C2438 a_19534_4839# VDD 0.15746f
C2439 a_18634_10921# a_18374_10698# 0.45119f
C2440 sg13cmos5l_buf_1_2.A sg13cmos5l_inv_1_6.Y 0.01915f
C2441 a_13478_16434# a_14181_16007# 0.02431f
C2442 a_7416_12404# a_8200_12342# 0.0213f
C2443 sg13cmos5l_mux2_1_1.A0 a_8734_12214# 0.08108f
C2444 sg13cmos5l_a21oi_1_12.Y sg13cmos5l_o21ai_1_5.A2 1.57801f
C2445 sg13cmos5l_nor3_1_2.A a_7841_8702# 0.01473f
C2446 sg13cmos5l_mux2_1_0.A1 sg13cmos5l_dfrbpq_1_24.D 0.05319f
C2447 sg13cmos5l_buf_1_13.A a_15935_7944# 0.03804f
C2448 sg13cmos5l_o21ai_1_5.A2 a_13575_13940# 0.01196f
C2449 sg13cmos5l_dlygate4sd3_1_20.A bp2 0.02956f
C2450 sg13cmos5l_buf_1_45.X sg13cmos5l_buf_1_57.A 0.37465f
C2451 sg13cmos5l_inv_1_0.A bp9 0.01086f
C2452 sg13cmos5l_inv_1_4.Y a_16356_5416# 0.03616f
C2453 sg13cmos5l_dlygate4sd3_1_3.A a_22522_3864# 0.27487f
C2454 a_7199_6432# a_7850_6320# 0.01562f
C2455 sg13cmos5l_buf_1_45.X a_13478_17946# 0.09084f
C2456 sg13cmos5l_dfrbpq_1_15.CLK a_7044_11885# 0.01285f
C2457 sg13cmos5l_and2_1_5.X a_15405_11808# 0.0747f
C2458 a_12929_19960# VDD 0.22739f
C2459 a_16838_9948# sg13cmos5l_buf_1_13.A 0.01342f
C2460 sg13cmos5l_buf_1_5.A a_18874_9912# 0.0683f
C2461 sg13cmos5l_a21oi_1_27.B1 a_9716_15202# 0.02706f
C2462 sg13cmos5l_o21ai_1_19.B1 sg13cmos5l_nand3b_1_1.C 0.05875f
C2463 sg13cmos5l_nand2b_1_1.A_N a_14446_9375# 0.04433f
C2464 sg13cmos5l_dfrbpq_1_15.CLK sg13cmos5l_o21ai_1_9.Y 0.028f
C2465 sg13cmos5l_a21oi_1_4.A1 a_7530_12972# 0.04749f
C2466 a_19534_13239# a_19649_13238# 0.3854f
C2467 sg13cmos5l_nand3b_1_1.C sg13cmos5l_nor4_1_4.C 0.20272f
C2468 a_20294_14922# bn8 0.03649f
C2469 a_9867_5423# clk 0.01379f
C2470 sg13cmos5l_dfrbpq_1_41.CLK a_14218_18226# 0.7069f
C2471 sg13cmos5l_o21ai_1_3.A2 a_14842_9154# 0.03584f
C2472 sg13cmos5l_inv_1_17.A a_21839_7285# 0.01634f
C2473 sg13cmos5l_dfrbpq_1_5.CLK a_21084_18222# 0.04994f
C2474 a_19534_4839# bp6 0.04592f
C2475 sg13cmos5l_nand2b_1_1.A_N sg13cmos5l_o21ai_1_0.A2 0.12889f
C2476 a_21839_7285# a_21745_7285# 0.16704f
C2477 sg13cmos5l_nand3_1_0.A a_12414_7996# 0.05592f
C2478 sg13cmos5l_inv_1_1.A sg13cmos5l_inv_1_11.Y 0.02818f
C2479 sg13cmos5l_a21oi_1_6.Y a_22241_9376# 0.01984f
C2480 sg13cmos5l_nand2b_1_0.B sg13cmos5l_a22oi_1_0.B2 0.04159f
C2481 sg13cmos5l_nand2_1_0.B sg13cmos5l_nand3_1_1.Y 0.51155f
C2482 sg13cmos5l_o21ai_1_17.Y a_11288_19061# 0.27781f
C2483 sg13cmos5l_nand4_1_18.C a_17621_12972# 0.05088f
C2484 a_4594_17886# a_4952_17549# 0.02803f
C2485 sg13cmos5l_nand3_1_5.Y sg13cmos5l_o21ai_1_19.B1 0.22237f
C2486 sg13cmos5l_dfrbpq_1_0.D bp7 0.62217f
C2487 sg13cmos5l_nor3_1_2.B VDD 1.28177f
C2488 a_5578_12940# VDD 0.09444f
C2489 a_11393_6352# a_11674_6130# 0.18796f
C2490 a_8878_7191# VDD 0.15904f
C2491 sg13cmos5l_o21ai_1_11.B1 sg13cmos5l_nor2_1_7.Y 0.02637f
C2492 a_10878_7180# sg13cmos5l_dfrbpq_1_47.Q 0.0199f
C2493 sg13cmos5l_nand3_1_2.Y sg13cmos5l_buf_1_57.A 0.02363f
C2494 sg13cmos5l_buf_1_13.X sg13cmos5l_buf_1_9.A 0.08154f
C2495 sg13cmos5l_a21oi_1_4.A2 sg13cmos5l_nand3_1_1.Y 0.03166f
C2496 sg13cmos5l_o21ai_1_5.A1 sg13cmos5l_o21ai_1_28.A1 0.15056f
C2497 a_6958_16935# sg13cmos5l_o21ai_1_10.Y 0.019f
C2498 sg13cmos5l_buf_1_1.A sg13cmos5l_buf_1_4.A 0.91067f
C2499 sg13cmos5l_dfrbpq_1_24.RESET_B sg13cmos5l_inv_1_25.Y 0.19234f
C2500 sg13cmos5l_nand3_1_3.Y a_10878_7180# 0.03839f
C2501 sg13cmos5l_buf_1_65.A a_9260_11424# 0.18674f
C2502 a_21839_4727# VDD 0.17426f
C2503 sg13cmos5l_buf_1_45.X sg13cmos5l_dfrbpq_1_41.CLK 0.23411f
C2504 sg13cmos5l_inv_1_12.Y a_18874_9912# 0.01591f
C2505 sg13cmos5l_o21ai_1_20.B1 sg13cmos5l_nand3b_1_3.C 0.48181f
C2506 a_19179_10820# a_20176_10918# 0.03412f
C2507 sg13cmos5l_buf_1_42.A sg13cmos5l_buf_1_57.A 0.04582f
C2508 sg13cmos5l_buf_1_15.A sg13cmos5l_nor2b_1_1.A 0.08718f
C2509 sg13cmos5l_buf_1_16.A bn4 1.76481f
C2510 sg13cmos5l_dfrbpq_1_11.D a_17316_8440# 0.01877f
C2511 sg13cmos5l_inv_1_13.Y sg13cmos5l_dlygate4sd3_1_18.X 0.06685f
C2512 sg13cmos5l_inv_1_32.Y a_14253_13320# 0.01401f
C2513 a_14181_16007# a_14052_16421# 0.01562f
C2514 a_13764_16000# a_14283_16007# 0.20754f
C2515 sg13cmos5l_buf_1_13.X a_17412_6928# 0.04698f
C2516 sg13cmos5l_o21ai_1_0.A2 a_11840_5498# 0.02411f
C2517 sg13cmos5l_buf_1_54.A sg13cmos5l_inv_1_24.A 1.75829f
C2518 sg13cmos5l_nor3_1_6.Y sg13cmos5l_nand2_1_19.A 0.1608f
C2519 sg13cmos5l_o21ai_1_5.A2 sg13cmos5l_a21oi_1_6.A2 0.02572f
C2520 sg13cmos5l_mux2_1_0.A1 a_8015_11821# 0.01337f
C2521 a_18682_16714# a_19035_16750# 0.05827f
C2522 sg13cmos5l_a21oi_1_15.Y VDD 0.22309f
C2523 sg13cmos5l_inv_1_20.Y a_16949_12508# 0.02732f
C2524 sg13cmos5l_dlygate4sd3_1_25.A a_16342_10694# 0.06593f
C2525 sg13cmos5l_a21oi_1_9.Y sg13cmos5l_dfrbpq_1_13.D 0.05606f
C2526 a_9646_6351# sg13cmos5l_a21oi_1_10.Y 0.01185f
C2527 a_9077_6460# a_8872_6294# 0.01003f
C2528 sg13cmos5l_a21oi_1_19.Y sg13cmos5l_buf_1_54.A 0.01615f
C2529 sg13cmos5l_buf_1_13.A a_16725_7832# 0.18822f
C2530 sg13cmos5l_inv_1_15.A sg13cmos5l_o21ai_1_5.A2 0.06468f
C2531 sg13cmos5l_buf_1_42.A sg13cmos5l_nand2_1_1.A 0.64364f
C2532 sg13cmos5l_nand3_1_0.C a_16167_9404# 0.06533f
C2533 sg13cmos5l_inv_1_15.Y sg13cmos5l_buf_1_13.A 0.22784f
C2534 sg13cmos5l_o21ai_1_1.B1 a_14842_9154# 0.06133f
C2535 sg13cmos5l_dfrbpq_1_24.RESET_B sg13cmos5l_o21ai_1_21.A2 0.07018f
C2536 sg13cmos5l_buf_8_2.A sg13cmos5l_dlygate4sd3_1_69.A 0.12749f
C2537 a_21063_16083# a_21866_16276# 0.07823f
C2538 sg13cmos5l_nor4_1_2.Y a_18287_15311# 0.02446f
C2539 sg13cmos5l_nand4_1_6.B sg13cmos5l_buf_1_53.A 0.03382f
C2540 a_7199_6432# a_7895_6553# 0.02431f
C2541 sg13cmos5l_o21ai_1_26.B1 sg13cmos5l_dlygate4sd3_1_97.X 0.033f
C2542 sg13cmos5l_a21oi_1_18.B1 sg13cmos5l_dfrbpq_1_27.Q 0.78599f
C2543 a_21099_14495# bn8 0.01864f
C2544 a_13434_6887# a_13460_6924# 0.21976f
C2545 sg13cmos5l_buf_1_24.A code5 0.05982f
C2546 sg13cmos5l_dfrbpq_1_13.CLK a_13575_13940# 0.03805f
C2547 sg13cmos5l_buf_1_16.A VDD 1.58283f
C2548 a_4646_19458# a_4906_18988# 0.45119f
C2549 sg13cmos5l_buf_1_4.A bn9 0.04093f
C2550 sg13cmos5l_o21ai_1_4.Y a_12188_6904# 0.01417f
C2551 sg13cmos5l_o21ai_1_5.A2 sg13cmos5l_a21oi_1_17.Y 0.01879f
C2552 sg13cmos5l_buf_1_53.A a_13384_14484# 0.01715f
C2553 sg13cmos5l_buf_8_2.A a_7726_10887# 0.02533f
C2554 sg13cmos5l_o21ai_1_7.Y a_6760_15366# 0.02706f
C2555 a_12430_9375# VDD 0.16346f
C2556 a_19054_18447# VDD 0.15801f
C2557 sg13cmos5l_nand2_1_5.Y a_12058_7678# 0.01589f
C2558 a_17253_19749# a_17355_19892# 0.36168f
C2559 a_16836_20088# sg13cmos5l_inv_1_31.A 0.07238f
C2560 a_20554_11428# a_20580_11464# 0.24169f
C2561 a_5124_9504# a_5541_9165# 0.28324f
C2562 a_4838_9186# a_5643_9308# 0.07916f
C2563 sg13cmos5l_inv_1_1.A sg13cmos5l_buf_1_4.A 0.01898f
C2564 sg13cmos5l_buf_1_26.A sg13cmos5l_a21oi_1_19.Y 0.04539f
C2565 sg13cmos5l_nand4_1_15.B a_17628_16362# 0.01114f
C2566 sg13cmos5l_o21ai_1_4.Y a_12082_7302# 0.06065f
C2567 sg13cmos5l_dfrbpq_1_13.CLK sg13cmos5l_dfrbpq_1_47.Q 0.02322f
C2568 a_11670_19044# a_11558_19020# 0.3854f
C2569 sg13cmos5l_inv_1_1.A sg13cmos5l_inv_1_3.Y 0.04031f
C2570 sg13cmos5l_nand2_1_1.A sg13cmos5l_nand3_1_1.Y 0.04148f
C2571 a_7120_13214# VDD 0.13708f
C2572 a_14763_19892# code0 0.02583f
C2573 sg13cmos5l_dfrbpq_1_13.CLK sg13cmos5l_nand3_1_3.Y 0.0856f
C2574 a_12344_6166# a_12614_6166# 0.18796f
C2575 sg13cmos5l_inv_1_17.Y a_21089_6352# 0.01139f
C2576 sg13cmos5l_nand4_1_18.C sg13cmos5l_a21oi_1_0.A2 0.04964f
C2577 a_9348_20088# a_9867_19892# 0.20773f
C2578 sg13cmos5l_dfrbpq_1_41.CLK sg13cmos5l_buf_1_42.A 0.21499f
C2579 sg13cmos5l_a21oi_1_11.Y a_12344_6166# 0.01557f
C2580 sg13cmos5l_dfrbpq_1_24.Q a_11278_13239# 0.02955f
C2581 sg13cmos5l_o21ai_1_5.A2 sg13cmos5l_o21ai_1_28.A1 0.08673f
C2582 sg13cmos5l_a21oi_1_0.A2 a_18374_10698# 0.03275f
C2583 sg13cmos5l_nand4_1_7.B sg13cmos5l_nand4_1_1.C 0.24646f
C2584 sg13cmos5l_buf_1_42.A sg13cmos5l_nand4_1_1.A 0.02177f
C2585 sg13cmos5l_inv_1_12.A sg13cmos5l_dfrbpq_1_28.D 0.01241f
C2586 a_14244_20088# a_15503_19847# 0.01412f
C2587 sg13cmos5l_nand4_1_3.B sg13cmos5l_nand3_1_8.Y 0.09058f
C2588 sg13cmos5l_nand2_1_11.B a_8879_15238# 0.03571f
C2589 sg13cmos5l_buf_1_1.A sg13cmos5l_dfrbpq_1_27.Q 0.7377f
C2590 sg13cmos5l_a21oi_1_0.A2 sg13cmos5l_buf_1_0.A 0.02418f
C2591 a_6256_14726# VDD 0.1369f
C2592 sg13cmos5l_dlygate4sd3_1_0.A VDD 0.34251f
C2593 a_20176_10918# a_20586_10996# 0.07015f
C2594 a_10864_5654# VDD 0.13622f
C2595 sg13cmos5l_dfrbpq_1_24.Q a_8337_13362# 0.19474f
C2596 sg13cmos5l_buf_1_15.A a_6021_12983# 0.01254f
C2597 sg13cmos5l_buf_1_1.A sg13cmos5l_inv_1_2.A 0.63423f
C2598 sg13cmos5l_buf_1_2.A sg13cmos5l_buf_1_4.A 0.44643f
C2599 sg13cmos5l_nand4_1_3.B sg13cmos5l_nand4_1_1.C 0.62044f
C2600 sg13cmos5l_buf_1_7.X sg13cmos5l_buf_1_13.A 0.23824f
C2601 a_14181_16007# a_14929_16357# 0.01058f
C2602 a_14283_16007# a_15023_16357# 0.17382f
C2603 a_16319_9456# a_16078_9186# 0.01058f
C2604 sg13cmos5l_inv_1_3.Y sg13cmos5l_buf_1_2.A 0.06808f
C2605 a_1294_9375# VDD 0.15722f
C2606 a_1409_15424# a_1690_15202# 0.18796f
C2607 sg13cmos5l_dfrbpq_1_13.RESET_B a_6470_11898# 0.09721f
C2608 sg13cmos5l_o21ai_1_9.A2 sg13cmos5l_a21o_1_2.A1 0.05489f
C2609 sg13cmos5l_o21ai_1_25.Y sg13cmos5l_inv_1_32.Y 0.43301f
C2610 sg13cmos5l_nand4_1_5.D a_18670_16263# 0.01616f
C2611 sg13cmos5l_buf_1_66.X a_12428_12936# 0.16209f
C2612 a_21839_10309# VDD 0.1727f
C2613 sg13cmos5l_nand3_1_0.C sg13cmos5l_dfrbpq_1_11.D 0.01996f
C2614 sg13cmos5l_dfrbpq_1_5.CLK a_22522_17472# 0.05049f
C2615 sg13cmos5l_inv_1_19.Y sg13cmos5l_nand2b_1_4.B 0.22364f
C2616 sg13cmos5l_a21oi_1_2.B1 a_18188_4614# 0.1834f
C2617 sg13cmos5l_dfrbpq_1_13.CLK sg13cmos5l_a21oi_1_2.A2 0.03605f
C2618 a_22126_4167# bp1 0.0514f
C2619 sg13cmos5l_nand2_1_2.Y a_16558_11727# 0.01895f
C2620 sg13cmos5l_mux2_1_0.A1 a_5554_13718# 0.08214f
C2621 sg13cmos5l_buf_1_26.A bn0 0.02801f
C2622 a_22005_16043# a_21911_16043# 0.45119f
C2623 sg13cmos5l_o21ai_1_11.Y sg13cmos5l_o21ai_1_10.Y 0.04172f
C2624 sg13cmos5l_inv_1_15.Y sg13cmos5l_buf_1_5.A 0.0306f
C2625 sg13cmos5l_a21oi_1_1.A2 bp5 0.11454f
C2626 sg13cmos5l_dfrbpq_1_28.RESET_B sg13cmos5l_inv_1_16.A 0.11049f
C2627 a_12929_13238# VDD 0.23027f
C2628 sg13cmos5l_inv_1_15.A sg13cmos5l_dfrbpq_1_13.CLK 0.01693f
C2629 sg13cmos5l_nand4_1_6.B sg13cmos5l_nand4_1_3.D 0.16295f
C2630 bn7 bn8 0.07789f
C2631 sg13cmos5l_nor2_1_2.A a_6766_7191# 0.02135f
C2632 a_4932_19024# a_5220_19445# 0.24435f
C2633 sg13cmos5l_o21ai_1_25.B1 bn2 0.01689f
C2634 sg13cmos5l_dfrbpq_1_15.Q a_7338_7972# 0.01286f
C2635 a_12428_12936# VDD 0.1782f
C2636 sg13cmos5l_buf_1_14.A a_15592_10736# 0.20751f
C2637 sg13cmos5l_buf_1_7.X bp7 0.0377f
C2638 sg13cmos5l_a21oi_1_27.B1 sg13cmos5l_a21o_1_2.A1 0.02816f
C2639 sg13cmos5l_dfrbpq_1_27.Q bn9 0.01535f
C2640 a_14446_9375# VDD 0.16122f
C2641 sg13cmos5l_nor3_1_0.Y sg13cmos5l_buf_1_14.A 0.02296f
C2642 sg13cmos5l_buf_1_22.A VDD 0.22917f
C2643 sg13cmos5l_nor2b_1_2.Y sg13cmos5l_dlygate4sd3_1_7.X 0.01537f
C2644 a_20997_11471# a_21099_11471# 0.3643f
C2645 sg13cmos5l_inv_1_31.A bn5 0.19487f
C2646 sg13cmos5l_o21ai_1_5.A1 a_10316_12936# 0.01848f
C2647 sg13cmos5l_inv_1_2.A bn9 0.11124f
C2648 a_5643_9308# a_6640_9406# 0.03412f
C2649 sg13cmos5l_nor2b_1_0.B_N a_15329_10214# 0.05771f
C2650 a_12140_19734# sg13cmos5l_o21ai_1_18.B1 0.19689f
C2651 sg13cmos5l_o21ai_1_17.Y a_10694_18258# 0.03183f
C2652 a_9056_13058# VDD 0.07597f
C2653 sg13cmos5l_buf_1_16.A a_16832_16082# 0.02413f
C2654 a_9070_18447# a_9185_18448# 0.3854f
C2655 sg13cmos5l_o21ai_1_21.Y sg13cmos5l_nand3b_1_1.Y 0.01629f
C2656 sg13cmos5l_o21ai_1_20.A1 sg13cmos5l_nor2b_1_1.A 0.33749f
C2657 sg13cmos5l_nor2_1_2.A a_8637_5682# 0.21304f
C2658 sg13cmos5l_inv_1_1.A sg13cmos5l_inv_1_2.A 0.04933f
C2659 sg13cmos5l_dfrbpq_1_45.Q VDD 0.33668f
C2660 sg13cmos5l_inv_1_17.Y a_19912_11460# 0.04885f
C2661 sg13cmos5l_buf_1_16.A a_17615_5773# 0.01204f
C2662 sg13cmos5l_nor2b_1_0.B_N a_12426_9948# 0.01328f
C2663 sg13cmos5l_nand3b_1_3.C sg13cmos5l_dfrbpq_1_24.RESET_B 1.1094f
C2664 sg13cmos5l_o21ai_1_0.A2 VDD 1.17287f
C2665 sg13cmos5l_inv_1_1.A sg13cmos5l_dlygate4sd3_1_13.X 0.03189f
C2666 sg13cmos5l_o21ai_1_15.B1 a_9848_18262# 0.05246f
C2667 sg13cmos5l_a22oi_1_0.B2 a_14465_10214# 0.0166f
C2668 sg13cmos5l_buf_1_15.A a_11674_12936# 0.016f
C2669 sg13cmos5l_nand4_1_15.B sg13cmos5l_a21oi_1_19.A2 0.04651f
C2670 sg13cmos5l_buf_8_2.A a_18730_17476# 0.029f
C2671 sg13cmos5l_nand4_1_1.B a_18682_16714# 0.02293f
C2672 sg13cmos5l_inv_1_17.Y a_20104_10034# 0.01107f
C2673 sg13cmos5l_a21oi_1_9.A1 a_13862_6166# 0.01894f
C2674 sg13cmos5l_buf_1_21.A a_11770_11830# 0.01865f
C2675 a_14661_19749# a_15409_19847# 0.01058f
C2676 sg13cmos5l_inv_1_32.Y valid 0.01836f
C2677 sg13cmos5l_a21oi_1_4.A1 sg13cmos5l_nor4_1_1.D 0.13291f
C2678 sg13cmos5l_nand4_1_1.A a_18678_13730# 0.01837f
C2679 sg13cmos5l_nand4_1_18.B sg13cmos5l_o21ai_1_8.B1 0.03326f
C2680 sg13cmos5l_nand2b_1_3.Y a_10365_7194# 0.19096f
C2681 sg13cmos5l_nand4_1_1.A a_19646_14850# 0.01771f
C2682 sg13cmos5l_mux2_1_1.A1 a_10155_12332# 0.02575f
C2683 sg13cmos5l_nand2_1_6.A sg13cmos5l_a21oi_1_10.A2 0.61999f
C2684 a_20586_10996# sg13cmos5l_dfrbpq_1_5.Q 0.0936f
C2685 sg13cmos5l_buf_1_15.A sg13cmos5l_buf_1_10.A 0.03683f
C2686 sg13cmos5l_buf_1_45.X bn3 0.05254f
C2687 a_12631_5376# VDD 0.19297f
C2688 sg13cmos5l_buf_8_2.A sg13cmos5l_a21oi_1_24.A2 0.04202f
C2689 sg13cmos5l_buf_1_15.A a_7530_12972# 0.01019f
C2690 sg13cmos5l_inv_1_12.A sg13cmos5l_dlygate4sd3_1_13.A 0.16091f
C2691 sg13cmos5l_nand4_1_8.B bn5 0.08575f
C2692 sg13cmos5l_dfrbpq_1_38.Q a_15322_16714# 0.2782f
C2693 sg13cmos5l_buf_1_7.X sg13cmos5l_a21oi_1_0.Y 0.03525f
C2694 a_15358_14850# bn5 0.03142f
C2695 sg13cmos5l_buf_1_65.A sg13cmos5l_a21oi_1_27.A1 0.03018f
C2696 a_16550_19770# VDD 0.52277f
C2697 a_20294_11898# VDD 0.52304f
C2698 sg13cmos5l_buf_1_26.A sg13cmos5l_nor2b_1_1.A 0.0611f
C2699 sg13cmos5l_inv_1_2.A sg13cmos5l_buf_1_2.A 0.03731f
C2700 sg13cmos5l_dlygate4sd3_1_18.A a_18874_9912# 0.27592f
C2701 sg13cmos5l_buf_1_7.X sg13cmos5l_buf_1_5.A 0.44742f
C2702 sg13cmos5l_inv_1_2.A a_19642_6130# 0.05282f
C2703 a_20384_16921# sg13cmos5l_dlygate4sd3_1_74.A 0.0759f
C2704 sg13cmos5l_o21ai_1_26.B1 a_13958_19770# 0.02034f
C2705 sg13cmos5l_nor2_1_2.Y VDD 0.35898f
C2706 a_17386_6892# a_17829_6935# 0.02241f
C2707 sg13cmos5l_a21oi_1_2.A2 a_17914_9912# 0.01612f
C2708 sg13cmos5l_buf_1_45.X sg13cmos5l_nor4_1_2.Y 0.0244f
C2709 sg13cmos5l_dfrbpq_1_37.D a_21866_18416# 0.02142f
C2710 sg13cmos5l_nor2_1_4.Y VDD 0.28911f
C2711 sg13cmos5l_dfrbpq_1_24.RESET_B a_4454_14922# 0.10983f
C2712 sg13cmos5l_inv_1_15.Y sg13cmos5l_inv_1_24.A 0.02152f
C2713 a_5784_15976# VDD 0.01828f
C2714 sg13cmos5l_o21ai_1_14.Y sg13cmos5l_dlygate4sd3_1_62.A 0.01796f
C2715 a_13191_5499# a_13343_5383# 0.36168f
C2716 sg13cmos5l_a21oi_1_19.Y sg13cmos5l_inv_1_15.Y 0.01775f
C2717 a_7310_12400# a_7742_12508# 0.02925f
C2718 sg13cmos5l_nor4_1_1.D sg13cmos5l_mux2_1_1.A1 0.40182f
C2719 sg13cmos5l_a21oi_1_4.A1 sg13cmos5l_inv_1_36.Y 0.2924f
C2720 a_5451_19031# a_6191_19381# 0.17382f
C2721 sg13cmos5l_o21ai_1_26.B1 a_13764_17512# 0.03567f
C2722 a_21531_13342# a_22784_13058# 0.01906f
C2723 sg13cmos5l_buf_1_45.X a_13015_13686# 0.10879f
C2724 sg13cmos5l_inv_1_32.Y sg13cmos5l_nand4_1_15.B 0.03196f
C2725 a_10954_18481# a_10694_18258# 0.45119f
C2726 sg13cmos5l_buf_1_53.A VDD 0.28535f
C2727 a_20580_12528# a_20997_12189# 0.28324f
C2728 a_20294_12210# a_21099_12332# 0.07916f
C2729 sg13cmos5l_nand2b_1_0.B sg13cmos5l_nand2_1_0.A 0.28526f
C2730 a_22096_11702# a_21839_11821# 0.23043f
C2731 a_6640_9406# sg13cmos5l_nor3_1_2.Y 0.01043f
C2732 a_7050_9484# a_7507_9380# 0.01342f
C2733 sg13cmos5l_buf_1_15.A sg13cmos5l_nand3_1_0.B 0.01279f
C2734 sg13cmos5l_a21oi_1_20.A2 sg13cmos5l_inv_1_16.Y 0.12987f
C2735 a_9056_16878# VDD 0.08522f
C2736 a_14152_14484# VDD 0.17815f
C2737 sg13cmos5l_buf_1_59.A sg13cmos5l_inv_1_24.Y 0.01618f
C2738 a_20503_15960# a_20974_16434# 0.16704f
C2739 sg13cmos5l_a21oi_1_0.A2 bp0 0.0249f
C2740 sg13cmos5l_inv_1_36.A a_5998_13911# 0.01056f
C2741 a_9848_18262# sg13cmos5l_o21ai_1_15.Y 0.03599f
C2742 sg13cmos5l_nand2_1_18.A a_13208_11501# 0.27377f
C2743 sg13cmos5l_a21oi_1_24.A1 a_9466_18226# 0.01035f
C2744 a_5334_17532# a_5792_17594# 0.01604f
C2745 sg13cmos5l_a21o_1_2.B1 a_7064_14525# 0.02798f
C2746 sg13cmos5l_nor2b_1_0.B_N a_15214_10215# 0.04796f
C2747 a_9636_12528# VDD 0.07463f
C2748 sg13cmos5l_buf_8_2.A sg13cmos5l_dfrbpq_1_15.CLK 0.07585f
C2749 sg13cmos5l_nor3_1_6.Y sg13cmos5l_dfrbpq_1_18.Q 0.02582f
C2750 sg13cmos5l_nand4_1_3.B a_18872_13338# 0.01118f
C2751 sg13cmos5l_inv_1_12.Y sg13cmos5l_buf_1_7.X 0.02079f
C2752 sg13cmos5l_nor4_1_2.Y sg13cmos5l_nand3_1_2.Y 0.03318f
C2753 sg13cmos5l_buf_1_15.A sg13cmos5l_a21oi_1_27.A2 0.04393f
C2754 a_10053_12189# a_9924_12223# 0.01562f
C2755 sg13cmos5l_buf_8_2.A sg13cmos5l_inv_1_11.Y 0.02605f
C2756 sg13cmos5l_mux2_1_0.S a_9147_13028# 0.13472f
C2757 sg13cmos5l_inv_1_15.A bn6 0.68206f
C2758 sg13cmos5l_nand4_1_8.B sg13cmos5l_dfrbpq_1_18.Q 0.0843f
C2759 sg13cmos5l_nor4_1_2.Y sg13cmos5l_buf_1_42.A 0.95003f
C2760 sg13cmos5l_dlygate4sd3_1_18.A a_17318_11898# 0.01418f
C2761 sg13cmos5l_inv_1_6.Y a_21839_4727# 0.01396f
C2762 a_6383_9263# VDD 0.17424f
C2763 sg13cmos5l_nand4_1_1.B busy 0.03736f
C2764 sg13cmos5l_o21ai_1_5.A1 sg13cmos5l_nand3_1_6.C 0.0115f
C2765 sg13cmos5l_a21oi_1_2.A2 a_16631_8065# 0.01522f
C2766 a_8844_15424# VDD 0.18913f
C2767 sg13cmos5l_a21oi_1_4.A1 sg13cmos5l_nand2_1_1.Y 0.48477f
C2768 sg13cmos5l_nand3_1_4.Y a_9368_7682# 0.01437f
C2769 sg13cmos5l_dfrbpq_1_13.CLK a_9765_5423# 0.20561f
C2770 a_17412_6928# a_18671_7285# 0.01412f
C2771 sg13cmos5l_dfrbpq_1_19.CLK sg13cmos5l_o21ai_1_19.B1 0.01073f
C2772 sg13cmos5l_o21ai_1_9.A2 a_5157_14495# 0.05403f
C2773 sg13cmos5l_dlygate4sd3_1_38.X sg13cmos5l_nor3_1_2.B 0.01073f
C2774 sg13cmos5l_nand3_1_0.B a_16319_9456# 0.05106f
C2775 bp8 bp5 0.02491f
C2776 sg13cmos5l_a21oi_1_1.A2 a_19365_5423# 0.02156f
C2777 bp7 bp4 0.02491f
C2778 sg13cmos5l_inv_1_31.A a_20503_15960# 0.01029f
C2779 sg13cmos5l_nand3_1_5.Y sg13cmos5l_a21oi_1_12.Y 0.18867f
C2780 a_1690_19738# VDD 0.27007f
C2781 sg13cmos5l_nand2_1_15.Y sg13cmos5l_inv_1_12.A 0.03386f
C2782 sg13cmos5l_dfrbpq_1_29.Q a_21911_17137# 0.01253f
C2783 sg13cmos5l_nand4_1_1.B sg13cmos5l_nand4_1_3.B 0.04396f
C2784 sg13cmos5l_a21oi_1_27.B1 a_8830_17874# 0.03118f
C2785 sg13cmos5l_buf_8_2.A sg13cmos5l_o21ai_1_8.B1 0.0317f
C2786 sg13cmos5l_a21oi_1_3.A2 a_17240_10702# 0.07327f
C2787 sg13cmos5l_o21ai_1_5.A1 sg13cmos5l_a21oi_1_4.A1 0.0369f
C2788 a_13343_5383# a_14039_5459# 0.02453f
C2789 sg13cmos5l_buf_1_0.A a_20294_6166# 0.0449f
C2790 sg13cmos5l_nand2_1_2.Y a_16090_10702# 0.01495f
C2791 sg13cmos5l_a21oi_1_9.A2 a_11274_5412# 0.057f
C2792 sg13cmos5l_o21ai_1_8.B1 sg13cmos5l_a21o_1_2.B1 0.05702f
C2793 a_1294_15423# VDD 0.15723f
C2794 sg13cmos5l_buf_1_16.A a_17835_8447# 0.01862f
C2795 sg13cmos5l_buf_1_16.A sg13cmos5l_a21oi_1_24.A2 0.01412f
C2796 sg13cmos5l_dfrbpq_1_15.CLK sg13cmos5l_nor3_1_2.B 0.06117f
C2797 sg13cmos5l_dfrbpq_1_15.CLK a_5578_12940# 0.03295f
C2798 sg13cmos5l_o21ai_1_10.A2 a_10162_16742# 0.07593f
C2799 a_20294_12210# a_20868_12223# 0.18486f
C2800 a_21099_12332# a_22096_12430# 0.03412f
C2801 sg13cmos5l_nor4_1_1.D sg13cmos5l_nor3_1_4.A 0.46832f
C2802 sg13cmos5l_nand4_1_15.B sg13cmos5l_inv_1_12.A 1.28951f
C2803 a_22506_11460# sg13cmos5l_dlygate4sd3_1_20.A 0.08438f
C2804 sg13cmos5l_a21oi_1_2.B1 VDD 1.48064f
C2805 sg13cmos5l_buf_1_16.A sg13cmos5l_inv_1_6.Y 0.01995f
C2806 sg13cmos5l_inv_1_25.Y bn5 0.02423f
C2807 sg13cmos5l_nand4_1_3.D VDD 0.63634f
C2808 a_21084_16357# a_22005_16043# 0.24169f
C2809 sg13cmos5l_buf_1_1.A a_21640_3176# 0.20258f
C2810 sg13cmos5l_nand4_1_5.D bn6 0.01299f
C2811 a_12134_19458# a_12939_19031# 0.07916f
C2812 a_19534_16263# a_19649_16262# 0.3854f
C2813 sg13cmos5l_o21ai_1_22.B1 VDD 0.31165f
C2814 sg13cmos5l_dlygate4sd3_1_42.X sg13cmos5l_dlygate4sd3_1_43.X 0.01938f
C2815 sg13cmos5l_buf_1_15.A a_22005_16043# 0.17275f
C2816 a_10895_12287# VDD 0.18157f
C2817 sg13cmos5l_a21oi_1_18.B1 sg13cmos5l_inv_1_16.Y 0.40482f
C2818 sg13cmos5l_inv_1_12.A bp2 0.06044f
C2819 sg13cmos5l_o21ai_1_4.A1 a_12082_7302# 0.05732f
C2820 sg13cmos5l_o21ai_1_5.A1 sg13cmos5l_mux2_1_1.A1 0.19894f
C2821 sg13cmos5l_nand4_1_6.B sg13cmos5l_mux2_1_0.S 0.06515f
C2822 sg13cmos5l_buf_1_10.A sg13cmos5l_a21oi_1_3.Y 0.12356f
C2823 a_10872_11016# VDD 0.01784f
C2824 sg13cmos5l_nand4_1_8.B a_14761_15238# 0.01815f
C2825 sg13cmos5l_o21ai_1_5.A2 a_12040_15272# 0.02731f
C2826 sg13cmos5l_dfrbpq_1_13.Q a_12040_6294# 0.04702f
C2827 sg13cmos5l_inv_1_5.Y VDD 0.13428f
C2828 a_9096_15996# a_9435_15996# 0.01986f
C2829 sg13cmos5l_nand4_1_15.B sg13cmos5l_nand2_1_13.A 0.01675f
C2830 sg13cmos5l_nand4_1_16.D a_16742_15234# 0.01094f
C2831 sg13cmos5l_nor2_1_2.B a_8296_4782# 0.02685f
C2832 a_14133_5459# VDD 0.09721f
C2833 sg13cmos5l_a21oi_1_2.B1 bp6 0.04352f
C2834 sg13cmos5l_inv_1_17.Y a_18660_11016# 0.02111f
C2835 a_11180_15198# VDD 0.18624f
C2836 sg13cmos5l_inv_1_15.A sg13cmos5l_dfrbpq_1_30.D 0.085f
C2837 sg13cmos5l_a21oi_1_15.A2 sg13cmos5l_inv_1_12.A 0.12209f
C2838 sg13cmos5l_nand4_1_18.C sg13cmos5l_dfrbpq_1_28.D 0.22615f
C2839 sg13cmos5l_o21ai_1_5.A2 sg13cmos5l_nand3_1_6.C 0.34737f
C2840 sg13cmos5l_nor3_1_6.Y sg13cmos5l_a21o_1_2.A1 0.02152f
C2841 sg13cmos5l_buf_8_2.A sg13cmos5l_inv_1_3.Y 0.01983f
C2842 sg13cmos5l_buf_1_57.A sg13cmos5l_and4_1_1.A 0.02378f
C2843 a_8192_15366# VDD 0.08004f
C2844 sg13cmos5l_a21oi_1_6.A2 a_19912_11460# 0.0225f
C2845 sg13cmos5l_buf_1_65.A a_8337_13362# 0.06621f
C2846 a_21838_19959# sg13cmos5l_dfrbpq_1_39.Q 0.01816f
C2847 sg13cmos5l_o21ai_1_5.A1 bn1 0.03746f
C2848 sg13cmos5l_a21oi_1_1.A2 sg13cmos5l_dlygate4sd3_1_2.A 0.04222f
C2849 a_21640_3176# bn9 0.16225f
C2850 a_18928_7166# a_19338_6924# 0.07015f
C2851 sg13cmos5l_dlygate4sd3_1_29.A sg13cmos5l_dfrbpq_1_1.D 0.03594f
C2852 sg13cmos5l_nand4_1_18.B sg13cmos5l_dfrbpq_1_13.RESET_B 0.01734f
C2853 a_20503_16710# a_21084_16710# 0.01412f
C2854 a_12504_15552# sg13cmos5l_o21ai_1_28.Y 0.01087f
C2855 sg13cmos5l_o21ai_1_23.A2 a_13782_15302# 0.01061f
C2856 sg13cmos5l_o21ai_1_5.A2 sg13cmos5l_a21oi_1_4.A1 0.67509f
C2857 sg13cmos5l_dfrbpq_1_5.CLK a_21099_12332# 0.03823f
C2858 a_7822_19959# sg13cmos5l_o21ai_1_19.Y 0.05034f
C2859 sg13cmos5l_inv_1_1.Y a_18756_17512# 0.03362f
C2860 a_7238_19458# a_7498_18988# 0.45119f
C2861 sg13cmos5l_nand3_1_0.B sg13cmos5l_a21oi_1_3.Y 0.01598f
C2862 sg13cmos5l_dfrbpq_1_18.Q sg13cmos5l_dfrbpq_1_24.Q 0.17527f
C2863 a_11397_18237# a_11268_18271# 0.01562f
C2864 a_12239_18335# a_12496_18478# 0.23043f
C2865 sg13cmos5l_buf_1_16.A sg13cmos5l_inv_1_11.Y 0.06504f
C2866 sg13cmos5l_buf_1_63.A sg13cmos5l_inv_1_32.Y 0.01928f
C2867 sg13cmos5l_a21oi_1_18.B1 code1 0.95656f
C2868 sg13cmos5l_a21oi_1_18.B1 sg13cmos5l_a21oi_1_24.A1 0.01558f
C2869 sg13cmos5l_or4_1_0.D a_7726_8703# 0.04325f
C2870 a_22235_5412# VDD 0.19611f
C2871 sg13cmos5l_buf_1_15.A sg13cmos5l_nor4_1_1.D 0.09865f
C2872 sg13cmos5l_nand4_1_17.Y a_18106_17472# 0.01502f
C2873 sg13cmos5l_o21ai_1_20.Y sg13cmos5l_nand3_1_5.Y 0.0322f
C2874 a_18352_19990# a_18762_20068# 0.07015f
C2875 sg13cmos5l_dfrbpq_1_19.CLK a_4108_18258# 0.02137f
C2876 sg13cmos5l_buf_1_16.A sg13cmos5l_dlygate4sd3_1_98.A 0.20137f
C2877 sg13cmos5l_inv_1_1.Y sg13cmos5l_dlygate4sd3_1_72.A 0.01843f
C2878 sg13cmos5l_nand3b_1_1.C sg13cmos5l_o21ai_1_28.A1 0.0613f
C2879 sg13cmos5l_dfrbpq_1_15.Q a_6700_6162# 0.01708f
C2880 a_12708_19445# a_12939_19031# 0.07823f
C2881 a_12420_19024# a_13585_19381# 0.25046f
C2882 sg13cmos5l_buf_1_13.A sg13cmos5l_o21ai_1_4.Y 0.0359f
C2883 sg13cmos5l_nand3_1_0.A sg13cmos5l_buf_1_13.A 0.01636f
C2884 a_11756_19734# VDD 0.17856f
C2885 a_12632_17549# VDD 0.26893f
C2886 sg13cmos5l_inv_1_1.A sg13cmos5l_nor3_1_7.Y 0.02037f
C2887 a_12987_12214# VDD 0.97552f
C2888 sg13cmos5l_o21ai_1_5.A2 sg13cmos5l_mux2_1_1.A1 0.03556f
C2889 sg13cmos5l_nand2_1_0.A a_14350_10215# 0.10894f
C2890 sg13cmos5l_o21ai_1_14.Y a_6968_17549# 0.01661f
C2891 a_20384_16283# VDD 0.27783f
C2892 a_16742_15234# a_17445_15213# 0.02453f
C2893 sg13cmos5l_a21oi_1_2.B1 a_17615_5773# 0.02324f
C2894 sg13cmos5l_a21o_1_2.X a_6666_14484# 0.03963f
C2895 sg13cmos5l_dfrbpq_1_13.CLK sg13cmos5l_nor4_1_0.Y 0.05489f
C2896 sg13cmos5l_a21oi_1_7.A2 a_20294_12210# 0.01169f
C2897 a_16773_5423# VDD 0.25038f
C2898 a_20997_9959# bp2 0.05257f
C2899 sg13cmos5l_nand3_1_8.Y a_20294_13722# 0.02238f
C2900 sg13cmos5l_o21ai_1_5.A1 sg13cmos5l_nor3_1_4.A 0.04031f
C2901 sg13cmos5l_buf_1_7.X a_20580_4968# 0.26252f
C2902 sg13cmos5l_inv_1_1.A sg13cmos5l_inv_1_16.Y 0.6941f
C2903 sg13cmos5l_buf_1_15.A sg13cmos5l_inv_1_36.Y 0.02018f
C2904 sg13cmos5l_inv_1_17.Y a_19919_10775# 0.04525f
C2905 sg13cmos5l_buf_1_4.A a_21839_4727# 0.02619f
C2906 sg13cmos5l_inv_1_17.Y sg13cmos5l_buf_1_8.A 0.01106f
C2907 sg13cmos5l_buf_1_7.X sg13cmos5l_buf_1_6.A 0.06547f
C2908 a_3500_19734# code8 0.16132f
C2909 sg13cmos5l_a21oi_1_26.A2 sg13cmos5l_nand4_1_5.D 0.03116f
C2910 sg13cmos5l_nand2_1_15.B a_13727_13992# 0.01516f
C2911 sg13cmos5l_buf_8_2.A sg13cmos5l_inv_1_2.A 0.06481f
C2912 sg13cmos5l_o21ai_1_5.A2 bn1 0.06504f
C2913 sg13cmos5l_inv_1_2.A a_20554_4873# 0.01007f
C2914 sg13cmos5l_buf_1_45.X sg13cmos5l_dlygate4sd3_1_55.X 0.06344f
C2915 sg13cmos5l_dfrbpq_1_24.RESET_B a_4823_17137# 0.11289f
C2916 sg13cmos5l_buf_8_2.A sg13cmos5l_dlygate4sd3_1_13.X 0.03451f
C2917 a_16330_5380# a_16773_5423# 0.02241f
C2918 a_16070_5850# a_16644_5837# 0.18486f
C2919 sg13cmos5l_a21oi_1_27.A1 a_9610_12433# 0.02344f
C2920 sg13cmos5l_o21ai_1_0.A2 sg13cmos5l_nand2_1_6.A 0.06513f
C2921 sg13cmos5l_o21ai_1_13.B1 sg13cmos5l_inv_1_25.Y 0.05679f
C2922 sg13cmos5l_a21oi_1_27.B1 sg13cmos5l_nand2_1_13.A 0.1876f
C2923 sg13cmos5l_buf_1_13.X sg13cmos5l_dfrbpq_1_11.D 0.54112f
C2924 sg13cmos5l_dlygate4sd3_1_54.A a_11288_19061# 0.01459f
C2925 a_7196_15552# VDD 0.01784f
C2926 sg13cmos5l_nand3b_1_3.C bn5 0.19232f
C2927 a_16078_19287# sg13cmos5l_dfrbpq_1_33.D 0.10697f
C2928 sg13cmos5l_a21oi_1_2.B1 a_20997_8447# 0.01091f
C2929 sg13cmos5l_inv_1_1.Y a_19275_17519# 0.01748f
C2930 sg13cmos5l_a21oi_1_8.A1 VDD 0.30945f
C2931 a_19624_8522# VDD 0.13426f
C2932 sg13cmos5l_buf_1_24.A sg13cmos5l_buf_1_20.A 0.08485f
C2933 sg13cmos5l_inv_1_8.A a_14253_13320# 0.1938f
C2934 sg13cmos5l_dfrbpq_1_28.RESET_B a_20554_14452# 0.20617f
C2935 sg13cmos5l_nand3_1_0.B a_16838_9948# 0.04096f
C2936 sg13cmos5l_buf_1_43.X sg13cmos5l_and2_1_3.X 0.11955f
C2937 sg13cmos5l_buf_1_26.A a_10389_16258# 0.03404f
C2938 sg13cmos5l_a21oi_1_4.A1 sg13cmos5l_dfrbpq_1_13.CLK 0.05225f
C2939 sg13cmos5l_buf_1_54.A a_14920_14484# 0.1878f
C2940 sg13cmos5l_o21ai_1_7.B1 sg13cmos5l_o21ai_1_11.B1 0.01081f
C2941 sg13cmos5l_buf_1_10.A sg13cmos5l_a21oi_1_6.Y 0.03239f
C2942 sg13cmos5l_nor3_1_6.Y sg13cmos5l_nand2b_1_0.B 0.02409f
C2943 a_18762_20068# sg13cmos5l_dfrbpq_1_40.Q 0.08619f
C2944 sg13cmos5l_dfrbpq_1_19.CLK sg13cmos5l_dfrbpq_1_20.D 0.07938f
C2945 sg13cmos5l_buf_8_2.A sg13cmos5l_dfrbpq_1_13.RESET_B 0.05235f
C2946 a_13679_19381# a_13585_19381# 0.16704f
C2947 sg13cmos5l_inv_1_36.A a_9176_13726# 0.28988f
C2948 sg13cmos5l_inv_1_17.A a_21099_13844# 0.01114f
C2949 sg13cmos5l_buf_1_15.A sg13cmos5l_nand2_1_1.Y 0.02145f
C2950 sg13cmos5l_o21ai_1_1.Y a_14328_7992# 0.01087f
C2951 sg13cmos5l_nor3_1_0.Y sg13cmos5l_a21oi_1_4.B1 0.09014f
C2952 sg13cmos5l_inv_1_8.A sg13cmos5l_a22oi_1_0.B2 0.79923f
C2953 sg13cmos5l_nand4_1_7.B sg13cmos5l_dlygate4sd3_1_80.X 0.01972f
C2954 sg13cmos5l_dfrbpq_1_5.CLK a_22145_19286# 0.0243f
C2955 sg13cmos5l_inv_1_15.Y sg13cmos5l_buf_1_10.A 0.03168f
C2956 sg13cmos5l_inv_1_20.Y sg13cmos5l_nand2_1_0.B 0.01346f
C2957 a_14438_6162# a_14724_6480# 0.26205f
C2958 sg13cmos5l_nand4_1_6.B sg13cmos5l_inv_1_24.Y 0.1847f
C2959 a_14698_6385# a_15141_6141# 0.02241f
C2960 sg13cmos5l_dfrbpq_1_28.D bp0 0.01009f
C2961 sg13cmos5l_buf_1_45.X a_14283_16007# 0.28012f
C2962 sg13cmos5l_o21ai_1_11.B1 a_6682_15960# 0.02679f
C2963 sg13cmos5l_buf_1_1.A bp1 0.32269f
C2964 a_9765_19749# a_9636_19783# 0.01562f
C2965 sg13cmos5l_buf_1_47.X a_10694_18258# 0.01743f
C2966 a_18730_18988# a_18756_19024# 0.24169f
C2967 sg13cmos5l_inv_1_32.Y sg13cmos5l_nand2_1_15.B 0.02549f
C2968 sg13cmos5l_nand2b_1_1.A_N a_10365_7194# 0.07956f
C2969 sg13cmos5l_buf_1_15.A sg13cmos5l_o21ai_1_5.A1 0.12919f
C2970 sg13cmos5l_mux2_1_1.A1 sg13cmos5l_dfrbpq_1_13.CLK 0.10093f
C2971 sg13cmos5l_dlygate4sd3_1_69.A a_12632_17549# 0.03775f
C2972 sg13cmos5l_nor2_1_12.Y sg13cmos5l_nand2_1_12.Y 0.06853f
C2973 sg13cmos5l_mux2_1_0.S VDD 1.27827f
C2974 sg13cmos5l_inv_1_17.Y a_19825_10775# 0.01726f
C2975 sg13cmos5l_o21ai_1_22.Y a_9526_16742# 0.06016f
C2976 sg13cmos5l_nand3_1_8.Y sg13cmos5l_nand4_1_18.A 0.21692f
C2977 sg13cmos5l_buf_1_15.A a_20716_16434# 0.10654f
C2978 sg13cmos5l_dfrbpq_1_19.D sg13cmos5l_o21ai_1_9.A2 0.06503f
C2979 sg13cmos5l_dfrbpq_1_14.D VDD 0.21531f
C2980 sg13cmos5l_dfrbpq_1_7.D a_21099_9959# 0.02111f
C2981 a_17338_18984# a_17717_19020# 0.02543f
C2982 sg13cmos5l_a21oi_1_4.A2 sg13cmos5l_inv_1_20.Y 0.03165f
C2983 sg13cmos5l_a21oi_1_15.Y a_19048_12248# 0.0269f
C2984 a_16644_5837# a_16875_5423# 0.07823f
C2985 sg13cmos5l_buf_1_42.A a_17608_13760# 0.16244f
C2986 sg13cmos5l_dlygate4sd3_1_64.X sg13cmos5l_o21ai_1_20.A1 0.02185f
C2987 sg13cmos5l_buf_1_13.X a_19995_9190# 0.03337f
C2988 sg13cmos5l_nand4_1_1.C sg13cmos5l_nand4_1_18.A 0.13216f
C2989 sg13cmos5l_a21oi_1_10.A2 sg13cmos5l_dfrbpq_1_13.D 0.01891f
C2990 sg13cmos5l_a21oi_1_2.B1 sg13cmos5l_a21oi_1_2.Y 1.00218f
C2991 a_21832_7806# VDD 0.13581f
C2992 sg13cmos5l_o21ai_1_15.B1 a_10162_16742# 0.02835f
C2993 a_9322_19993# sg13cmos5l_buf_1_15.A 0.1815f
C2994 sg13cmos5l_buf_1_42.A a_17038_14751# 0.03358f
C2995 a_20580_9952# a_21099_9959# 0.20754f
C2996 a_20294_14922# VDD 0.52309f
C2997 sg13cmos5l_dfrbpq_1_13.RESET_B sg13cmos5l_nor3_1_2.B 0.087f
C2998 sg13cmos5l_nand3_1_0.B a_16725_7832# 0.01969f
C2999 a_16942_19287# a_17057_19286# 0.3854f
C3000 a_16474_18984# sg13cmos5l_a21oi_1_18.B1 0.01727f
C3001 a_7941_19031# a_8689_19381# 0.01058f
C3002 sg13cmos5l_inv_1_15.Y sg13cmos5l_nand3_1_0.B 0.03065f
C3003 sg13cmos5l_inv_1_15.A a_21761_15424# 0.02098f
C3004 bp1 bn9 0.01473f
C3005 sg13cmos5l_dfrbpq_1_28.RESET_B a_21839_14845# 0.10885f
C3006 sg13cmos5l_a21oi_1_6.A2 a_18660_11016# 0.04128f
C3007 a_19077_7653# VDD 0.24514f
C3008 sg13cmos5l_buf_1_16.A a_19048_12248# 0.1578f
C3009 sg13cmos5l_buf_1_47.X sg13cmos5l_nand4_1_1.B 0.23286f
C3010 a_6470_11898# a_6756_11464# 0.26205f
C3011 sg13cmos5l_dlygate4sd3_1_42.A sg13cmos5l_nor3_1_2.C 0.12023f
C3012 sg13cmos5l_nand4_1_18.D sg13cmos5l_a21oi_1_16.A2 0.04464f
C3013 sg13cmos5l_inv_1_1.A bp1 0.01901f
C3014 sg13cmos5l_a21oi_1_2.B1 a_17835_8447# 0.06857f
C3015 sg13cmos5l_dlygate4sd3_1_77.A a_19336_15366# 0.02427f
C3016 a_18106_17472# VDD 0.2882f
C3017 sg13cmos5l_inv_1_32.Y sg13cmos5l_nand4_1_8.B 0.02863f
C3018 sg13cmos5l_buf_1_7.X sg13cmos5l_buf_1_10.A 0.02718f
C3019 a_15754_18481# code1 0.02239f
C3020 a_17316_8440# VDD 0.0721f
C3021 sg13cmos5l_a21oi_1_24.A1 a_15754_18481# 0.01544f
C3022 sg13cmos5l_nand4_1_18.D sg13cmos5l_inv_1_16.Y 0.34946f
C3023 sg13cmos5l_inv_1_1.Y a_20554_9916# 0.01404f
C3024 sg13cmos5l_a21oi_1_2.B1 sg13cmos5l_inv_1_6.Y 0.08251f
C3025 sg13cmos5l_buf_1_65.A a_9716_15202# 0.19218f
C3026 sg13cmos5l_nand2_1_19.A sg13cmos5l_buf_1_14.A 0.2298f
C3027 sg13cmos5l_dfrbpq_1_5.CLK sg13cmos5l_a21oi_1_7.A2 0.16279f
C3028 sg13cmos5l_inv_1_7.Y sg13cmos5l_inv_1_0.A 0.72147f
C3029 sg13cmos5l_inv_1_17.A a_21839_13799# 0.03796f
C3030 sg13cmos5l_nand4_1_15.B sg13cmos5l_nand4_1_18.C 0.23838f
C3031 sg13cmos5l_inv_1_1.Y a_19923_18284# 0.01159f
C3032 a_20580_4968# bp4 0.03702f
C3033 sg13cmos5l_buf_1_13.A a_14438_6162# 0.09693f
C3034 a_17445_15213# a_17316_15247# 0.01562f
C3035 sg13cmos5l_o21ai_1_7.A2 sg13cmos5l_a21oi_1_4.A1 0.02849f
C3036 sg13cmos5l_nor2_1_7.Y sg13cmos5l_a21oi_1_12.Y 0.20024f
C3037 sg13cmos5l_dfrbpq_1_15.CLK a_6383_9263# 0.01837f
C3038 a_19173_19031# a_19275_19031# 0.3643f
C3039 sg13cmos5l_dlygate4sd3_1_51.X a_4646_19458# 0.18013f
C3040 a_13014_17532# a_12902_17508# 0.3854f
C3041 sg13cmos5l_nand2_1_1.A sg13cmos5l_inv_1_20.Y 0.27794f
C3042 a_14061_8784# sg13cmos5l_a22oi_1_2.Y 0.01225f
C3043 sg13cmos5l_buf_1_15.A sg13cmos5l_o21ai_1_5.A2 0.16829f
C3044 sg13cmos5l_nand2_1_18.A sg13cmos5l_nand3b_1_0.C 0.19923f
C3045 sg13cmos5l_nand4_1_18.B sg13cmos5l_a21oi_1_16.A2 0.01027f
C3046 sg13cmos5l_nor2b_1_0.B_N sg13cmos5l_nand3_1_0.A 0.01639f
C3047 a_22126_9375# a_22241_9376# 0.3854f
C3048 sg13cmos5l_o21ai_1_0.Y a_12082_7302# 0.02468f
C3049 sg13cmos5l_dlygate4sd3_1_13.A bp0 0.89052f
C3050 sg13cmos5l_nand4_1_18.B sg13cmos5l_nand2_1_9.Y 0.01044f
C3051 sg13cmos5l_a21oi_1_4.A1 sg13cmos5l_mux2_1_0.A1 0.28184f
C3052 sg13cmos5l_nand4_1_18.B sg13cmos5l_inv_1_16.Y 0.26386f
C3053 sg13cmos5l_dfrbpq_1_20.D a_6113_17774# 0.01013f
C3054 sg13cmos5l_dfrbpq_1_19.CLK a_3900_16357# 0.07108f
C3055 a_10500_9952# VDD 0.07414f
C3056 sg13cmos5l_buf_1_25.A a_19044_19445# 0.01008f
C3057 sg13cmos5l_a21oi_1_7.A2 a_21269_9484# 0.07902f
C3058 sg13cmos5l_a21oi_1_4.A1 bn6 0.76101f
C3059 sg13cmos5l_dfrbpq_1_20.Q a_4607_18528# 0.01768f
C3060 sg13cmos5l_nand4_1_12.Y a_17717_19020# 0.07912f
C3061 sg13cmos5l_nor2_1_10.Y sg13cmos5l_a21oi_1_24.A1 0.04397f
C3062 sg13cmos5l_buf_1_0.A bp2 0.02695f
C3063 sg13cmos5l_o21ai_1_15.Y a_10162_16742# 0.06449f
C3064 sg13cmos5l_inv_1_12.A a_20997_11471# 0.02748f
C3065 sg13cmos5l_nor4_1_2.Y sg13cmos5l_and4_1_1.A 0.04061f
C3066 sg13cmos5l_dfrbpq_1_25.Q a_7238_19458# 0.02704f
C3067 a_17615_5773# a_17521_5773# 0.16704f
C3068 sg13cmos5l_o21ai_1_25.B1 sg13cmos5l_nand4_1_1.B 0.72095f
C3069 sg13cmos5l_a21oi_1_25.A2 bn5 0.01422f
C3070 sg13cmos5l_nand3b_1_3.C a_14761_15238# 0.20116f
C3071 sg13cmos5l_dfrbpq_1_47.Q sg13cmos5l_a21oi_1_11.Y 0.02758f
C3072 sg13cmos5l_buf_1_45.X a_12420_19024# 0.27335f
C3073 sg13cmos5l_nand4_1_12.Y sg13cmos5l_a21oi_1_26.A1 0.01664f
C3074 a_9734_17508# sg13cmos5l_o21ai_1_22.B1 0.02102f
C3075 sg13cmos5l_nand4_1_18.C sg13cmos5l_a21oi_1_15.A2 0.02763f
C3076 sg13cmos5l_inv_1_13.Y a_18195_13748# 0.01192f
C3077 sg13cmos5l_nand4_1_3.B sg13cmos5l_inv_1_12.Y 0.34711f
C3078 a_21911_16043# bn6 0.01742f
C3079 sg13cmos5l_a21oi_1_1.A2 a_18660_11016# 0.01627f
C3080 sg13cmos5l_a21oi_1_9.A1 sg13cmos5l_dfrbpq_1_47.Q 0.0511f
C3081 sg13cmos5l_buf_1_9.A sg13cmos5l_dfrbpq_1_11.D 0.02608f
C3082 sg13cmos5l_nand4_1_1.C a_18882_13730# 0.01049f
C3083 sg13cmos5l_inv_1_24.A busy 0.04084f
C3084 sg13cmos5l_dfrbpq_1_47.Q sg13cmos5l_nor3_1_1.Y 0.01654f
C3085 sg13cmos5l_inv_1_31.A a_21215_18528# 0.20126f
C3086 sg13cmos5l_nand3_1_3.Y sg13cmos5l_a21oi_1_11.Y 0.10241f
C3087 sg13cmos5l_nand4_1_7.B sg13cmos5l_inv_1_24.A 0.01388f
C3088 a_5416_9948# VDD 0.18754f
C3089 a_21099_14495# VDD 0.20602f
C3090 sg13cmos5l_a21oi_1_2.A2 sg13cmos5l_buf_1_8.A 0.93533f
C3091 sg13cmos5l_nand3_1_3.Y sg13cmos5l_a21oi_1_9.A1 1.00185f
C3092 sg13cmos5l_inv_1_13.Y a_18101_14020# 0.02814f
C3093 a_21063_16964# a_21084_16710# 0.20754f
C3094 sg13cmos5l_nand3_1_3.Y sg13cmos5l_nor3_1_1.Y 0.07335f
C3095 a_3512_9989# VDD 0.29036f
C3096 sg13cmos5l_dfrbpq_1_33.D a_15392_18390# 0.03656f
C3097 sg13cmos5l_a21oi_1_12.A2 VDD 0.47311f
C3098 a_20974_19959# a_21089_19960# 0.3854f
C3099 a_4740_14488# VDD 0.07212f
C3100 sg13cmos5l_nor3_1_6.Y sg13cmos5l_inv_1_12.A 0.1316f
C3101 sg13cmos5l_nand3_1_0.B a_16558_11727# 0.1356f
C3102 sg13cmos5l_dfrbpq_1_9.Q a_19642_6130# 0.01356f
C3103 sg13cmos5l_nand4_1_3.B sg13cmos5l_inv_1_24.A 0.08104f
C3104 a_20176_7894# VDD 0.13635f
C3105 a_3895_18222# a_4108_18258# 0.23043f
C3106 VDD code5 0.33991f
C3107 a_6756_11464# a_7044_11885# 0.24435f
C3108 a_19173_17519# VDD 0.244f
C3109 sg13cmos5l_mux2_1_1.A1 sg13cmos5l_mux2_1_0.A1 0.56659f
C3110 sg13cmos5l_dfrbpq_1_28.RESET_B bn6 0.57378f
C3111 sg13cmos5l_dfrbpq_1_24.RESET_B a_11288_19061# 0.01507f
C3112 sg13cmos5l_a21oi_1_2.B1 a_17578_11428# 0.03652f
C3113 sg13cmos5l_buf_1_24.A a_11499_18380# 0.04278f
C3114 sg13cmos5l_a21oi_1_2.B1 sg13cmos5l_inv_1_11.Y 0.17709f
C3115 sg13cmos5l_dfrbpq_1_5.CLK sg13cmos5l_inv_1_17.Y 0.04216f
C3116 sg13cmos5l_nor2_1_2.B sg13cmos5l_nand2b_1_3.B 0.04497f
C3117 a_14929_16357# code0 0.01485f
C3118 sg13cmos5l_nand2b_1_1.A_N a_14446_12508# 0.10617f
C3119 a_10864_19990# code5 0.01267f
C3120 sg13cmos5l_nand2_1_15.Y sg13cmos5l_inv_1_8.A 0.25848f
C3121 sg13cmos5l_dfrbpq_1_28.RESET_B a_20682_17508# 0.01225f
C3122 sg13cmos5l_o21ai_1_9.Y sg13cmos5l_dfrbpq_1_24.D 0.01205f
C3123 sg13cmos5l_a21oi_1_18.B1 sg13cmos5l_inv_1_17.Y 0.16918f
C3124 a_7726_10887# sg13cmos5l_dfrbpq_1_14.D 0.1067f
C3125 a_18575_8797# VDD 0.17085f
C3126 sg13cmos5l_inv_1_6.Y a_22235_5412# 0.04594f
C3127 sg13cmos5l_dfrbpq_1_17.Q a_7841_8702# 0.01283f
C3128 sg13cmos5l_inv_1_7.A bp4 0.01724f
C3129 sg13cmos5l_dfrbpq_1_19.CLK a_6670_18447# 0.02947f
C3130 sg13cmos5l_dfrbpq_1_35.Q a_22145_19286# 0.01829f
C3131 sg13cmos5l_dfrbpq_1_13.RESET_B a_10864_5654# 0.09622f
C3132 sg13cmos5l_nor3_1_2.C sg13cmos5l_dfrbpq_1_15.Q 0.22146f
C3133 sg13cmos5l_nand3_1_4.Y clk 0.04234f
C3134 sg13cmos5l_nor4_1_2.Y a_18785_16262# 0.04173f
C3135 sg13cmos5l_inv_1_17.A bp2 0.03477f
C3136 sg13cmos5l_nand4_1_18.B sg13cmos5l_a21oi_1_24.A1 0.04858f
C3137 sg13cmos5l_dlygate4sd3_1_42.A a_6682_8400# 0.28819f
C3138 sg13cmos5l_buf_1_66.X sg13cmos5l_inv_1_24.Y 0.26689f
C3139 sg13cmos5l_buf_1_13.A a_16240_6382# 0.10651f
C3140 sg13cmos5l_nand3_1_0.C VDD 0.40427f
C3141 a_14283_17519# VDD 0.2044f
C3142 sg13cmos5l_o21ai_1_20.A1 a_10774_17886# 0.05975f
C3143 sg13cmos5l_a21oi_1_7.A2 bn9 0.0394f
C3144 sg13cmos5l_nand4_1_3.B a_9176_13726# 0.05793f
C3145 sg13cmos5l_nor3_1_6.Y sg13cmos5l_nand2_1_13.A 2.20263f
C3146 sg13cmos5l_dlygate4sd3_1_50.X sg13cmos5l_dfrbpq_1_19.D 0.01195f
C3147 sg13cmos5l_nand2_1_18.A a_13676_12936# 0.01766f
C3148 sg13cmos5l_nand3b_1_1.C sg13cmos5l_nand3_1_6.C 0.19425f
C3149 a_16950_9972# VDD 0.15926f
C3150 a_16240_6382# a_16650_6460# 0.07015f
C3151 sg13cmos5l_nand4_1_15.B sg13cmos5l_a21oi_1_20.Y 0.02159f
C3152 a_15243_6284# a_15012_6175# 0.07823f
C3153 a_6094_19959# a_6209_19960# 0.3854f
C3154 a_14724_6480# a_15889_6239# 0.25046f
C3155 sg13cmos5l_o21ai_1_1.B1 sg13cmos5l_nor4_1_0.Y 0.17264f
C3156 sg13cmos5l_nand4_1_15.B sg13cmos5l_inv_1_8.A 0.08687f
C3157 a_20272_19262# a_20015_19381# 0.23043f
C3158 bn0 busy 0.35263f
C3159 sg13cmos5l_inv_1_31.A a_21350_17508# 0.05926f
C3160 code1 code0 0.02698f
C3161 sg13cmos5l_a21oi_1_24.A1 code0 0.01967f
C3162 sg13cmos5l_dfrbpq_1_28.RESET_B a_20716_18258# 0.09631f
C3163 sg13cmos5l_nand2_1_0.B a_13566_8412# 0.08787f
C3164 a_18922_5380# VDD 0.09605f
C3165 sg13cmos5l_buf_1_3.A bp5 0.01041f
C3166 sg13cmos5l_nand4_1_7.B bn0 0.01482f
C3167 sg13cmos5l_buf_1_66.X sg13cmos5l_dlygate4sd3_1_45.X 0.0573f
C3168 sg13cmos5l_buf_1_59.A a_15280_16238# 0.04013f
C3169 sg13cmos5l_buf_8_2.A a_21160_12972# 0.01911f
C3170 sg13cmos5l_dfrbpq_1_28.RESET_B sg13cmos5l_a21oi_1_24.Y 0.50959f
C3171 sg13cmos5l_buf_8_2.A sg13cmos5l_o21ai_1_22.Y 0.02106f
C3172 sg13cmos5l_dfrbpq_1_39.Q sg13cmos5l_dfrbpq_1_37.D 0.02201f
C3173 sg13cmos5l_buf_1_21.A sg13cmos5l_inv_1_24.A 0.01052f
C3174 sg13cmos5l_buf_1_26.A sg13cmos5l_o21ai_1_5.A1 0.20105f
C3175 sg13cmos5l_inv_1_24.Y VDD 0.44992f
C3176 sg13cmos5l_buf_1_7.X a_20554_11428# 0.20602f
C3177 a_11019_9959# VDD 0.20582f
C3178 sg13cmos5l_inv_1_1.A sg13cmos5l_a21oi_1_3.A2 0.04917f
C3179 sg13cmos5l_inv_1_32.Y sg13cmos5l_inv_1_25.Y 0.02473f
C3180 sg13cmos5l_buf_1_26.A sg13cmos5l_dlygate4sd3_1_97.X 0.01695f
C3181 sg13cmos5l_buf_1_15.A sg13cmos5l_dfrbpq_1_13.CLK 0.04232f
C3182 sg13cmos5l_dfrbpq_1_19.CLK sg13cmos5l_o21ai_1_20.Y 0.04251f
C3183 a_10365_7194# VDD 0.18998f
C3184 sg13cmos5l_buf_8_2.A sg13cmos5l_nor3_1_7.Y 0.01698f
C3185 sg13cmos5l_buf_1_45.X a_13679_19381# 0.15608f
C3186 sg13cmos5l_buf_1_1.A sg13cmos5l_inv_1_17.Y 0.04688f
C3187 sg13cmos5l_mux2_1_1.A1 a_11388_14020# 0.01804f
C3188 sg13cmos5l_a21oi_1_1.A2 sg13cmos5l_buf_1_8.A 0.01351f
C3189 a_20580_8440# a_20868_8861# 0.24435f
C3190 sg13cmos5l_inv_1_1.A a_17098_6130# 0.01563f
C3191 sg13cmos5l_dlygate4sd3_1_45.X VDD 0.38542f
C3192 sg13cmos5l_a21oi_1_25.A2 sg13cmos5l_buf_1_43.X 0.04571f
C3193 sg13cmos5l_dfrbpq_1_30.D a_21911_16043# 0.16658f
C3194 sg13cmos5l_a21oi_1_4.A2 sg13cmos5l_buf_1_57.A 0.04279f
C3195 a_18374_7674# a_19077_7653# 0.02453f
C3196 VDD bn7 0.1998f
C3197 sg13cmos5l_buf_8_2.A sg13cmos5l_a21oi_1_16.A2 0.03271f
C3198 sg13cmos5l_o21ai_1_18.B1 sg13cmos5l_nand3b_1_1.C 1.06842f
C3199 sg13cmos5l_nor3_1_4.A a_10016_13854# 0.02235f
C3200 a_21063_16964# a_21911_17137# 0.07916f
C3201 sg13cmos5l_inv_1_4.Y a_17386_6892# 0.03f
C3202 sg13cmos5l_inv_1_13.Y a_18490_9154# 0.05822f
C3203 sg13cmos5l_a21oi_1_18.B1 a_15494_18258# 0.02966f
C3204 sg13cmos5l_buf_1_10.A bp4 0.04721f
C3205 a_10878_7180# sg13cmos5l_a21oi_1_9.A2 0.06937f
C3206 sg13cmos5l_buf_1_10.A a_22522_3864# 0.01476f
C3207 sg13cmos5l_nand3_1_5.Y sg13cmos5l_a21oi_1_4.A1 0.17088f
C3208 sg13cmos5l_buf_8_2.A sg13cmos5l_inv_1_16.Y 0.01788f
C3209 sg13cmos5l_buf_1_13.X a_21099_9959# 0.28008f
C3210 sg13cmos5l_dlygate4sd3_1_28.A VDD 0.31917f
C3211 a_4607_18528# a_5397_18416# 0.02241f
C3212 a_4455_18476# a_4476_18222# 0.20754f
C3213 sg13cmos5l_a21oi_1_25.Y sg13cmos5l_dfrbpq_1_39.Q 0.02319f
C3214 a_7275_11471# a_8272_11702# 0.03546f
C3215 sg13cmos5l_nand4_1_1.B sg13cmos5l_nand4_1_18.A 0.02517f
C3216 sg13cmos5l_a21oi_1_4.A1 sg13cmos5l_o21ai_1_1.B1 0.17762f
C3217 a_20272_17750# VDD 0.13701f
C3218 sg13cmos5l_buf_1_15.A a_9464_17549# 0.0199f
C3219 sg13cmos5l_nand4_1_15.B bp0 0.0115f
C3220 sg13cmos5l_nand2_1_9.Y sg13cmos5l_a21o_1_2.B1 0.19781f
C3221 a_22241_4166# bp3 0.01157f
C3222 sg13cmos5l_o21ai_1_5.A1 sg13cmos5l_a21o_1_2.X 0.02607f
C3223 sg13cmos5l_dfrbpq_1_24.RESET_B sg13cmos5l_dfrbpq_1_23.D 0.096f
C3224 sg13cmos5l_dfrbpq_1_5.CLK a_20997_13701# 0.21742f
C3225 sg13cmos5l_buf_1_42.A a_16742_15234# 0.01926f
C3226 sg13cmos5l_inv_1_36.A a_11674_12936# 0.013f
C3227 sg13cmos5l_dfrbpq_1_28.RESET_B sg13cmos5l_dfrbpq_1_30.D 0.02388f
C3228 sg13cmos5l_a21oi_1_2.B1 sg13cmos5l_buf_1_4.A 0.24997f
C3229 sg13cmos5l_nand4_1_1.B sg13cmos5l_o21ai_1_24.Y 0.6211f
C3230 a_18021_11471# VDD 0.24624f
C3231 sg13cmos5l_a21oi_1_14.Y a_22005_16043# 0.02344f
C3232 sg13cmos5l_a21oi_1_18.B1 a_20997_13701# 0.01471f
C3233 sg13cmos5l_dfrbpq_1_40.Q a_20225_19960# 0.01893f
C3234 a_16068_18271# code1 0.01089f
C3235 sg13cmos5l_nor3_1_4.A sg13cmos5l_mux2_1_0.A1 0.39991f
C3236 sg13cmos5l_o21ai_1_25.B1 a_16078_19287# 0.01631f
C3237 sg13cmos5l_inv_1_5.A a_17733_8447# 0.19289f
C3238 sg13cmos5l_dfrbpq_1_24.RESET_B sg13cmos5l_o21ai_1_15.B1 0.03327f
C3239 sg13cmos5l_a21oi_1_2.B1 sg13cmos5l_inv_1_3.Y 1.38899f
C3240 a_17030_8874# a_17733_8447# 0.02431f
C3241 a_15607_9150# a_16167_9404# 0.17382f
C3242 a_15208_12972# VDD 0.20513f
C3243 sg13cmos5l_o21ai_1_18.B1 sg13cmos5l_nand3_1_5.Y 0.03143f
C3244 sg13cmos5l_inv_1_8.A sg13cmos5l_nand2_1_0.A 0.6442f
C3245 sg13cmos5l_inv_1_17.Y bn9 0.0611f
C3246 a_15804_7638# VDD 0.07326f
C3247 sg13cmos5l_a21oi_1_8.A2 a_7199_6432# 0.01588f
C3248 sg13cmos5l_dfrbpq_1_38.Q VDD 0.40878f
C3249 sg13cmos5l_nand3b_1_3.C sg13cmos5l_o21ai_1_23.B1 0.33614f
C3250 a_21358_5679# VDD 0.16032f
C3251 sg13cmos5l_nor2b_1_1.A sg13cmos5l_nand4_1_7.B 0.02406f
C3252 sg13cmos5l_buf_1_45.X sg13cmos5l_a21oi_1_26.A1 0.06409f
C3253 a_20384_18433# VDD 0.27594f
C3254 a_13096_15996# sg13cmos5l_dlygate4sd3_1_80.X 0.0216f
C3255 a_13590_11484# a_13478_11460# 0.3854f
C3256 a_20682_19020# sg13cmos5l_dfrbpq_1_35.Q 0.08095f
C3257 sg13cmos5l_nand2_1_0.A sg13cmos5l_a22oi_1_2.Y 0.02766f
C3258 sg13cmos5l_inv_1_15.A sg13cmos5l_a21oi_1_20.A2 0.01316f
C3259 a_20464_5654# VDD 0.13568f
C3260 sg13cmos5l_a21oi_1_2.Y a_21832_7806# 0.04313f
C3261 a_22126_7863# a_22241_7864# 0.3854f
C3262 sg13cmos5l_o21ai_1_20.B1 sg13cmos5l_o21ai_1_14.Y 0.03099f
C3263 a_18730_18988# sg13cmos5l_a21oi_1_19.Y 0.01438f
C3264 sg13cmos5l_buf_1_26.A sg13cmos5l_o21ai_1_5.A2 0.21093f
C3265 a_10696_15272# bn3 0.15437f
C3266 a_12808_10034# VDD 0.13267f
C3267 sg13cmos5l_buf_1_45.X sg13cmos5l_buf_1_25.A 0.45828f
C3268 sg13cmos5l_buf_8_2.A a_10980_18576# 0.01077f
C3269 a_21185_7864# a_21466_7642# 0.18796f
C3270 sg13cmos5l_buf_8_2.A a_21099_12332# 0.02914f
C3271 sg13cmos5l_a21oi_1_15.A2 bp0 0.99877f
C3272 sg13cmos5l_buf_1_45.X a_16193_19286# 0.01689f
C3273 a_20554_14452# a_20580_14488# 0.24169f
C3274 a_4360_19808# a_4168_19902# 0.01225f
C3275 sg13cmos5l_buf_1_7.X a_22096_11702# 0.09622f
C3276 a_12987_10318# VDD 0.91092f
C3277 sg13cmos5l_dfrbpq_1_41.CLK sg13cmos5l_a21oi_1_4.A2 0.02738f
C3278 sg13cmos5l_nor2_1_15.Y a_14038_16742# 0.06988f
C3279 sg13cmos5l_a21oi_1_0.A2 sg13cmos5l_inv_1_4.Y 0.0254f
C3280 sg13cmos5l_nand4_1_1.B sg13cmos5l_a21oi_1_27.A1 0.10617f
C3281 sg13cmos5l_buf_1_45.X sg13cmos5l_a21oi_1_26.Y 0.03356f
C3282 sg13cmos5l_dfrbpq_1_19.CLK a_4031_15967# 0.20356f
C3283 sg13cmos5l_inv_1_15.A sg13cmos5l_dlygate4sd3_1_74.A 0.02838f
C3284 sg13cmos5l_buf_8_2.A code1 0.02682f
C3285 sg13cmos5l_a21oi_1_4.A2 sg13cmos5l_nand4_1_1.A 0.10572f
C3286 sg13cmos5l_buf_8_2.A sg13cmos5l_a21oi_1_24.A1 0.05558f
C3287 sg13cmos5l_o21ai_1_19.Y VDD 0.43056f
C3288 sg13cmos5l_dfrbpq_1_13.CLK sg13cmos5l_a21oi_1_9.A2 0.4686f
C3289 sg13cmos5l_a21oi_1_17.Y sg13cmos5l_a21oi_1_20.A2 0.22858f
C3290 a_21099_8447# a_22096_8678# 0.03546f
C3291 sg13cmos5l_nand4_1_15.B sg13cmos5l_nand4_1_16.D 0.01503f
C3292 sg13cmos5l_a21oi_1_26.A1 a_16299_18380# 0.03733f
C3293 sg13cmos5l_inv_1_17.Y sg13cmos5l_buf_1_2.A 0.01768f
C3294 sg13cmos5l_nand2_1_0.B sg13cmos5l_inv_1_18.Y 0.15646f
C3295 sg13cmos5l_nand3_1_2.Y a_13478_11460# 0.0235f
C3296 a_18660_7992# a_19919_7751# 0.01412f
C3297 a_21215_18528# sg13cmos5l_inv_1_25.Y 0.01205f
C3298 a_3628_16746# VDD 0.13727f
C3299 a_21084_16710# a_20974_16746# 0.25046f
C3300 a_7238_17508# VDD 0.20825f
C3301 sg13cmos5l_a21oi_1_25.Y a_18756_19024# 0.0446f
C3302 sg13cmos5l_a21oi_1_5.A2 sg13cmos5l_a21oi_1_0.Y 0.01145f
C3303 a_21911_18649# bn4 0.01113f
C3304 a_6671_7751# VDD 0.17467f
C3305 sg13cmos5l_dfrbpq_1_29.D a_20012_14448# 0.03254f
C3306 a_5303_18649# sg13cmos5l_dfrbpq_1_20.D 0.16645f
C3307 sg13cmos5l_dfrbpq_1_13.RESET_B a_9636_12528# 0.26993f
C3308 a_9610_12433# a_10053_12189# 0.02241f
C3309 a_21462_17532# VDD 0.15877f
C3310 sg13cmos5l_dfrbpq_1_24.RESET_B a_10694_18258# 0.08999f
C3311 sg13cmos5l_dfrbpq_1_24.Q sg13cmos5l_nand2_1_13.A 0.02675f
C3312 sg13cmos5l_a21oi_1_16.A2 sg13cmos5l_a21oi_1_15.Y 0.09872f
C3313 a_21256_3176# bp3 0.15674f
C3314 a_13958_19770# a_14244_20088# 0.26205f
C3315 sg13cmos5l_dfrbpq_1_11.Q a_19829_8436# 0.01581f
C3316 sg13cmos5l_a21oi_1_5.A2 sg13cmos5l_buf_1_5.A 0.03957f
C3317 a_10214_10386# a_10917_9959# 0.02431f
C3318 a_21084_16357# bn6 0.01794f
C3319 a_8520_8436# a_8859_8436# 0.01986f
C3320 sg13cmos5l_inv_1_15.Y sg13cmos5l_nand2_1_1.Y 0.0337f
C3321 sg13cmos5l_dfrbpq_1_7.D VDD 0.24826f
C3322 sg13cmos5l_a21oi_1_3.A2 a_16188_9150# 0.04674f
C3323 sg13cmos5l_nand4_1_5.D sg13cmos5l_a21oi_1_20.A2 0.06599f
C3324 sg13cmos5l_inv_1_16.Y sg13cmos5l_a21oi_1_15.Y 0.01895f
C3325 a_18863_11821# VDD 0.17578f
C3326 sg13cmos5l_buf_1_15.A sg13cmos5l_mux2_1_0.A1 0.57576f
C3327 sg13cmos5l_buf_1_16.A sg13cmos5l_nor3_1_7.Y 0.09757f
C3328 sg13cmos5l_o21ai_1_9.Y a_5554_13718# 0.06779f
C3329 a_17733_8447# a_17604_8861# 0.01562f
C3330 sg13cmos5l_buf_1_13.A a_17015_9577# 0.07632f
C3331 a_17316_8440# a_17835_8447# 0.20754f
C3332 sg13cmos5l_inv_1_15.A sg13cmos5l_dfrbpq_1_29.D 0.01167f
C3333 sg13cmos5l_a21oi_1_2.B1 sg13cmos5l_inv_1_2.A 0.39721f
C3334 sg13cmos5l_dfrbpq_1_14.D sg13cmos5l_dlygate4sd3_1_38.X 0.02257f
C3335 sg13cmos5l_dfrbpq_1_41.CLK sg13cmos5l_buf_1_57.A 0.04865f
C3336 sg13cmos5l_buf_1_66.X sg13cmos5l_nand2_1_18.A 0.05942f
C3337 sg13cmos5l_buf_1_15.A bn6 0.36344f
C3338 sg13cmos5l_inv_1_36.A sg13cmos5l_a21oi_1_27.A2 0.01812f
C3339 sg13cmos5l_nand4_1_18.D sg13cmos5l_a21oi_1_3.A2 0.02978f
C3340 sg13cmos5l_a21oi_1_2.B1 sg13cmos5l_dlygate4sd3_1_13.X 0.11171f
C3341 sg13cmos5l_dfrbpq_1_13.RESET_B a_6383_9263# 0.11161f
C3342 a_20580_9952# VDD 0.0733f
C3343 a_19246_6351# a_19361_6352# 0.3854f
C3344 sg13cmos5l_dlygate4sd3_1_3.A bp3 0.01734f
C3345 a_14446_12508# VDD 0.1035f
C3346 a_21911_18649# VDD 0.52273f
C3347 sg13cmos5l_dfrbpq_1_24.RESET_B a_4568_15238# 0.05594f
C3348 sg13cmos5l_nor2_1_2.B a_8006_7678# 0.01611f
C3349 sg13cmos5l_dfrbpq_1_34.Q a_21838_19959# 0.01764f
C3350 sg13cmos5l_o21ai_1_19.B1 a_7954_17886# 0.09504f
C3351 sg13cmos5l_a21oi_1_27.B1 a_9185_18448# 0.03297f
C3352 sg13cmos5l_nand2b_1_1.A_N a_13505_7864# 0.01991f
C3353 sg13cmos5l_nand3_1_0.C a_16566_8460# 0.03585f
C3354 sg13cmos5l_dfrbpq_1_35.Q a_21080_19061# 0.06641f
C3355 a_17338_18984# valid 0.03081f
C3356 sg13cmos5l_buf_1_26.A a_17825_17774# 0.01792f
C3357 a_6490_19738# sg13cmos5l_dfrbpq_1_25.Q 0.27025f
C3358 sg13cmos5l_inv_1_32.Y sg13cmos5l_nand3b_1_3.C 0.01417f
C3359 sg13cmos5l_nor2b_1_0.B_N a_15208_9318# 0.07247f
C3360 a_20272_19262# sg13cmos5l_a21oi_1_19.Y 0.01261f
C3361 sg13cmos5l_and2_1_3.X sg13cmos5l_inv_1_12.A 0.02209f
C3362 a_13764_17512# a_14181_17519# 0.28418f
C3363 a_13478_17946# a_14052_17933# 0.18486f
C3364 sg13cmos5l_a21oi_1_9.Y a_9765_5423# 0.01993f
C3365 sg13cmos5l_buf_8_2.A bp1 0.33557f
C3366 sg13cmos5l_nand2_1_18.A VDD 0.85797f
C3367 sg13cmos5l_dfrbpq_1_5.CLK sg13cmos5l_a21oi_1_6.A2 0.35102f
C3368 sg13cmos5l_buf_1_24.A sg13cmos5l_dlygate4sd3_1_65.A 0.01885f
C3369 a_20580_14488# a_21839_14845# 0.01412f
C3370 sg13cmos5l_nand2_1_19.Y sg13cmos5l_buf_1_14.A 0.11761f
C3371 sg13cmos5l_dfrbpq_1_5.CLK sg13cmos5l_inv_1_15.A 0.07844f
C3372 sg13cmos5l_a21oi_1_27.B1 a_4838_15238# 0.01384f
C3373 sg13cmos5l_a21oi_1_18.B1 sg13cmos5l_inv_1_15.A 0.22034f
C3374 sg13cmos5l_buf_8_2.A sg13cmos5l_o21ai_1_19.B1 0.01858f
C3375 sg13cmos5l_o21ai_1_21.A2 a_3975_16964# 0.04218f
C3376 sg13cmos5l_buf_1_8.A bp8 0.03344f
C3377 sg13cmos5l_nand4_1_18.B sg13cmos5l_a21oi_1_3.A2 0.01525f
C3378 sg13cmos5l_buf_1_45.X a_13574_18262# 0.01491f
C3379 sg13cmos5l_nor4_1_0.Y sg13cmos5l_dlygate4sd3_1_9.A 0.01631f
C3380 sg13cmos5l_inv_1_5.A sg13cmos5l_nand2b_1_3.B 0.26643f
C3381 sg13cmos5l_a21oi_1_21.A1 sg13cmos5l_a21oi_1_18.B1 0.05169f
C3382 sg13cmos5l_inv_1_18.A sg13cmos5l_nand3b_1_0.C 0.51998f
C3383 a_6209_19960# code6 0.01968f
C3384 sg13cmos5l_buf_1_26.A a_13764_17512# 0.02165f
C3385 sg13cmos5l_nand2b_1_3.Y sg13cmos5l_dfrbpq_1_13.Q 0.04301f
C3386 sg13cmos5l_a21oi_1_21.A1 sg13cmos5l_dlygate4sd3_1_82.A 0.07118f
C3387 sg13cmos5l_a21oi_1_0.A2 sg13cmos5l_nand3_1_0.Y 0.03709f
C3388 a_4454_14922# a_5157_14495# 0.02431f
C3389 sg13cmos5l_dlygate4sd3_1_50.X sg13cmos5l_o21ai_1_21.Y 0.02342f
C3390 sg13cmos5l_o21ai_1_0.A2 a_12430_6980# 0.01871f
C3391 a_18660_7992# a_19825_7751# 0.25046f
C3392 a_22005_18416# sg13cmos5l_inv_1_25.Y 0.03394f
C3393 a_19179_7796# a_18948_7687# 0.07823f
C3394 sg13cmos5l_buf_1_15.A sg13cmos5l_o21ai_1_3.A2 0.01133f
C3395 sg13cmos5l_buf_1_10.A sg13cmos5l_nand3_1_0.A 1.54161f
C3396 a_6094_16935# VDD 0.15999f
C3397 sg13cmos5l_nand4_1_6.B sg13cmos5l_buf_1_20.A 0.07737f
C3398 sg13cmos5l_dfrbpq_1_13.CLK sg13cmos5l_a21o_1_0.X 0.01579f
C3399 sg13cmos5l_a21oi_1_25.Y a_20015_19381# 0.01103f
C3400 sg13cmos5l_and2_1_3.X sg13cmos5l_nand2_1_13.A 0.43801f
C3401 sg13cmos5l_inv_1_1.Y a_20503_16710# 0.01577f
C3402 a_18730_17476# a_19173_17519# 0.02241f
C3403 sg13cmos5l_buf_1_9.A a_21099_9959# 0.01684f
C3404 sg13cmos5l_a21oi_1_4.A2 sg13cmos5l_and2_1_5.X 0.01051f
C3405 sg13cmos5l_o21ai_1_0.A1 a_12902_8436# 0.01343f
C3406 sg13cmos5l_o21ai_1_0.A2 a_12344_6166# 0.02684f
C3407 sg13cmos5l_a21oi_1_18.B1 sg13cmos5l_a21oi_1_17.Y 0.34455f
C3408 sg13cmos5l_buf_1_42.A sg13cmos5l_a21oi_1_13.Y 0.01077f
C3409 sg13cmos5l_nand4_1_12.Y a_17706_18556# 0.06211f
C3410 sg13cmos5l_buf_1_47.X a_13294_16935# 0.01328f
C3411 sg13cmos5l_dfrbpq_1_13.RESET_B a_10895_12287# 0.10875f
C3412 sg13cmos5l_dfrbpq_1_24.RESET_B a_12496_18478# 0.09962f
C3413 sg13cmos5l_nand3_1_2.Y a_13880_10706# 0.01443f
C3414 sg13cmos5l_inv_1_11.Y a_19077_7653# 0.02169f
C3415 a_15754_18481# a_15494_18258# 0.45119f
C3416 sg13cmos5l_mux2_1_1.A1 a_8911_12508# 0.01194f
C3417 sg13cmos5l_nor3_1_6.Y sg13cmos5l_nand4_1_18.C 0.40227f
C3418 sg13cmos5l_a21oi_1_2.B1 a_20997_6935# 0.01744f
C3419 sg13cmos5l_buf_1_16.A code1 0.1867f
C3420 sg13cmos5l_a21oi_1_24.A1 sg13cmos5l_buf_1_16.A 0.13343f
C3421 sg13cmos5l_buf_1_1.A sg13cmos5l_a21oi_1_6.A2 0.02159f
C3422 sg13cmos5l_dlygate4sd3_1_72.A a_18756_17512# 0.01818f
C3423 sg13cmos5l_dfrbpq_1_30.D a_21084_16357# 0.02596f
C3424 a_17835_8447# a_18575_8797# 0.17382f
C3425 sg13cmos5l_dfrbpq_1_38.Q a_16064_17594# 0.01341f
C3426 sg13cmos5l_inv_1_15.A sg13cmos5l_buf_1_1.A 0.0135f
C3427 sg13cmos5l_buf_1_15.A sg13cmos5l_nand3b_1_1.C 0.01193f
C3428 sg13cmos5l_dfrbpq_1_15.Q a_9640_7010# 0.04262f
C3429 a_8830_17874# sg13cmos5l_buf_1_65.A 0.11575f
C3430 a_14253_13320# sg13cmos5l_nand3_1_2.A 0.08135f
C3431 sg13cmos5l_buf_1_45.X a_14253_13320# 0.01558f
C3432 a_7841_10888# a_8122_10666# 0.18796f
C3433 sg13cmos5l_a21oi_1_18.B1 sg13cmos5l_nand4_1_5.D 0.29773f
C3434 a_8122_8400# a_7841_8702# 0.18796f
C3435 sg13cmos5l_dfrbpq_1_5.CLK sg13cmos5l_a21oi_1_1.A2 0.41841f
C3436 sg13cmos5l_a21oi_1_9.A1 a_10513_5773# 0.01575f
C3437 sg13cmos5l_buf_1_15.A sg13cmos5l_dfrbpq_1_30.D 0.11926f
C3438 sg13cmos5l_a21oi_1_18.B1 sg13cmos5l_a21oi_1_1.A2 0.02958f
C3439 sg13cmos5l_o21ai_1_0.B1 a_13042_4646# 0.06947f
C3440 sg13cmos5l_buf_1_16.A a_17931_6935# 0.05373f
C3441 sg13cmos5l_nand4_1_12.Y valid 0.03536f
C3442 a_21080_19061# a_21350_19020# 0.18796f
C3443 sg13cmos5l_inv_1_15.A a_18544_15454# 0.01083f
C3444 sg13cmos5l_nand3_1_0.B sg13cmos5l_nand3_1_0.A 0.56576f
C3445 sg13cmos5l_o21ai_1_10.B1 a_6286_16263# 0.12427f
C3446 sg13cmos5l_o21ai_1_20.Y a_3895_18222# 0.01994f
C3447 sg13cmos5l_buf_1_24.A code2 0.01964f
C3448 sg13cmos5l_a21oi_1_9.Y a_10513_5773# 0.01675f
C3449 a_7334_10386# a_7620_9952# 0.26205f
C3450 sg13cmos5l_inv_1_3.Y a_17521_5773# 0.01487f
C3451 a_21839_4727# bp1 0.03041f
C3452 sg13cmos5l_buf_8_2.A a_6756_11464# 0.01204f
C3453 a_21839_14845# a_22506_14484# 0.09257f
C3454 a_20294_13722# a_20580_14040# 0.26205f
C3455 sg13cmos5l_nand2b_1_1.A_N sg13cmos5l_inv_1_18.A 0.02422f
C3456 sg13cmos5l_dfrbpq_1_34.Q sg13cmos5l_dfrbpq_1_40.Q 1.03927f
C3457 sg13cmos5l_nor2b_1_0.B_N a_15592_10736# 0.01622f
C3458 sg13cmos5l_dlygate4sd3_1_33.X a_5416_9948# 0.18685f
C3459 sg13cmos5l_o21ai_1_7.A2 sg13cmos5l_o21ai_1_20.A1 0.01896f
C3460 sg13cmos5l_inv_1_17.A a_20997_11471# 0.01398f
C3461 sg13cmos5l_dfrbpq_1_37.D a_21866_16904# 0.01829f
C3462 sg13cmos5l_nor3_1_0.Y sg13cmos5l_nor2b_1_0.B_N 0.34508f
C3463 a_20580_14488# bn6 0.04284f
C3464 sg13cmos5l_buf_1_15.A sg13cmos5l_o21ai_1_1.B1 0.02008f
C3465 sg13cmos5l_o21ai_1_7.B1 a_6209_19960# 0.01703f
C3466 sg13cmos5l_a21oi_1_8.Y sg13cmos5l_nor2_1_2.Y 0.14591f
C3467 sg13cmos5l_buf_1_45.X a_15780_18576# 0.30544f
C3468 sg13cmos5l_inv_1_1.A sg13cmos5l_a21oi_1_2.A2 0.05454f
C3469 a_5386_7897# a_5126_7674# 0.45119f
C3470 sg13cmos5l_dlygate4sd3_1_28.A sg13cmos5l_a21oi_1_2.Y 0.03275f
C3471 sg13cmos5l_buf_1_26.A a_15023_17869# 0.01611f
C3472 sg13cmos5l_o21ai_1_25.Y a_14218_18226# 0.02038f
C3473 sg13cmos5l_inv_1_4.Y a_21363_9212# 0.01159f
C3474 a_4740_14488# sg13cmos5l_dfrbpq_1_15.CLK 0.05959f
C3475 a_5157_14495# a_5028_14909# 0.01562f
C3476 a_7937_19960# a_7941_19031# 0.01248f
C3477 a_18662_5850# a_18922_5380# 0.45119f
C3478 sg13cmos5l_inv_1_1.A sg13cmos5l_a21oi_1_6.A2 0.02257f
C3479 a_19542_9254# sg13cmos5l_dfrbpq_1_6.D 0.10673f
C3480 a_19919_7751# a_19825_7751# 0.16704f
C3481 sg13cmos5l_buf_1_47.X bn0 0.07778f
C3482 sg13cmos5l_a21o_1_2.X a_4264_14570# 0.04058f
C3483 sg13cmos5l_nand2_1_15.B sg13cmos5l_inv_1_8.A 0.05958f
C3484 sg13cmos5l_inv_1_15.A sg13cmos5l_inv_1_1.A 0.10561f
C3485 sg13cmos5l_dlygate4sd3_1_64.X sg13cmos5l_dfrbpq_1_23.Q 0.3879f
C3486 sg13cmos5l_dlygate4sd3_1_15.X a_14350_10215# 0.03357f
C3487 sg13cmos5l_nand3_1_0.A a_12022_8814# 0.10283f
C3488 sg13cmos5l_buf_1_54.A bn6 0.0105f
C3489 a_18756_17512# a_19275_17519# 0.20754f
C3490 a_19173_17519# a_19044_17933# 0.01562f
C3491 a_8200_12342# VDD 0.13556f
C3492 sg13cmos5l_o21ai_1_7.B1 sg13cmos5l_dfrbpq_1_20.D 0.09452f
C3493 sg13cmos5l_buf_8_2.A sg13cmos5l_a21oi_1_7.A2 0.01466f
C3494 sg13cmos5l_buf_1_1.A sg13cmos5l_a21oi_1_1.A2 0.03172f
C3495 a_19829_3900# VDD 0.16176f
C3496 sg13cmos5l_o21ai_1_23.B1 bn2 1.00072f
C3497 sg13cmos5l_nand4_1_17.Y sg13cmos5l_dfrbpq_1_30.Q 0.01935f
C3498 sg13cmos5l_dlygate4sd3_1_50.X a_4838_15238# 0.01551f
C3499 sg13cmos5l_buf_1_1.A a_20997_4629# 0.013f
C3500 sg13cmos5l_nand3_1_8.Y sg13cmos5l_a21oi_1_23.A2 0.01409f
C3501 sg13cmos5l_buf_8_2.A sg13cmos5l_a21oi_1_3.A2 0.06584f
C3502 a_10917_9959# a_11665_10309# 0.01058f
C3503 a_15780_18576# a_16299_18380# 0.20773f
C3504 sg13cmos5l_a21oi_1_27.A2 sg13cmos5l_mux2_1_1.A0 0.02022f
C3505 sg13cmos5l_nor2_1_10.Y a_11116_17044# 0.01315f
C3506 sg13cmos5l_a21oi_1_2.A2 sg13cmos5l_buf_1_2.A 0.15371f
C3507 a_19930_12936# VDD 0.25929f
C3508 sg13cmos5l_nand4_1_7.B a_17051_15996# 0.02228f
C3509 sg13cmos5l_and4_1_0.D a_10878_7180# 0.15115f
C3510 sg13cmos5l_buf_1_45.X a_13690_16714# 0.07322f
C3511 sg13cmos5l_nand4_1_1.C sg13cmos5l_a21oi_1_23.A2 0.10131f
C3512 sg13cmos5l_a21oi_1_2.B1 a_22096_7166# 0.02337f
C3513 sg13cmos5l_or2_1_1.X sg13cmos5l_o21ai_1_0.A1 0.17631f
C3514 sg13cmos5l_dlygate4sd3_1_72.A a_19275_17519# 0.03864f
C3515 sg13cmos5l_inv_1_1.A sg13cmos5l_a21oi_1_17.Y 0.03598f
C3516 a_12597_11722# clk 0.01766f
C3517 sg13cmos5l_nand3b_1_3.C a_6760_17594# 0.05895f
C3518 a_17015_9577# a_17109_9344# 0.45119f
C3519 sg13cmos5l_a21oi_1_20.Y a_17792_14570# 0.03825f
C3520 a_19733_6924# VDD 0.16081f
C3521 sg13cmos5l_buf_8_2.A a_17098_6130# 0.32115f
C3522 sg13cmos5l_buf_1_13.A a_18587_4948# 0.01388f
C3523 sg13cmos5l_or4_1_0.C sg13cmos5l_o21ai_1_6.Y 0.27556f
C3524 sg13cmos5l_dfrbpq_1_15.Q sg13cmos5l_a21oi_1_10.A2 0.07112f
C3525 sg13cmos5l_nor3_1_2.B sg13cmos5l_dlygate4sd3_1_42.A 0.0303f
C3526 sg13cmos5l_nor3_1_6.Y sg13cmos5l_inv_1_8.A 0.02206f
C3527 sg13cmos5l_dlygate4sd3_1_29.A VDD 0.32006f
C3528 a_22523_15532# VDD 0.16047f
C3529 sg13cmos5l_a21oi_1_24.Y a_18470_17946# 0.01221f
C3530 sg13cmos5l_a21o_1_1.A2 a_8785_10309# 0.01919f
C3531 sg13cmos5l_o21ai_1_25.Y sg13cmos5l_buf_1_45.X 1.01789f
C3532 sg13cmos5l_nand3_1_0.C sg13cmos5l_inv_1_11.Y 0.02001f
C3533 sg13cmos5l_nand4_1_15.B a_18296_13338# 0.01426f
C3534 sg13cmos5l_dfrbpq_1_9.D a_16631_8065# 0.01266f
C3535 sg13cmos5l_inv_1_36.A sg13cmos5l_inv_1_36.Y 0.05503f
C3536 a_19829_3900# bp6 0.03939f
C3537 a_18874_9912# a_18593_10214# 0.18796f
C3538 a_15104_7849# a_15436_7674# 0.07015f
C3539 sg13cmos5l_inv_1_8.A sg13cmos5l_inv_1_9.Y 0.01722f
C3540 sg13cmos5l_buf_1_13.X VDD 4.47575f
C3541 sg13cmos5l_inv_1_9.Y sg13cmos5l_dlygate4sd3_1_25.A 0.12522f
C3542 sg13cmos5l_a21oi_1_1.A2 bn9 0.02132f
C3543 sg13cmos5l_a21oi_1_2.B1 a_17622_10766# 0.01019f
C3544 sg13cmos5l_dfrbpq_1_35.Q sg13cmos5l_inv_1_15.A 0.01302f
C3545 sg13cmos5l_dlygate4sd3_1_64.X sg13cmos5l_dlygate4sd3_1_62.A 0.19337f
C3546 a_15023_17869# a_15690_17508# 0.09257f
C3547 sg13cmos5l_buf_1_66.X sg13cmos5l_nand2_1_11.B 0.02672f
C3548 a_19035_16750# bn5 0.02075f
C3549 sg13cmos5l_a21oi_1_18.B1 sg13cmos5l_dlygate4sd3_1_76.A 1.21934f
C3550 sg13cmos5l_nor4_1_2.Y sg13cmos5l_buf_1_57.A 0.14632f
C3551 sg13cmos5l_inv_1_15.Y sg13cmos5l_dfrbpq_1_13.CLK 0.02276f
C3552 a_21754_5376# a_21473_5678# 0.18796f
C3553 a_7620_9952# a_7908_10373# 0.24435f
C3554 sg13cmos5l_dfrbpq_1_24.RESET_B a_4607_18528# 0.06277f
C3555 a_14218_18226# valid 0.02407f
C3556 sg13cmos5l_inv_1_5.A sg13cmos5l_dfrbpq_1_2.D 0.03259f
C3557 sg13cmos5l_nand4_1_5.D sg13cmos5l_inv_1_1.A 0.03367f
C3558 sg13cmos5l_dlygate4sd3_1_82.X a_16942_19287# 0.10673f
C3559 a_14328_7992# VDD 0.01784f
C3560 a_4821_16043# a_4727_16043# 0.45119f
C3561 sg13cmos5l_inv_1_1.A sg13cmos5l_a21oi_1_1.A2 0.04814f
C3562 sg13cmos5l_nor2_1_7.Y sg13cmos5l_a21oi_1_4.A1 0.12409f
C3563 a_13505_7864# VDD 0.20789f
C3564 sg13cmos5l_nand2b_1_0.B sg13cmos5l_buf_1_14.A 0.46104f
C3565 sg13cmos5l_buf_1_20.A bn4 0.0284f
C3566 a_14842_11424# sg13cmos5l_nor2b_1_0.B_N 0.28306f
C3567 sg13cmos5l_inv_1_15.A a_22005_16904# 0.01377f
C3568 a_21839_10309# bp1 0.01962f
C3569 sg13cmos5l_nand2_1_11.B VDD 0.78623f
C3570 sg13cmos5l_buf_1_66.X sg13cmos5l_buf_1_20.A 0.02898f
C3571 sg13cmos5l_a21oi_1_27.B1 a_9040_19262# 0.03435f
C3572 sg13cmos5l_buf_1_26.A sg13cmos5l_a21oi_1_24.Y 0.75007f
C3573 sg13cmos5l_a21oi_1_13.A2 sg13cmos5l_inv_1_17.Y 0.13049f
C3574 sg13cmos5l_o21ai_1_20.A1 sg13cmos5l_nand3b_1_1.C 0.18109f
C3575 sg13cmos5l_nor2_1_3.Y sg13cmos5l_nor2b_1_0.B_N 0.07224f
C3576 sg13cmos5l_buf_8_2.A sg13cmos5l_inv_1_17.Y 0.0785f
C3577 sg13cmos5l_nand4_1_18.B sg13cmos5l_a21oi_1_12.Y 0.08711f
C3578 sg13cmos5l_buf_1_7.X a_21185_7864# 0.01191f
C3579 a_20974_6351# bp2 0.01058f
C3580 a_3319_15960# a_3532_16434# 0.23043f
C3581 sg13cmos5l_o21ai_1_17.B1 sg13cmos5l_buf_1_24.A 0.06043f
C3582 a_5800_16878# VDD 0.14322f
C3583 sg13cmos5l_dfrbpq_1_13.CLK sg13cmos5l_and4_1_0.D 0.05794f
C3584 a_19720_3176# VDD 0.17821f
C3585 sg13cmos5l_nor3_1_6.Y bp0 0.01382f
C3586 sg13cmos5l_nand4_1_18.A sg13cmos5l_inv_1_12.Y 0.01794f
C3587 sg13cmos5l_a21oi_1_25.Y sg13cmos5l_a21oi_1_19.Y 0.13187f
C3588 sg13cmos5l_buf_1_43.X sg13cmos5l_nand3_1_8.Y 0.21639f
C3589 sg13cmos5l_buf_1_7.X a_21099_8447# 0.28002f
C3590 sg13cmos5l_a21oi_1_0.A2 sg13cmos5l_inv_1_0.Y 0.11983f
C3591 sg13cmos5l_a21oi_1_5.A2 sg13cmos5l_dlygate4sd3_1_18.A 0.01443f
C3592 sg13cmos5l_buf_1_42.A sg13cmos5l_dlygate4sd3_1_13.A 0.02383f
C3593 a_13738_15964# VDD 0.09615f
C3594 sg13cmos5l_dfrbpq_1_41.CLK bn3 0.01719f
C3595 sg13cmos5l_inv_1_32.Y bn2 0.01311f
C3596 sg13cmos5l_a21oi_1_1.A2 sg13cmos5l_buf_1_2.A 0.01405f
C3597 a_11759_10309# a_12426_9948# 0.09257f
C3598 sg13cmos5l_dlygate4sd3_1_64.X code9 0.01161f
C3599 sg13cmos5l_nand4_1_3.B sg13cmos5l_inv_1_16.A 0.22119f
C3600 sg13cmos5l_buf_1_43.X sg13cmos5l_nand4_1_1.C 0.5002f
C3601 a_15494_18258# a_16068_18271# 0.18486f
C3602 sg13cmos5l_buf_1_20.A VDD 0.88667f
C3603 sg13cmos5l_a21oi_1_15.Y sg13cmos5l_a21oi_1_7.A2 0.06301f
C3604 sg13cmos5l_nand4_1_5.D sg13cmos5l_dlygate4sd3_1_77.A 0.0419f
C3605 sg13cmos5l_buf_1_45.X valid 1.62501f
C3606 sg13cmos5l_inv_1_14.Y sg13cmos5l_inv_1_0.Y 0.02037f
C3607 a_10230_18326# VDD 0.16212f
C3608 a_6487_6126# VDD 0.1875f
C3609 sg13cmos5l_inv_1_2.A a_19077_7653# 0.20134f
C3610 a_17578_11428# a_18021_11471# 0.02241f
C3611 sg13cmos5l_buf_1_65.A sg13cmos5l_nand2_1_13.A 0.04822f
C3612 sg13cmos5l_a21oi_1_9.B1 sg13cmos5l_dfrbpq_1_47.Q 0.27786f
C3613 sg13cmos5l_a21oi_1_2.A2 a_16188_9150# 0.01787f
C3614 sg13cmos5l_nand3_1_5.Y sg13cmos5l_o21ai_1_20.A1 0.90193f
C3615 sg13cmos5l_inv_1_15.Y a_16763_17508# 0.03208f
C3616 a_22506_6924# VDD 0.27509f
C3617 sg13cmos5l_a21oi_1_3.A2 sg13cmos5l_a21oi_1_15.Y 0.06919f
C3618 sg13cmos5l_mux2_1_0.S sg13cmos5l_dfrbpq_1_13.RESET_B 0.23266f
C3619 sg13cmos5l_dlygate4sd3_1_98.A a_20272_17750# 0.01856f
C3620 sg13cmos5l_a21oi_1_0.Y a_18587_4948# 0.11245f
C3621 sg13cmos5l_nand3_1_3.Y sg13cmos5l_a21oi_1_9.B1 0.46131f
C3622 sg13cmos5l_or4_1_0.C a_9928_10034# 0.02646f
C3623 sg13cmos5l_buf_1_26.A sg13cmos5l_nand3b_1_1.C 0.08512f
C3624 sg13cmos5l_dfrbpq_1_41.CLK sg13cmos5l_nor4_1_2.Y 0.03796f
C3625 sg13cmos5l_inv_1_11.Y a_15804_7638# 0.01927f
C3626 a_8830_17874# sg13cmos5l_o21ai_1_14.A1 0.13323f
C3627 sg13cmos5l_a21oi_1_24.Y a_17243_17508# 0.10108f
C3628 sg13cmos5l_dfrbpq_1_28.RESET_B a_20513_13238# 0.0761f
C3629 sg13cmos5l_o21ai_1_5.A1 sg13cmos5l_inv_1_36.A 0.0243f
C3630 sg13cmos5l_a21oi_1_2.B1 sg13cmos5l_nor3_1_7.Y 0.02117f
C3631 sg13cmos5l_buf_1_5.A sg13cmos5l_dlygate4sd3_1_22.A 0.14173f
C3632 sg13cmos5l_o21ai_1_22.Y sg13cmos5l_o21ai_1_22.B1 0.44735f
C3633 sg13cmos5l_nand4_1_18.D sg13cmos5l_a21oi_1_2.A2 0.03691f
C3634 sg13cmos5l_dfrbpq_1_13.RESET_B sg13cmos5l_dfrbpq_1_14.D 0.12661f
C3635 sg13cmos5l_nor3_1_1.Y a_12131_5412# 0.02664f
C3636 sg13cmos5l_dfrbpq_1_28.RESET_B a_20294_12210# 0.09864f
C3637 sg13cmos5l_o21ai_1_13.B1 a_11288_19061# 0.01612f
C3638 sg13cmos5l_or4_1_0.C sg13cmos5l_a21o_1_0.X 0.07414f
C3639 sg13cmos5l_nor4_1_2.Y sg13cmos5l_nand4_1_1.A 0.60795f
C3640 sg13cmos5l_buf_1_16.A sg13cmos5l_a21oi_1_7.A2 0.01688f
C3641 a_15935_7944# a_16631_8065# 0.02431f
C3642 a_15783_7892# a_15804_7638# 0.20754f
C3643 sg13cmos5l_buf_1_45.X sg13cmos5l_nand2_1_15.Y 0.07158f
C3644 sg13cmos5l_nand2_1_15.Y sg13cmos5l_nand3_1_2.A 0.01458f
C3645 sg13cmos5l_inv_1_13.Y VDD 0.52415f
C3646 sg13cmos5l_a21oi_1_16.A2 sg13cmos5l_a21oi_1_2.B1 0.09302f
C3647 sg13cmos5l_buf_1_14.A a_15872_11546# 0.02097f
C3648 sg13cmos5l_nand2_1_1.A a_19448_12214# 0.02553f
C3649 sg13cmos5l_buf_1_10.A a_22126_9375# 0.11368f
C3650 sg13cmos5l_nand4_1_3.D sg13cmos5l_a21oi_1_16.A2 0.01738f
C3651 sg13cmos5l_nand4_1_18.D sg13cmos5l_a21oi_1_6.A2 0.04724f
C3652 sg13cmos5l_dlygate4sd3_1_72.A sg13cmos5l_nor4_1_2.Y 0.01223f
C3653 sg13cmos5l_o21ai_1_12.Y a_6401_16262# 0.01176f
C3654 a_8139_9959# a_9136_10190# 0.03546f
C3655 a_13596_13686# a_14378_13880# 0.24435f
C3656 a_16299_18380# valid 0.01438f
C3657 sg13cmos5l_dlygate4sd3_1_18.X VDD 0.20719f
C3658 sg13cmos5l_inv_1_15.A sg13cmos5l_nand4_1_18.D 0.04346f
C3659 sg13cmos5l_or4_1_1.X bn3 0.08995f
C3660 a_22241_9376# bp3 0.01292f
C3661 sg13cmos5l_nand4_1_18.D a_15496_13760# 0.02005f
C3662 sg13cmos5l_a21oi_1_20.A2 a_16469_14484# 0.05605f
C3663 sg13cmos5l_dfrbpq_1_13.CLK a_16558_11727# 0.01024f
C3664 a_20580_14040# a_20868_13735# 0.24435f
C3665 a_17434_14448# VDD 0.27816f
C3666 sg13cmos5l_inv_1_16.Y sg13cmos5l_a21oi_1_2.B1 0.42216f
C3667 a_13575_13940# a_14423_14113# 0.07916f
C3668 sg13cmos5l_nand4_1_3.D sg13cmos5l_inv_1_16.Y 0.03432f
C3669 a_13886_6924# VDD 0.0107f
C3670 a_16440_11016# VDD 0.01861f
C3671 sg13cmos5l_inv_1_17.A sg13cmos5l_inv_1_25.Y 0.33018f
C3672 sg13cmos5l_nand4_1_16.D a_17792_14570# 0.02775f
C3673 sg13cmos5l_buf_1_45.X sg13cmos5l_nand4_1_15.B 0.05605f
C3674 sg13cmos5l_nand3b_1_0.C a_14561_11726# 0.01177f
C3675 sg13cmos5l_nor2_1_0.Y a_14561_9376# 0.02677f
C3676 sg13cmos5l_nor3_1_2.A a_6286_8703# 0.01604f
C3677 sg13cmos5l_buf_1_16.A a_17098_6130# 0.03856f
C3678 sg13cmos5l_o21ai_1_21.A2 a_6209_16936# 0.01014f
C3679 sg13cmos5l_buf_1_13.X a_17615_5773# 0.02556f
C3680 sg13cmos5l_nand4_1_18.B sg13cmos5l_a21oi_1_2.A2 0.03765f
C3681 a_17355_19892# a_18095_19847# 0.17382f
C3682 a_5126_7674# a_5931_7796# 0.07916f
C3683 a_5412_7992# a_5829_7653# 0.28324f
C3684 sg13cmos5l_inv_1_18.A VDD 1.14919f
C3685 a_19365_5423# a_20113_5773# 0.01058f
C3686 sg13cmos5l_buf_1_1.A bp8 0.02011f
C3687 sg13cmos5l_a21oi_1_17.Y sg13cmos5l_nand4_1_18.D 0.031f
C3688 a_11360_9318# VDD 0.07763f
C3689 a_7073_19960# code6 0.02064f
C3690 a_12040_6294# VDD 0.12369f
C3691 sg13cmos5l_nand4_1_18.B sg13cmos5l_a21oi_1_6.A2 0.02416f
C3692 a_9765_19749# VDD 0.24324f
C3693 sg13cmos5l_nor2b_1_1.A a_10162_16742# 0.02169f
C3694 sg13cmos5l_nand4_1_7.B sg13cmos5l_nor4_1_1.D 0.01257f
C3695 a_7073_16936# VDD 0.20658f
C3696 sg13cmos5l_nand4_1_18.B sg13cmos5l_inv_1_15.A 0.16633f
C3697 sg13cmos5l_buf_1_15.A a_15790_7191# 0.02252f
C3698 a_10408_6294# VDD 0.12302f
C3699 a_22241_3328# VDD 0.2029f
C3700 sg13cmos5l_nand4_1_8.B sg13cmos5l_nand4_1_16.D 0.76787f
C3701 sg13cmos5l_dlygate4sd3_1_64.X sg13cmos5l_o21ai_1_11.Y 0.02144f
C3702 a_22330_10666# sg13cmos5l_a21oi_1_6.Y 0.27591f
C3703 a_9867_19892# a_10607_19847# 0.17382f
C3704 sg13cmos5l_buf_1_21.A a_14920_14484# 0.04276f
C3705 a_9761_6352# VDD 0.2071f
C3706 a_15280_16238# VDD 0.13661f
C3707 sg13cmos5l_o21ai_1_24.Y bn0 0.0424f
C3708 sg13cmos5l_dfrbpq_1_28.RESET_B sg13cmos5l_a21oi_1_20.A2 0.01349f
C3709 sg13cmos5l_dfrbpq_1_30.Q VDD 0.27733f
C3710 sg13cmos5l_nand4_1_3.B sg13cmos5l_nor4_1_1.D 0.22143f
C3711 sg13cmos5l_inv_1_12.Y sg13cmos5l_dlygate4sd3_1_22.A 1.43654f
C3712 sg13cmos5l_o21ai_1_21.A2 sg13cmos5l_o21ai_1_21.Y 2.30624f
C3713 sg13cmos5l_inv_1_15.Y bn6 0.02152f
C3714 a_7416_12404# VDD 0.56536f
C3715 a_7989_6320# VDD 0.09708f
C3716 sg13cmos5l_nand3_1_3.Y sg13cmos5l_a21oi_1_10.A2 0.07745f
C3717 a_18021_11471# a_18123_11471# 0.3643f
C3718 sg13cmos5l_a21oi_1_21.A1 code0 0.01283f
C3719 sg13cmos5l_buf_1_59.A a_15322_16714# 0.01682f
C3720 a_19240_13058# VDD 0.13767f
C3721 sg13cmos5l_nand4_1_1.B bn5 0.14456f
C3722 sg13cmos5l_nand4_1_18.B sg13cmos5l_a21oi_1_17.Y 0.05155f
C3723 sg13cmos5l_dfrbpq_1_28.RESET_B sg13cmos5l_dlygate4sd3_1_74.A 0.04859f
C3724 sg13cmos5l_nand4_1_18.D sg13cmos5l_a21oi_1_1.A2 0.01186f
C3725 sg13cmos5l_buf_1_59.A sg13cmos5l_nor2_1_15.Y 0.02522f
C3726 sg13cmos5l_buf_8_2.A sg13cmos5l_a21oi_1_12.Y 0.01732f
C3727 sg13cmos5l_o21ai_1_5.A2 sg13cmos5l_inv_1_36.A 0.12051f
C3728 a_21089_6352# a_21370_6130# 0.18796f
C3729 sg13cmos5l_nand4_1_15.B sg13cmos5l_nand3_1_2.Y 0.01575f
C3730 sg13cmos5l_dfrbpq_1_13.RESET_B a_10500_9952# 0.28055f
C3731 sg13cmos5l_buf_1_16.A sg13cmos5l_inv_1_17.Y 0.10668f
C3732 a_5222_17508# VDD 0.20543f
C3733 sg13cmos5l_a21oi_1_12.Y sg13cmos5l_a21o_1_2.B1 0.42028f
C3734 sg13cmos5l_dfrbpq_1_28.RESET_B a_22096_12430# 0.09962f
C3735 bp4 bp5 0.04728f
C3736 bp8 bn9 0.02772f
C3737 bp7 bp3 0.02779f
C3738 a_16558_11727# a_16673_11726# 0.3854f
C3739 a_22522_3864# bp5 0.05277f
C3740 sg13cmos5l_buf_1_9.A VDD 0.82785f
C3741 a_18095_19847# sg13cmos5l_dfrbpq_1_28.RESET_B 0.01708f
C3742 a_16631_8065# a_16725_7832# 0.45119f
C3743 sg13cmos5l_nand2_1_1.A a_19534_13239# 0.01602f
C3744 a_21215_18528# a_21866_18416# 0.01562f
C3745 sg13cmos5l_nand4_1_15.B sg13cmos5l_buf_1_42.A 0.39626f
C3746 sg13cmos5l_buf_1_7.X a_19365_5423# 0.03663f
C3747 sg13cmos5l_inv_1_1.A bp8 0.01121f
C3748 sg13cmos5l_dfrbpq_1_5.CLK a_20580_11464# 0.07377f
C3749 sg13cmos5l_o21ai_1_13.B1 sg13cmos5l_o21ai_1_15.B1 0.16105f
C3750 sg13cmos5l_a21oi_1_2.B1 a_17931_6935# 0.01964f
C3751 a_8118_7742# sg13cmos5l_nand2b_1_4.Y 0.03831f
C3752 sg13cmos5l_dfrbpq_1_13.RESET_B a_5416_9948# 0.0863f
C3753 a_8061_7194# a_8143_7294# 0.01126f
C3754 sg13cmos5l_nand3_1_2.A sg13cmos5l_nand2_1_0.A 0.10711f
C3755 a_20716_18258# a_21063_18476# 0.03546f
C3756 sg13cmos5l_inv_1_5.A sg13cmos5l_buf_1_0.A 0.04091f
C3757 a_21839_13799# a_22506_14020# 0.09257f
C3758 sg13cmos5l_a21oi_1_5.A2 sg13cmos5l_buf_1_10.A 0.02196f
C3759 sg13cmos5l_buf_1_43.X a_16556_15960# 0.01283f
C3760 sg13cmos5l_nand2b_1_1.A_N a_14561_11726# 0.04605f
C3761 sg13cmos5l_o21ai_1_17.Y a_10774_17886# 0.06016f
C3762 a_17412_6928# VDD 0.07255f
C3763 sg13cmos5l_nand4_1_18.B sg13cmos5l_nand4_1_5.D 0.26964f
C3764 a_3415_16710# a_3628_16746# 0.23043f
C3765 sg13cmos5l_inv_1_1.Y sg13cmos5l_a21oi_1_13.Y 0.04978f
C3766 sg13cmos5l_inv_1_1.Y a_20294_6166# 0.02859f
C3767 a_21185_7864# bp4 0.02095f
C3768 sg13cmos5l_inv_1_2.A a_18922_5380# 0.01601f
C3769 sg13cmos5l_a21oi_1_2.Y a_19829_3900# 0.10071f
C3770 sg13cmos5l_dfrbpq_1_2.D a_15436_7674# 0.0302f
C3771 a_6448_19262# VDD 0.13644f
C3772 sg13cmos5l_o21ai_1_21.A2 a_7354_16714# 0.01157f
C3773 a_5931_7796# a_6928_7894# 0.03412f
C3774 a_13590_11484# sg13cmos5l_nand2_1_0.A 0.01261f
C3775 sg13cmos5l_nand2b_1_1.A_N sg13cmos5l_dfrbpq_1_13.Q 0.03737f
C3776 sg13cmos5l_dfrbpq_1_28.RESET_B sg13cmos5l_dfrbpq_1_29.D 0.07749f
C3777 sg13cmos5l_nand4_1_3.B a_9064_14570# 0.01407f
C3778 sg13cmos5l_dfrbpq_1_24.RESET_B a_4727_16043# 0.1321f
C3779 sg13cmos5l_nand2b_1_0.B a_12414_7996# 0.05058f
C3780 sg13cmos5l_buf_1_9.A bp6 0.02736f
C3781 sg13cmos5l_and2_1_3.X sg13cmos5l_a21oi_1_20.Y 0.16121f
C3782 sg13cmos5l_dfrbpq_1_47.D VDD 0.26667f
C3783 sg13cmos5l_dfrbpq_1_5.CLK a_21911_16043# 0.0112f
C3784 sg13cmos5l_a21oi_1_8.Y sg13cmos5l_a21oi_1_8.A1 0.25349f
C3785 sg13cmos5l_buf_1_2.A bp8 0.0647f
C3786 sg13cmos5l_dlygate4sd3_1_50.A a_2920_16082# 0.02646f
C3787 a_3319_15960# a_3879_16083# 0.17382f
C3788 sg13cmos5l_nand2b_1_1.A_N sg13cmos5l_o21ai_1_0.A1 0.14296f
C3789 sg13cmos5l_dfrbpq_1_24.RESET_B a_3532_16434# 0.10249f
C3790 sg13cmos5l_dfrbpq_1_27.Q bn7 0.02149f
C3791 a_15214_10215# sg13cmos5l_o21ai_1_3.A2 0.10685f
C3792 sg13cmos5l_a21oi_1_4.A2 a_16342_10694# 0.01745f
C3793 sg13cmos5l_dfrbpq_1_28.RESET_B a_17547_15356# 0.29335f
C3794 sg13cmos5l_a21oi_1_9.A2 a_15790_7191# 0.12545f
C3795 sg13cmos5l_dfrbpq_1_8.D a_20580_6928# 0.02224f
C3796 a_13670_15238# VDD 0.20725f
C3797 sg13cmos5l_a21oi_1_7.A2 a_20294_11898# 0.01867f
C3798 sg13cmos5l_buf_8_2.A a_19430_9190# 0.012f
C3799 a_15503_19847# a_15409_19847# 0.16704f
C3800 a_19160_9190# a_19430_9190# 0.18796f
C3801 sg13cmos5l_inv_1_31.A a_21646_15423# 0.01945f
C3802 sg13cmos5l_a21oi_1_2.B1 bp1 0.78569f
C3803 sg13cmos5l_buf_8_2.A sg13cmos5l_a21oi_1_2.A2 0.02976f
C3804 sg13cmos5l_inv_1_2.A sg13cmos5l_dlygate4sd3_1_28.A 0.41293f
C3805 sg13cmos5l_a21oi_1_14.Y bn6 0.0207f
C3806 a_18123_11471# a_18863_11821# 0.17382f
C3807 sg13cmos5l_dfrbpq_1_5.CLK sg13cmos5l_dfrbpq_1_28.RESET_B 0.39774f
C3808 sg13cmos5l_nand3_1_2.Y sg13cmos5l_nand2_1_0.A 0.03199f
C3809 sg13cmos5l_buf_1_13.A a_12844_5850# 0.09971f
C3810 sg13cmos5l_buf_1_15.A sg13cmos5l_dfrbpq_1_19.CLK 0.05139f
C3811 a_11499_18380# VDD 0.20536f
C3812 sg13cmos5l_a21oi_1_18.B1 sg13cmos5l_dfrbpq_1_28.RESET_B 0.05732f
C3813 a_18952_4688# a_19328_4782# 0.01689f
C3814 sg13cmos5l_dfrbpq_1_47.D a_15016_5498# 0.03976f
C3815 sg13cmos5l_inv_1_2.Y VDD 0.15481f
C3816 sg13cmos5l_buf_1_9.A a_20294_8874# 0.02147f
C3817 sg13cmos5l_buf_1_7.X a_21089_6352# 0.0171f
C3818 sg13cmos5l_buf_1_45.X a_16810_19993# 0.17208f
C3819 sg13cmos5l_a21oi_1_2.A2 a_16970_9344# 0.01859f
C3820 a_13210_19738# bn0 0.02956f
C3821 sg13cmos5l_buf_1_0.A a_22126_7863# 0.10958f
C3822 sg13cmos5l_buf_1_66.X sg13cmos5l_nor2_1_6.Y 0.35598f
C3823 sg13cmos5l_buf_8_2.A sg13cmos5l_a21oi_1_6.A2 0.04106f
C3824 sg13cmos5l_nand3b_1_3.C a_13764_16000# 0.02723f
C3825 sg13cmos5l_o21ai_1_5.A1 busy 0.02897f
C3826 sg13cmos5l_dfrbpq_1_13.RESET_B a_11019_9959# 0.28001f
C3827 a_12837_19031# VDD 0.25396f
C3828 a_4700_17488# VDD 0.01784f
C3829 sg13cmos5l_inv_1_15.A sg13cmos5l_buf_8_2.A 0.1993f
C3830 sg13cmos5l_nand4_1_1.B sg13cmos5l_buf_1_43.X 0.20332f
C3831 sg13cmos5l_o21ai_1_5.A1 sg13cmos5l_nand4_1_7.B 0.10494f
C3832 a_20872_3176# bp5 0.15459f
C3833 sg13cmos5l_nor2_1_16.Y a_12458_17044# 0.01314f
C3834 a_8960_16082# VDD 0.08259f
C3835 sg13cmos5l_buf_1_13.X a_17835_8447# 0.28016f
C3836 a_20294_10386# a_20997_9959# 0.02431f
C3837 sg13cmos5l_nand2_1_1.A sg13cmos5l_dlygate4sd3_1_71.X 0.02248f
C3838 sg13cmos5l_and2_1_3.X bp0 0.05454f
C3839 sg13cmos5l_o21ai_1_5.A1 sg13cmos5l_nand4_1_3.B 1.56423f
C3840 sg13cmos5l_inv_1_36.A sg13cmos5l_dfrbpq_1_13.CLK 0.26198f
C3841 a_8006_7678# sg13cmos5l_dlygate4sd3_1_43.A 0.01105f
C3842 sg13cmos5l_a21oi_1_4.A2 a_14283_16007# 0.0449f
C3843 sg13cmos5l_o21ai_1_21.B1 a_4182_19044# 0.05293f
C3844 a_21084_18222# a_21911_18649# 0.26205f
C3845 sg13cmos5l_nor2_1_6.Y VDD 0.26227f
C3846 sg13cmos5l_buf_1_13.X sg13cmos5l_inv_1_6.Y 0.02388f
C3847 a_18671_7285# VDD 0.17114f
C3848 a_3975_16964# a_4823_17137# 0.07916f
C3849 sg13cmos5l_inv_1_5.A a_15905_7190# 0.05709f
C3850 sg13cmos5l_inv_1_31.A sg13cmos5l_nand4_1_12.Y 0.14655f
C3851 sg13cmos5l_nand3b_1_3.C sg13cmos5l_o21ai_1_21.Y 0.83858f
C3852 sg13cmos5l_inv_1_31.A a_21084_16710# 0.09077f
C3853 sg13cmos5l_nand3_1_0.B sg13cmos5l_nor3_1_0.Y 0.02054f
C3854 sg13cmos5l_mux2_1_0.A1 a_8411_12252# 0.14005f
C3855 sg13cmos5l_buf_8_2.A sg13cmos5l_a21oi_1_17.Y 0.04903f
C3856 a_7073_19960# sg13cmos5l_dfrbpq_1_21.D 0.0237f
C3857 a_20580_11464# bn9 0.0104f
C3858 a_20026_15202# VDD 0.26244f
C3859 sg13cmos5l_buf_1_63.A sg13cmos5l_buf_1_45.X 0.1391f
C3860 sg13cmos5l_dlygate4sd3_1_82.X sg13cmos5l_buf_1_24.A 0.02235f
C3861 a_6383_9263# sg13cmos5l_dlygate4sd3_1_42.A 0.03056f
C3862 sg13cmos5l_dlygate4sd3_1_24.A bp4 0.036f
C3863 a_21070_7863# bp4 0.0445f
C3864 sg13cmos5l_dfrbpq_1_28.RESET_B sg13cmos5l_buf_1_1.A 0.04568f
C3865 sg13cmos5l_inv_1_4.Y bp2 0.57572f
C3866 sg13cmos5l_inv_1_17.A a_22126_7863# 0.03791f
C3867 sg13cmos5l_nand2_1_0.A sg13cmos5l_nand3_1_1.Y 0.01498f
C3868 sg13cmos5l_nor4_1_4.C a_11180_15198# 0.01203f
C3869 sg13cmos5l_inv_1_8.A sg13cmos5l_dlygate4sd3_1_15.X 0.08335f
C3870 a_17028_15552# VDD 0.07338f
C3871 sg13cmos5l_o21ai_1_7.Y a_6785_18448# 0.01048f
C3872 a_12896_13897# sg13cmos5l_nand2_1_18.A 0.09859f
C3873 sg13cmos5l_inv_1_17.A a_21839_8797# 0.0155f
C3874 sg13cmos5l_nand3b_1_0.C a_13208_11501# 0.01091f
C3875 sg13cmos5l_inv_1_1.A a_16469_14484# 0.01043f
C3876 sg13cmos5l_buf_8_2.A sg13cmos5l_nand4_1_5.D 0.02586f
C3877 sg13cmos5l_dfrbpq_1_28.RESET_B a_18544_15454# 0.1117f
C3878 sg13cmos5l_dlygate4sd3_1_64.X sg13cmos5l_dfrbpq_1_20.Q 0.01543f
C3879 sg13cmos5l_inv_1_1.A sg13cmos5l_a21oi_1_4.A1 0.02486f
C3880 sg13cmos5l_a21oi_1_13.A2 sg13cmos5l_a21oi_1_1.A2 0.21487f
C3881 sg13cmos5l_o21ai_1_5.A1 sg13cmos5l_buf_1_21.A 0.20549f
C3882 a_21953_19960# VDD 0.20267f
C3883 sg13cmos5l_a21oi_1_7.A2 a_20868_11885# 0.01556f
C3884 sg13cmos5l_buf_8_2.A sg13cmos5l_a21oi_1_1.A2 0.0216f
C3885 sg13cmos5l_dfrbpq_1_13.CLK a_11393_6352# 0.06341f
C3886 sg13cmos5l_a22oi_1_0.B2 a_13749_9386# 0.02525f
C3887 sg13cmos5l_inv_1_0.Y sg13cmos5l_inv_1_7.Y 0.01707f
C3888 sg13cmos5l_dfrbpq_1_28.RESET_B a_19275_19031# 0.28341f
C3889 sg13cmos5l_dlygate4sd3_1_28.A a_20997_6935# 0.04621f
C3890 a_22235_5412# bp1 0.01937f
C3891 sg13cmos5l_buf_1_1.A a_21839_11821# 0.016f
C3892 sg13cmos5l_dfrbpq_1_13.CLK a_11278_6351# 0.0515f
C3893 a_20554_4873# a_20997_4629# 0.02241f
C3894 a_20294_4650# a_20580_4968# 0.26205f
C3895 sg13cmos5l_inv_1_16.A sg13cmos5l_a21oi_1_5.A2 0.74209f
C3896 a_18104_18262# a_18374_18262# 0.18796f
C3897 a_16942_19287# VDD 0.16011f
C3898 sg13cmos5l_a21oi_1_9.A2 sg13cmos5l_o21ai_1_0.B1 0.12025f
C3899 sg13cmos5l_buf_1_13.A a_13191_5499# 0.28174f
C3900 a_8321_9376# VDD 0.209f
C3901 sg13cmos5l_nand3b_1_3.C a_7354_16714# 0.0192f
C3902 sg13cmos5l_a21oi_1_14.Y sg13cmos5l_dfrbpq_1_30.D 0.08893f
C3903 sg13cmos5l_buf_1_63.A a_19642_19738# 0.05919f
C3904 sg13cmos5l_dfrbpq_1_45.Q a_9056_11546# 0.01341f
C3905 sg13cmos5l_nand4_1_16.D sg13cmos5l_and2_1_3.X 0.22648f
C3906 sg13cmos5l_dlygate4sd3_1_64.X comp 0.01381f
C3907 sg13cmos5l_dfrbpq_1_7.D sg13cmos5l_inv_1_2.A 0.01793f
C3908 sg13cmos5l_nand3b_1_3.C a_15023_16357# 0.01781f
C3909 sg13cmos5l_nand4_1_7.B sg13cmos5l_o21ai_1_5.A2 0.18832f
C3910 a_14346_19020# VDD 0.27648f
C3911 sg13cmos5l_a21oi_1_15.Y sg13cmos5l_a21oi_1_2.A2 0.01035f
C3912 a_17429_12508# sg13cmos5l_dlygate4sd3_1_18.A 0.10034f
C3913 sg13cmos5l_dfrbpq_1_28.RESET_B bn9 0.01058f
C3914 sg13cmos5l_buf_1_63.A sg13cmos5l_nand3_1_2.Y 0.03f
C3915 sg13cmos5l_dfrbpq_1_30.Q a_19930_15960# 0.0681f
C3916 sg13cmos5l_a21oi_1_9.A2 sg13cmos5l_a21oi_1_11.Y 0.02012f
C3917 sg13cmos5l_a21oi_1_9.A2 sg13cmos5l_a21oi_1_9.A1 0.85851f
C3918 a_5345_19960# VDD 0.20143f
C3919 sg13cmos5l_o21ai_1_26.B1 sg13cmos5l_buf_8_2.A 0.14084f
C3920 sg13cmos5l_a21oi_1_4.A2 a_14624_15366# 0.051f
C3921 sg13cmos5l_a21oi_1_9.A2 sg13cmos5l_nor3_1_1.Y 0.02313f
C3922 sg13cmos5l_dfrbpq_1_28.RESET_B sg13cmos5l_inv_1_1.A 0.02591f
C3923 sg13cmos5l_buf_1_15.A sg13cmos5l_dlygate4sd3_1_74.A 0.0326f
C3924 a_18470_19458# sg13cmos5l_inv_1_25.Y 0.01708f
C3925 sg13cmos5l_o21ai_1_5.A2 sg13cmos5l_nand4_1_3.B 0.01395f
C3926 sg13cmos5l_buf_1_13.X a_17578_11428# 0.19f
C3927 a_13478_16434# sg13cmos5l_inv_1_24.Y 0.01184f
C3928 a_20580_9952# sg13cmos5l_inv_1_2.A 0.05215f
C3929 sg13cmos5l_buf_1_13.X sg13cmos5l_inv_1_11.Y 0.2357f
C3930 a_20997_9959# a_20868_10373# 0.01562f
C3931 sg13cmos5l_inv_1_15.A sg13cmos5l_a21oi_1_15.Y 0.01281f
C3932 sg13cmos5l_buf_1_16.A a_19430_9190# 0.01986f
C3933 sg13cmos5l_mux2_1_0.S a_7310_12400# 0.07888f
C3934 a_4823_17137# sg13cmos5l_dfrbpq_1_19.D 0.03287f
C3935 sg13cmos5l_inv_1_5.A a_17829_6935# 0.23865f
C3936 sg13cmos5l_dfrbpq_1_13.RESET_B a_6671_7751# 0.10877f
C3937 sg13cmos5l_inv_1_31.Y VDD 0.12979f
C3938 sg13cmos5l_a21oi_1_3.A2 sg13cmos5l_a21oi_1_2.B1 0.10864f
C3939 sg13cmos5l_buf_1_45.X a_13210_12936# 0.04864f
C3940 a_8043_19031# VDD 0.20622f
C3941 sg13cmos5l_nand4_1_3.D sg13cmos5l_a21oi_1_3.A2 0.02045f
C3942 sg13cmos5l_buf_1_0.A a_15436_7674# 0.0106f
C3943 a_7354_19738# sg13cmos5l_o21ai_1_7.Y 0.29192f
C3944 a_22784_19106# VDD 0.06744f
C3945 sg13cmos5l_nand3_1_3.Y a_10864_5654# 0.03034f
C3946 sg13cmos5l_buf_1_16.A sg13cmos5l_a21oi_1_6.A2 0.04317f
C3947 a_9062_19770# code5 0.03966f
C3948 sg13cmos5l_inv_1_14.Y a_18282_5412# 0.04021f
C3949 a_14561_11726# VDD 0.20812f
C3950 sg13cmos5l_dfrbpq_1_19.CLK sg13cmos5l_o21ai_1_20.A1 0.21643f
C3951 sg13cmos5l_inv_1_15.A sg13cmos5l_buf_1_16.A 0.34295f
C3952 a_15607_9150# VDD 0.17408f
C3953 sg13cmos5l_a21oi_1_2.B1 a_17098_6130# 0.05779f
C3954 sg13cmos5l_inv_1_17.A a_21745_14845# 0.01487f
C3955 a_5643_9308# a_5412_9199# 0.07823f
C3956 a_5124_9504# a_6289_9263# 0.25046f
C3957 sg13cmos5l_nand2b_1_0.B sg13cmos5l_a21oi_1_4.B1 0.05188f
C3958 sg13cmos5l_nor2b_1_0.B_N sg13cmos5l_nor2_1_0.Y 1.0274f
C3959 a_15480_8752# VDD 0.16676f
C3960 sg13cmos5l_nand3_1_0.A a_16454_8436# 0.0593f
C3961 sg13cmos5l_dfrbpq_1_41.CLK a_14283_16007# 0.05469f
C3962 sg13cmos5l_dfrbpq_1_13.Q VDD 0.5538f
C3963 sg13cmos5l_dfrbpq_1_28.RESET_B sg13cmos5l_dlygate4sd3_1_77.A 0.0136f
C3964 a_21089_6352# bp4 0.03545f
C3965 sg13cmos5l_o21ai_1_5.A2 sg13cmos5l_buf_1_21.A 1.01605f
C3966 sg13cmos5l_inv_1_36.A sg13cmos5l_mux2_1_0.A1 0.15588f
C3967 sg13cmos5l_nand3_1_0.A a_14902_8814# 0.03681f
C3968 sg13cmos5l_dfrbpq_1_24.RESET_B a_3879_16083# 0.29061f
C3969 sg13cmos5l_dfrbpq_1_33.Q sg13cmos5l_buf_1_16.A 0.02757f
C3970 sg13cmos5l_buf_1_9.A sg13cmos5l_a21oi_1_2.Y 0.02868f
C3971 sg13cmos5l_inv_1_16.A a_20294_13722# 0.03588f
C3972 sg13cmos5l_buf_1_13.A a_15496_5498# 0.0119f
C3973 sg13cmos5l_buf_1_45.X sg13cmos5l_nand2_1_15.B 0.43462f
C3974 sg13cmos5l_nand2_1_15.B sg13cmos5l_nand3_1_2.A 0.02593f
C3975 sg13cmos5l_buf_1_24.A sg13cmos5l_nand4_1_6.B 0.17214f
C3976 sg13cmos5l_nand2_1_11.B sg13cmos5l_o21ai_1_8.B1 0.33051f
C3977 a_17057_19286# VDD 0.2059f
C3978 sg13cmos5l_nand2b_1_1.A_N a_8993_7190# 0.01789f
C3979 sg13cmos5l_o21ai_1_0.A1 VDD 1.18142f
C3980 sg13cmos5l_buf_1_13.A a_14039_5459# 0.09686f
C3981 sg13cmos5l_buf_1_57.A a_13400_15238# 0.03474f
C3982 sg13cmos5l_a21oi_1_0.A2 a_18660_7992# 0.04989f
C3983 sg13cmos5l_dfrbpq_1_5.CLK a_21084_16357# 0.07722f
C3984 sg13cmos5l_a21oi_1_1.A2 sg13cmos5l_a21oi_1_15.Y 0.16157f
C3985 a_6280_11546# VDD 0.18045f
C3986 a_13958_19770# busy 0.03788f
C3987 sg13cmos5l_buf_1_10.A sg13cmos5l_dlygate4sd3_1_8.X 0.20705f
C3988 a_20874_5412# bp4 0.02996f
C3989 sg13cmos5l_dfrbpq_1_28.RESET_B a_22005_16904# 0.19348f
C3990 sg13cmos5l_nand3b_1_3.C sg13cmos5l_nand4_1_16.D 0.03156f
C3991 sg13cmos5l_a21oi_1_15.A2 a_16949_12508# 0.08661f
C3992 sg13cmos5l_dfrbpq_1_24.RESET_B a_6021_12983# 0.03662f
C3993 sg13cmos5l_buf_1_45.X sg13cmos5l_inv_1_31.A 0.04545f
C3994 a_16840_16878# VDD 0.14233f
C3995 sg13cmos5l_o21ai_1_0.A2 sg13cmos5l_dfrbpq_1_47.Q 0.21105f
C3996 a_18209_9376# sg13cmos5l_nand3_1_0.Y 0.04679f
C3997 sg13cmos5l_o21ai_1_0.A2 a_12632_8477# 0.05245f
C3998 sg13cmos5l_dfrbpq_1_19.D sg13cmos5l_o21ai_1_10.A2 0.20203f
C3999 sg13cmos5l_buf_1_15.A sg13cmos5l_dfrbpq_1_5.CLK 0.15019f
C4000 code9 code8 0.09063f
C4001 sg13cmos5l_buf_1_15.A sg13cmos5l_a21oi_1_18.B1 0.0141f
C4002 sg13cmos5l_buf_1_9.A a_17835_8447# 0.01789f
C4003 sg13cmos5l_nand2_1_3.Y sg13cmos5l_a21oi_1_10.A2 0.30036f
C4004 a_20554_13945# VDD 0.09464f
C4005 sg13cmos5l_inv_1_17.Y sg13cmos5l_a21oi_1_2.B1 0.19541f
C4006 sg13cmos5l_buf_1_13.X a_18123_11471# 0.28736f
C4007 a_1192_8436# VDD 0.18157f
C4008 sg13cmos5l_o21ai_1_25.Y code3 0.07434f
C4009 sg13cmos5l_nand3_1_8.Y sg13cmos5l_inv_1_12.A 0.01568f
C4010 sg13cmos5l_buf_1_16.A sg13cmos5l_nand4_1_5.D 0.63766f
C4011 sg13cmos5l_buf_1_13.X sg13cmos5l_buf_1_4.A 0.02486f
C4012 sg13cmos5l_buf_1_9.A sg13cmos5l_inv_1_6.Y 0.02235f
C4013 sg13cmos5l_dlygate4sd3_1_29.X a_17829_6935# 0.01441f
C4014 sg13cmos5l_buf_1_16.A sg13cmos5l_a21oi_1_1.A2 0.33855f
C4015 a_12814_19959# code3 0.01299f
C4016 a_5318_13410# a_5892_13397# 0.18486f
C4017 a_5604_12976# a_6021_12983# 0.28418f
C4018 sg13cmos5l_a21oi_1_12.Y sg13cmos5l_nor2_1_4.Y 0.25642f
C4019 sg13cmos5l_buf_1_13.X sg13cmos5l_inv_1_3.Y 0.50722f
C4020 sg13cmos5l_a22oi_1_0.B2 clk 0.01641f
C4021 sg13cmos5l_nand4_1_1.C sg13cmos5l_inv_1_12.A 0.27476f
C4022 sg13cmos5l_nor3_1_6.Y sg13cmos5l_nand3_1_2.A 0.0381f
C4023 a_10124_11424# clk 0.01169f
C4024 sg13cmos5l_nand2_1_1.A sg13cmos5l_a21oi_1_0.A2 0.02173f
C4025 sg13cmos5l_nand4_1_12.Y sg13cmos5l_inv_1_25.Y 0.02077f
C4026 a_21084_16710# sg13cmos5l_inv_1_25.Y 0.04401f
C4027 sg13cmos5l_buf_1_8.A sg13cmos5l_dfrbpq_1_0.D 0.02888f
C4028 sg13cmos5l_dlygate4sd3_1_65.A VDD 0.39078f
C4029 sg13cmos5l_nand4_1_3.B sg13cmos5l_dfrbpq_1_13.CLK 0.01399f
C4030 sg13cmos5l_a21oi_1_4.A1 sg13cmos5l_nand4_1_18.D 0.01122f
C4031 sg13cmos5l_or4_1_0.D a_7841_8702# 0.06051f
C4032 sg13cmos5l_dfrbpq_1_9.D a_17024_7010# 0.03656f
C4033 sg13cmos5l_o21ai_1_18.B1 sg13cmos5l_nor2_1_10.Y 0.08726f
C4034 sg13cmos5l_o21ai_1_7.Y sg13cmos5l_a21oi_1_27.B1 0.01132f
C4035 sg13cmos5l_a21oi_1_4.A2 sg13cmos5l_o21ai_1_23.A2 0.18922f
C4036 sg13cmos5l_inv_1_31.A a_16299_18380# 0.0274f
C4037 sg13cmos5l_o21ai_1_6.B1 sg13cmos5l_nand3_1_4.Y 0.14228f
C4038 sg13cmos5l_o21ai_1_23.B1 sg13cmos5l_nand4_1_1.B 0.04243f
C4039 a_20398_4167# a_20513_4166# 0.3854f
C4040 a_20406_6230# VDD 0.16035f
C4041 sg13cmos5l_nand3_1_2.Y sg13cmos5l_nand2_1_15.B 0.04732f
C4042 sg13cmos5l_buf_1_45.X sg13cmos5l_nand4_1_8.B 0.02143f
C4043 sg13cmos5l_nor4_1_4.C sg13cmos5l_mux2_1_0.S 0.27294f
C4044 sg13cmos5l_buf_1_54.A sg13cmos5l_a21oi_1_20.A2 0.01539f
C4045 sg13cmos5l_nor3_1_2.Y a_5412_9199# 0.01263f
C4046 a_13764_16000# bn2 0.04599f
C4047 sg13cmos5l_inv_1_24.A a_14536_14484# 0.2195f
C4048 sg13cmos5l_nand4_1_8.B a_16172_14448# 0.04401f
C4049 a_21160_12972# bn7 0.15436f
C4050 sg13cmos5l_nand2b_1_1.A_N sg13cmos5l_o21ai_1_1.Y 0.02119f
C4051 a_14144_10830# VDD 0.07543f
C4052 sg13cmos5l_nand2_1_1.A a_19745_15424# 0.0342f
C4053 sg13cmos5l_nand2b_1_1.A_N sg13cmos5l_nand2b_1_3.Y 0.25765f
C4054 sg13cmos5l_buf_1_17.X rst_n 0.07979f
C4055 sg13cmos5l_buf_1_15.A a_8783_19381# 0.03782f
C4056 sg13cmos5l_buf_1_57.A a_16742_15234# 0.01702f
C4057 sg13cmos5l_nand4_1_18.B sg13cmos5l_a21oi_1_4.A1 0.05943f
C4058 sg13cmos5l_o21ai_1_23.B1 sg13cmos5l_o21ai_1_28.Y 0.02543f
C4059 sg13cmos5l_inv_1_36.Y sg13cmos5l_nor3_1_0.Y 0.603f
C4060 a_22096_4870# a_22506_4948# 0.07015f
C4061 sg13cmos5l_dfrbpq_1_41.CLK a_11397_18237# 0.19589f
C4062 a_9322_5380# a_9348_5416# 0.24169f
C4063 a_17098_6130# a_16773_5423# 0.01936f
C4064 sg13cmos5l_dlygate4sd3_1_55.X bn3 0.01643f
C4065 a_18104_18262# sg13cmos5l_nand4_1_17.Y 0.0106f
C4066 sg13cmos5l_inv_1_17.A a_22126_6351# 0.05604f
C4067 sg13cmos5l_nand3_1_2.Y sg13cmos5l_nor3_1_6.Y 0.03743f
C4068 sg13cmos5l_buf_1_21.A sg13cmos5l_dfrbpq_1_13.CLK 0.13165f
C4069 sg13cmos5l_a21oi_1_4.A1 code0 0.04716f
C4070 sg13cmos5l_dfrbpq_1_41.CLK a_12420_19024# 0.04071f
C4071 a_13686_18326# VDD 0.15979f
C4072 sg13cmos5l_nor3_1_2.B sg13cmos5l_a22oi_1_0.A2 0.04398f
C4073 sg13cmos5l_inv_1_16.A sg13cmos5l_nand4_1_18.A 0.04508f
C4074 sg13cmos5l_a21oi_1_27.A1 sg13cmos5l_a21oi_1_27.A2 0.3738f
C4075 sg13cmos5l_nor4_1_0.Y a_12512_8522# 0.04438f
C4076 sg13cmos5l_inv_1_12.A a_20794_12936# 0.01609f
C4077 sg13cmos5l_buf_1_25.A sg13cmos5l_nand2_1_12.Y 0.01265f
C4078 a_6113_13912# VDD 0.20623f
C4079 sg13cmos5l_nand4_1_18.B sg13cmos5l_o21ai_1_18.B1 0.03515f
C4080 sg13cmos5l_buf_1_57.A sg13cmos5l_o21ai_1_23.A2 0.66374f
C4081 a_20294_7362# a_20580_6928# 0.26205f
C4082 sg13cmos5l_nand4_1_1.A sg13cmos5l_a21oi_1_0.A2 0.09167f
C4083 a_15126_19044# VDD 0.16024f
C4084 sg13cmos5l_a21oi_1_0.A2 a_18832_8678# 0.04957f
C4085 sg13cmos5l_nand3_1_5.Y sg13cmos5l_dfrbpq_1_23.Q 0.5017f
C4086 sg13cmos5l_inv_1_2.A a_19733_6924# 0.0162f
C4087 sg13cmos5l_inv_1_24.A bn5 0.05725f
C4088 sg13cmos5l_nor3_1_7.Y a_18021_11471# 0.01123f
C4089 sg13cmos5l_a21o_1_0.A2 a_10774_10694# 0.06016f
C4090 sg13cmos5l_inv_1_1.Y bp2 0.0221f
C4091 sg13cmos5l_buf_1_9.A sg13cmos5l_inv_1_11.Y 0.02186f
C4092 a_18574_14751# a_18689_14750# 0.3854f
C4093 a_6958_19959# VDD 0.15962f
C4094 sg13cmos5l_nand4_1_8.B sg13cmos5l_nand3_1_2.Y 0.01627f
C4095 sg13cmos5l_a21oi_1_19.Y bn5 0.01678f
C4096 sg13cmos5l_inv_1_2.A sg13cmos5l_dlygate4sd3_1_29.A 0.02344f
C4097 sg13cmos5l_inv_1_13.Y a_18123_11471# 0.02666f
C4098 sg13cmos5l_nand4_1_18.B sg13cmos5l_dfrbpq_1_28.RESET_B 0.03045f
C4099 sg13cmos5l_inv_1_12.A a_21254_10702# 0.01652f
C4100 a_8955_9228# a_9157_9190# 0.01126f
C4101 sg13cmos5l_nand4_1_18.B sg13cmos5l_mux2_1_1.A1 0.21777f
C4102 sg13cmos5l_o21ai_1_9.A2 a_5259_14495# 0.0699f
C4103 sg13cmos5l_buf_1_13.X sg13cmos5l_inv_1_2.A 0.0211f
C4104 sg13cmos5l_nand4_1_15.B sg13cmos5l_and4_1_1.A 0.22548f
C4105 sg13cmos5l_nand4_1_8.B sg13cmos5l_buf_1_42.A 0.32831f
C4106 VDD code2 0.14536f
C4107 sg13cmos5l_nor3_1_2.C sg13cmos5l_o21ai_1_6.Y 0.0286f
C4108 sg13cmos5l_buf_1_15.A sg13cmos5l_inv_1_1.A 0.40584f
C4109 sg13cmos5l_buf_1_15.A sg13cmos5l_o21ai_1_9.Y 0.05686f
C4110 a_21911_17137# sg13cmos5l_inv_1_25.Y 0.02627f
C4111 sg13cmos5l_buf_1_16.A sg13cmos5l_dlygate4sd3_1_76.A 0.02535f
C4112 sg13cmos5l_dlygate4sd3_1_13.X sg13cmos5l_buf_1_13.X 0.17238f
C4113 sg13cmos5l_buf_1_47.X sg13cmos5l_o21ai_1_5.A1 0.14087f
C4114 a_8734_12214# a_8637_12508# 0.02925f
C4115 a_16840_12972# VDD 0.21411f
C4116 a_8411_12252# a_8911_12508# 0.03336f
C4117 sg13cmos5l_a21oi_1_4.A1 a_14423_14113# 0.04499f
C4118 sg13cmos5l_a21o_1_1.A2 a_7750_9508# 0.01556f
C4119 sg13cmos5l_nand3b_1_1.Y sg13cmos5l_or4_1_1.X 0.01947f
C4120 a_20794_3864# bp4 0.05209f
C4121 a_19336_3176# bp9 0.01222f
C4122 sg13cmos5l_nand2_1_3.Y a_8878_7191# 0.02553f
C4123 sg13cmos5l_dfrbpq_1_5.CLK a_20580_14488# 0.07683f
C4124 a_14218_18226# sg13cmos5l_inv_1_25.Y 0.01126f
C4125 sg13cmos5l_inv_1_32.Y sg13cmos5l_nand4_1_1.B 0.03722f
C4126 sg13cmos5l_inv_1_7.A bp3 0.103f
C4127 sg13cmos5l_inv_1_24.Y code1 0.01639f
C4128 sg13cmos5l_inv_1_15.A a_21866_16276# 0.01038f
C4129 a_16167_9404# VDD 0.20516f
C4130 sg13cmos5l_mux2_1_0.A1 sg13cmos5l_mux2_1_1.A0 0.0439f
C4131 sg13cmos5l_buf_1_54.A a_17547_15356# 0.0288f
C4132 a_14218_19993# VDD 0.0938f
C4133 sg13cmos5l_nand2_1_1.Y sg13cmos5l_nor3_1_0.Y 0.01968f
C4134 sg13cmos5l_inv_1_15.A sg13cmos5l_buf_1_53.A 0.21425f
C4135 sg13cmos5l_inv_1_8.A sg13cmos5l_buf_1_14.A 0.02421f
C4136 sg13cmos5l_a21oi_1_26.A1 a_16385_17856# 0.01159f
C4137 sg13cmos5l_dfrbpq_1_1.D VDD 0.20871f
C4138 a_22030_19287# VDD 0.15801f
C4139 sg13cmos5l_buf_1_24.A bn4 0.03975f
C4140 sg13cmos5l_inv_1_5.A sg13cmos5l_nor2b_1_2.Y 0.04334f
C4141 a_14938_6888# a_14657_7190# 0.18796f
C4142 sg13cmos5l_nand2_1_0.A a_13749_9386# 0.10835f
C4143 sg13cmos5l_nand2b_1_0.B a_14561_9376# 0.05717f
C4144 sg13cmos5l_o21ai_1_21.Y a_4823_17137# 0.01104f
C4145 sg13cmos5l_a21oi_1_18.B1 sg13cmos5l_buf_1_54.A 0.01235f
C4146 a_13208_11501# VDD 0.26856f
C4147 sg13cmos5l_dlygate4sd3_1_42.X sg13cmos5l_nor3_1_2.A 0.33007f
C4148 busy bn6 0.01353f
C4149 bn1 code0 1.99433f
C4150 sg13cmos5l_inv_1_16.A a_20868_13735# 0.02399f
C4151 sg13cmos5l_buf_1_3.A bn9 0.1069f
C4152 sg13cmos5l_nand4_1_7.B bn6 0.01387f
C4153 sg13cmos5l_dlygate4sd3_1_64.X sg13cmos5l_o21ai_1_20.B1 0.38037f
C4154 sg13cmos5l_inv_1_36.Y a_14842_11424# 0.01636f
C4155 sg13cmos5l_dfrbpq_1_41.CLK a_13304_18262# 0.03283f
C4156 a_9348_5416# a_10607_5773# 0.01412f
C4157 sg13cmos5l_inv_1_20.Y sg13cmos5l_a22oi_1_0.B2 0.65649f
C4158 a_12430_9375# a_12545_9376# 0.3854f
C4159 sg13cmos5l_nand4_1_3.B sg13cmos5l_mux2_1_0.A1 0.13375f
C4160 sg13cmos5l_dfrbpq_1_34.Q a_16836_20088# 0.01677f
C4161 sg13cmos5l_nand2b_1_1.A_N sg13cmos5l_or2_1_1.X 0.01647f
C4162 sg13cmos5l_o21ai_1_3.A2 sg13cmos5l_nand3_1_0.A 0.31392f
C4163 sg13cmos5l_buf_8_2.A a_20580_11464# 0.02789f
C4164 a_16197_18237# VDD 0.24641f
C4165 sg13cmos5l_nand4_1_3.B bn6 0.05403f
C4166 a_7432_13854# VDD 0.12001f
C4167 sg13cmos5l_inv_1_12.A a_20997_12189# 0.02243f
C4168 a_20294_7362# a_21099_6935# 0.07916f
C4169 sg13cmos5l_buf_1_24.A VDD 0.6303f
C4170 sg13cmos5l_buf_1_45.X sg13cmos5l_inv_1_25.Y 0.26872f
C4171 sg13cmos5l_a21oi_1_0.A2 a_17604_11464# 0.02193f
C4172 a_8993_7190# VDD 0.20769f
C4173 a_19361_19960# VDD 0.2014f
C4174 sg13cmos5l_nor3_1_7.Y a_18863_11821# 0.01648f
C4175 sg13cmos5l_nor2_1_2.Y a_8021_5412# 0.01648f
C4176 sg13cmos5l_buf_1_9.A sg13cmos5l_buf_1_4.A 0.01821f
C4177 sg13cmos5l_buf_8_2.A sg13cmos5l_a21oi_1_4.A1 0.06841f
C4178 sg13cmos5l_buf_1_1.A a_22096_8678# 0.0174f
C4179 sg13cmos5l_buf_1_7.X a_19919_10775# 0.01223f
C4180 a_8960_19902# sg13cmos5l_dlygate4sd3_1_58.X 0.03663f
C4181 VDD bn8 0.43481f
C4182 sg13cmos5l_a21oi_1_18.B1 sg13cmos5l_buf_1_26.A 0.36461f
C4183 a_12136_16082# VDD 0.14939f
C4184 sg13cmos5l_buf_1_43.X sg13cmos5l_inv_1_24.A 0.01891f
C4185 sg13cmos5l_dfrbpq_1_38.Q code1 0.04042f
C4186 a_6863_13333# a_7530_12972# 0.09257f
C4187 sg13cmos5l_a21oi_1_4.A1 sg13cmos5l_a21o_1_2.B1 0.30006f
C4188 sg13cmos5l_nand4_1_5.D sg13cmos5l_buf_1_53.A 0.55141f
C4189 sg13cmos5l_o21ai_1_9.A2 sg13cmos5l_and4_1_1.A 0.01462f
C4190 sg13cmos5l_dlygate4sd3_1_82.A sg13cmos5l_buf_1_26.A 0.01326f
C4191 sg13cmos5l_buf_1_10.A bp3 0.17701f
C4192 sg13cmos5l_a21oi_1_19.Y sg13cmos5l_buf_1_43.X 0.03237f
C4193 sg13cmos5l_inv_1_1.A sg13cmos5l_dlygate4sd3_1_1.A 0.25739f
C4194 sg13cmos5l_dfrbpq_1_19.CLK a_3996_16710# 0.08293f
C4195 sg13cmos5l_o21ai_1_21.A2 a_10634_17044# 0.01306f
C4196 sg13cmos5l_dfrbpq_1_19.D sg13cmos5l_o21ai_1_10.Y 0.20632f
C4197 sg13cmos5l_buf_1_0.A a_20580_6928# 0.0151f
C4198 sg13cmos5l_buf_1_2.A sg13cmos5l_buf_1_3.A 0.17486f
C4199 a_15322_16714# VDD 0.27282f
C4200 sg13cmos5l_dfrbpq_1_24.Q a_7616_13854# 0.03805f
C4201 a_22126_3327# bp9 0.0157f
C4202 sg13cmos5l_a21oi_1_2.B1 sg13cmos5l_a21oi_1_2.A2 0.09297f
C4203 sg13cmos5l_inv_1_3.Y a_17412_6928# 0.01823f
C4204 sg13cmos5l_o21ai_1_18.B1 sg13cmos5l_buf_8_2.A 0.90648f
C4205 sg13cmos5l_nor2_1_15.Y VDD 0.22432f
C4206 sg13cmos5l_nand2_1_1.A a_19829_14020# 0.01966f
C4207 sg13cmos5l_dlygate4sd3_1_13.A sg13cmos5l_inv_1_20.Y 0.02788f
C4208 sg13cmos5l_a21oi_1_3.A2 a_17316_8440# 0.02831f
C4209 sg13cmos5l_o21ai_1_8.B1 a_8960_16082# 0.02232f
C4210 sg13cmos5l_a21oi_1_18.B1 a_22506_14484# 0.04137f
C4211 sg13cmos5l_dfrbpq_1_11.D VDD 0.23214f
C4212 sg13cmos5l_o21ai_1_21.Y sg13cmos5l_o21ai_1_10.A2 0.03497f
C4213 sg13cmos5l_buf_1_21.A bn6 0.01368f
C4214 sg13cmos5l_inv_1_14.Y a_19467_5423# 0.02645f
C4215 sg13cmos5l_o21ai_1_7.A2 a_6968_17549# 0.01194f
C4216 sg13cmos5l_nand4_1_1.B sg13cmos5l_inv_1_12.A 0.01749f
C4217 sg13cmos5l_dfrbpq_1_13.RESET_B a_6487_6126# 0.10955f
C4218 sg13cmos5l_a21oi_1_6.A2 sg13cmos5l_a21oi_1_2.B1 0.03181f
C4219 sg13cmos5l_dfrbpq_1_28.RESET_B sg13cmos5l_a21oi_1_13.A2 0.02579f
C4220 sg13cmos5l_dfrbpq_1_28.RESET_B sg13cmos5l_buf_8_2.A 0.07495f
C4221 sg13cmos5l_nor4_1_1.D sg13cmos5l_a21oi_1_27.A1 0.11582f
C4222 sg13cmos5l_a21oi_1_27.B1 sg13cmos5l_and4_1_1.A 0.03007f
C4223 sg13cmos5l_nand4_1_3.D sg13cmos5l_a21oi_1_6.A2 0.02812f
C4224 sg13cmos5l_inv_1_15.A sg13cmos5l_a21oi_1_2.B1 0.02035f
C4225 sg13cmos5l_nor3_1_2.B a_5541_9165# 0.02427f
C4226 sg13cmos5l_inv_1_15.A sg13cmos5l_nand4_1_3.D 0.04218f
C4227 sg13cmos5l_dlygate4sd3_1_0.A bp8 0.02889f
C4228 sg13cmos5l_inv_1_8.A a_14938_6888# 0.03135f
C4229 sg13cmos5l_dfrbpq_1_23.D sg13cmos5l_dfrbpq_1_19.D 0.02654f
C4230 sg13cmos5l_nand2b_1_0.B sg13cmos5l_nand2_1_2.Y 0.06572f
C4231 sg13cmos5l_o21ai_1_17.B1 VDD 0.42737f
C4232 sg13cmos5l_o21ai_1_5.A2 sg13cmos5l_nor3_1_0.Y 0.01617f
C4233 a_13596_13686# VDD 0.07314f
C4234 sg13cmos5l_nor2b_1_1.A a_9716_15202# 0.06155f
C4235 sg13cmos5l_nand2_1_1.A sg13cmos5l_a21oi_1_13.Y 0.18155f
C4236 sg13cmos5l_o21ai_1_1.B1 sg13cmos5l_nand3_1_0.A 0.1974f
C4237 sg13cmos5l_a21o_1_2.A1 a_7078_14044# 0.06923f
C4238 sg13cmos5l_dfrbpq_1_41.CLK sg13cmos5l_buf_1_25.A 0.04192f
C4239 a_22126_17775# sg13cmos5l_inv_1_17.A 0.10678f
C4240 sg13cmos5l_nand3b_1_1.C sg13cmos5l_nand4_1_7.B 0.1826f
C4241 a_5999_14845# a_6666_14484# 0.09257f
C4242 a_13390_7863# a_13505_7864# 0.3854f
C4243 sg13cmos5l_o21ai_1_1.Y VDD 0.41449f
C4244 a_4182_19044# VDD 0.16085f
C4245 a_10607_5773# a_11274_5412# 0.09257f
C4246 sg13cmos5l_nand2b_1_3.Y VDD 0.27872f
C4247 sg13cmos5l_o21ai_1_7.A2 a_7941_19031# 0.02459f
C4248 sg13cmos5l_buf_8_2.A a_21839_11821# 0.02522f
C4249 a_12902_8436# VDD 0.2267f
C4250 a_10316_12936# sg13cmos5l_buf_1_22.A 0.19403f
C4251 sg13cmos5l_nand4_1_1.B sg13cmos5l_nand2_1_13.A 0.0103f
C4252 a_18104_18262# VDD 0.26202f
C4253 a_12420_19024# bn3 0.02731f
C4254 a_19054_18447# a_19169_18448# 0.3854f
C4255 sg13cmos5l_a21oi_1_17.Y sg13cmos5l_nand4_1_3.D 0.01268f
C4256 sg13cmos5l_and2_1_3.X a_16172_14448# 0.02815f
C4257 a_18374_18262# sg13cmos5l_nand4_1_17.Y 0.05058f
C4258 sg13cmos5l_buf_1_54.A sg13cmos5l_inv_1_1.A 0.05227f
C4259 sg13cmos5l_a21oi_1_9.B1 a_10592_4782# 0.02201f
C4260 sg13cmos5l_buf_8_2.A bn1 0.02276f
C4261 a_20580_6928# a_21745_7285# 0.25046f
C4262 sg13cmos5l_buf_1_10.A sg13cmos5l_nor2_1_0.Y 0.81932f
C4263 sg13cmos5l_dfrbpq_1_39.Q a_20503_18222# 0.04529f
C4264 sg13cmos5l_inv_1_3.Y sg13cmos5l_inv_1_2.Y 0.01278f
C4265 sg13cmos5l_o21ai_1_23.B1 sg13cmos5l_dlygate4sd3_1_80.X 0.12238f
C4266 sg13cmos5l_a22oi_1_0.B2 sg13cmos5l_nand2_1_0.B 0.21025f
C4267 sg13cmos5l_o21ai_1_0.A2 a_12545_9376# 0.02437f
C4268 sg13cmos5l_a21oi_1_13.Y a_20868_14909# 0.02065f
C4269 sg13cmos5l_nand3_1_5.Y sg13cmos5l_o21ai_1_11.Y 0.04736f
C4270 a_1192_14484# sg13cmos5l_inv_1_36.A 0.15674f
C4271 sg13cmos5l_inv_1_1.A sg13cmos5l_a21oi_1_3.Y 0.02629f
C4272 a_22096_13942# VDD 0.13554f
C4273 sg13cmos5l_nand2_1_6.A sg13cmos5l_dfrbpq_1_13.Q 0.01511f
C4274 sg13cmos5l_buf_1_43.X a_15392_13854# 0.03221f
C4275 sg13cmos5l_nand2_1_0.A clk 0.06683f
C4276 a_7912_12972# sg13cmos5l_dfrbpq_1_45.Q 0.19093f
C4277 sg13cmos5l_buf_1_9.A sg13cmos5l_inv_1_2.A 0.43672f
C4278 sg13cmos5l_mux2_1_0.S a_9056_11546# 0.01138f
C4279 sg13cmos5l_nand3_1_8.Y sg13cmos5l_nand4_1_18.C 0.02196f
C4280 a_21761_15424# a_22042_15202# 0.18796f
C4281 sg13cmos5l_a21oi_1_1.A2 sg13cmos5l_a21oi_1_2.B1 0.04613f
C4282 sg13cmos5l_a22oi_1_1.B2 sg13cmos5l_a21oi_1_10.A2 0.11938f
C4283 sg13cmos5l_nand4_1_18.B sg13cmos5l_buf_1_15.A 0.64219f
C4284 sg13cmos5l_dfrbpq_1_24.Q a_9446_13726# 0.02118f
C4285 a_20488_3176# bp4 0.15432f
C4286 sg13cmos5l_a21oi_1_27.B1 a_9350_12210# 0.0371f
C4287 a_19995_9190# VDD 0.86572f
C4288 sg13cmos5l_o21ai_1_12.Y a_5880_15552# 0.01087f
C4289 sg13cmos5l_nand4_1_1.C sg13cmos5l_nand4_1_18.C 0.12811f
C4290 sg13cmos5l_dfrbpq_1_13.CLK sg13cmos5l_a21oi_1_5.A2 0.01286f
C4291 a_7066_18226# VDD 0.2874f
C4292 sg13cmos5l_dfrbpq_1_5.CLK a_22241_17774# 0.03423f
C4293 a_19649_4840# VDD 0.20921f
C4294 a_18660_11016# a_19077_10677# 0.28324f
C4295 sg13cmos5l_buf_1_63.A code3 0.05416f
C4296 a_18374_10698# a_19179_10820# 0.07916f
C4297 a_16319_9456# a_16188_9150# 0.28418f
C4298 sg13cmos5l_buf_1_5.A a_19179_7796# 0.05177f
C4299 sg13cmos5l_buf_1_13.X a_17622_10766# 0.07128f
C4300 sg13cmos5l_dfrbpq_1_13.RESET_B a_7989_6320# 0.20191f
C4301 a_18101_14020# VDD 0.16691f
C4302 sg13cmos5l_dlygate4sd3_1_64.X sg13cmos5l_dfrbpq_1_24.RESET_B 0.06946f
C4303 a_13478_16434# a_13738_15964# 0.45119f
C4304 sg13cmos5l_nor2_1_12.Y valid 0.03459f
C4305 sg13cmos5l_a21oi_1_3.A2 sg13cmos5l_nand3_1_0.C 0.27195f
C4306 sg13cmos5l_a21o_1_1.A2 a_8206_9375# 0.02176f
C4307 sg13cmos5l_nand2_1_1.A sg13cmos5l_dfrbpq_1_28.D 0.02655f
C4308 sg13cmos5l_o21ai_1_9.B1 sg13cmos5l_o21ai_1_9.Y 0.18478f
C4309 sg13cmos5l_o21ai_1_19.Y sg13cmos5l_o21ai_1_19.B1 0.18261f
C4310 sg13cmos5l_nor2b_1_1.A sg13cmos5l_dfrbpq_1_18.Q 0.01735f
C4311 sg13cmos5l_buf_1_42.A sg13cmos5l_and2_1_3.X 0.28627f
C4312 sg13cmos5l_a21oi_1_27.B1 clk 0.01717f
C4313 sg13cmos5l_buf_1_59.A VDD 0.41947f
C4314 sg13cmos5l_nor2_1_2.B a_8061_7194# 0.03943f
C4315 a_12814_13239# a_12929_13238# 0.3854f
C4316 sg13cmos5l_o21ai_1_5.A1 sg13cmos5l_o21ai_1_12.Y 0.01448f
C4317 sg13cmos5l_nor2b_1_2.Y a_15436_7674# 0.03814f
C4318 sg13cmos5l_a21oi_1_2.A2 a_16773_5423# 0.04926f
C4319 a_12040_13058# a_12224_13058# 0.05762f
C4320 sg13cmos5l_nand3b_1_1.Y sg13cmos5l_o21ai_1_18.A2 0.18461f
C4321 sg13cmos5l_nand2b_1_1.A_N sg13cmos5l_nand3b_1_0.C 0.11565f
C4322 sg13cmos5l_buf_1_45.X sg13cmos5l_nand3b_1_3.C 0.12907f
C4323 sg13cmos5l_o21ai_1_3.Y a_15607_9150# 0.01799f
C4324 sg13cmos5l_o21ai_1_0.A2 a_13042_4646# 0.04914f
C4325 sg13cmos5l_buf_1_9.A a_21256_3900# 0.18786f
C4326 sg13cmos5l_a21o_1_2.X sg13cmos5l_o21ai_1_9.Y 0.04146f
C4327 sg13cmos5l_buf_1_21.A sg13cmos5l_o21ai_1_1.B1 0.03689f
C4328 sg13cmos5l_a22oi_1_2.Y a_12414_7996# 0.11903f
C4329 sg13cmos5l_dfrbpq_1_13.CLK sg13cmos5l_nor3_1_0.Y 0.03539f
C4330 a_19649_4840# bp6 0.02579f
C4331 sg13cmos5l_dlygate4sd3_1_7.X a_13974_6230# 0.02273f
C4332 sg13cmos5l_nand4_1_12.Y sg13cmos5l_a21oi_1_25.A2 0.16853f
C4333 sg13cmos5l_a21oi_1_18.B1 sg13cmos5l_inv_1_15.Y 0.18044f
C4334 sg13cmos5l_buf_1_8.A bp4 1.31437f
C4335 sg13cmos5l_a22oi_1_0.B2 a_13566_8412# 0.04962f
C4336 sg13cmos5l_a21oi_1_4.A2 sg13cmos5l_dlygate4sd3_1_13.A 0.02078f
C4337 a_22096_7166# a_22506_6924# 0.07015f
C4338 sg13cmos5l_dfrbpq_1_41.CLK a_14744_19061# 0.01963f
C4339 sg13cmos5l_o21ai_1_5.A1 sg13cmos5l_a21oi_1_27.A1 0.31131f
C4340 sg13cmos5l_buf_1_0.A a_21256_3176# 0.19652f
C4341 sg13cmos5l_nand4_1_8.B a_10833_14874# 0.06784f
C4342 sg13cmos5l_dfrbpq_1_28.RESET_B sg13cmos5l_buf_1_16.A 0.05333f
C4343 sg13cmos5l_buf_1_13.A sg13cmos5l_nand2b_1_3.B 0.12459f
C4344 sg13cmos5l_inv_1_2.A sg13cmos5l_inv_1_2.Y 0.06218f
C4345 sg13cmos5l_inv_1_17.A sg13cmos5l_nand3_1_8.Y 0.02523f
C4346 sg13cmos5l_or2_1_1.X VDD 0.68819f
C4347 sg13cmos5l_dfrbpq_1_28.RESET_B a_19054_18447# 0.02088f
C4348 sg13cmos5l_nand3_1_5.Y a_6968_17549# 0.01918f
C4349 sg13cmos5l_inv_1_32.Y sg13cmos5l_dlygate4sd3_1_80.X 0.11514f
C4350 sg13cmos5l_nand2b_1_3.B a_16650_6460# 0.08579f
C4351 a_5318_13410# VDD 0.52803f
C4352 sg13cmos5l_nor3_1_6.Y a_5259_14495# 0.0159f
C4353 sg13cmos5l_inv_1_1.A sg13cmos5l_dfrbpq_1_0.D 0.01511f
C4354 sg13cmos5l_a21oi_1_23.A2 a_17984_13854# 0.02062f
C4355 sg13cmos5l_dlygate4sd3_1_58.X sg13cmos5l_dfrbpq_1_19.CLK 0.02186f
C4356 sg13cmos5l_buf_1_1.A sg13cmos5l_a21oi_1_6.Y 2.22414f
C4357 a_7822_19959# VDD 0.1584f
C4358 a_14763_19892# code2 0.02422f
C4359 sg13cmos5l_o21ai_1_0.A2 sg13cmos5l_nor4_1_0.Y 0.02283f
C4360 a_6881_7190# VDD 0.20962f
C4361 sg13cmos5l_a21oi_1_1.A2 a_22235_5412# 0.07311f
C4362 sg13cmos5l_buf_1_15.A a_9558_13790# 0.02049f
C4363 sg13cmos5l_nor2_1_10.Y sg13cmos5l_o21ai_1_20.A1 0.13194f
C4364 sg13cmos5l_mux2_1_0.S a_8694_14020# 0.01631f
C4365 a_6209_16936# sg13cmos5l_o21ai_1_10.Y 0.01385f
C4366 sg13cmos5l_a21oi_1_6.A2 a_19624_8522# 0.02667f
C4367 sg13cmos5l_inv_1_31.A sg13cmos5l_inv_1_1.Y 0.44913f
C4368 sg13cmos5l_a21oi_1_15.A2 sg13cmos5l_inv_1_20.Y 0.12104f
C4369 sg13cmos5l_a21oi_1_9.B1 sg13cmos5l_a21oi_1_9.A2 0.9393f
C4370 sg13cmos5l_o21ai_1_21.B1 VDD 0.48658f
C4371 sg13cmos5l_buf_1_45.X a_14661_19749# 0.03624f
C4372 a_18490_9154# VDD 0.26132f
C4373 sg13cmos5l_nand2_1_12.Y valid 0.01542f
C4374 a_10049_9376# clk 0.04262f
C4375 sg13cmos5l_dfrbpq_1_11.D a_16566_8460# 0.01834f
C4376 sg13cmos5l_inv_1_16.Y sg13cmos5l_buf_1_13.X 0.01198f
C4377 a_18401_16936# a_18682_16714# 0.18796f
C4378 sg13cmos5l_buf_1_2.A sg13cmos5l_dfrbpq_1_0.D 0.01394f
C4379 sg13cmos5l_a21oi_1_19.Y sg13cmos5l_o21ai_1_23.B1 0.01486f
C4380 sg13cmos5l_buf_1_42.A a_19534_16263# 0.01032f
C4381 sg13cmos5l_dfrbpq_1_19.CLK sg13cmos5l_dfrbpq_1_23.Q 0.01258f
C4382 sg13cmos5l_buf_1_5.A a_19242_8436# 0.05642f
C4383 a_7895_6553# a_7850_6320# 0.18486f
C4384 a_20974_16434# a_21215_15967# 0.01058f
C4385 sg13cmos5l_dfrbpq_1_5.CLK sg13cmos5l_buf_1_7.X 0.03136f
C4386 sg13cmos5l_buf_1_25.A bn3 5.31512f
C4387 sg13cmos5l_nand2_1_1.A sg13cmos5l_dlygate4sd3_1_13.A 0.13968f
C4388 sg13cmos5l_buf_1_14.A a_15405_11808# 0.01364f
C4389 sg13cmos5l_buf_1_15.A sg13cmos5l_buf_8_2.A 0.14472f
C4390 sg13cmos5l_a21oi_1_6.Y bn9 0.02944f
C4391 sg13cmos5l_o21ai_1_25.Y a_13478_17946# 0.02985f
C4392 sg13cmos5l_o21ai_1_21.Y sg13cmos5l_o21ai_1_10.Y 0.4948f
C4393 sg13cmos5l_inv_1_20.Y sg13cmos5l_nand2_1_0.A 0.10567f
C4394 sg13cmos5l_o21ai_1_0.Y a_13148_4968# 0.01087f
C4395 sg13cmos5l_dfrbpq_1_15.CLK a_6113_13912# 0.01095f
C4396 a_6487_6126# a_7068_6126# 0.01412f
C4397 a_6700_6162# a_7047_6380# 0.03546f
C4398 sg13cmos5l_a21oi_1_0.Y a_18948_5416# 0.02589f
C4399 sg13cmos5l_o21ai_1_26.B1 a_12632_17549# 0.01156f
C4400 sg13cmos5l_nand4_1_6.B a_13384_14484# 0.01026f
C4401 sg13cmos5l_a21o_1_2.X a_6835_13916# 0.11666f
C4402 sg13cmos5l_dfrbpq_1_28.Q a_20997_12189# 0.01246f
C4403 sg13cmos5l_dfrbpq_1_1.D a_18662_5850# 0.16153f
C4404 sg13cmos5l_dfrbpq_1_5.CLK sg13cmos5l_a21oi_1_14.Y 1.00452f
C4405 sg13cmos5l_nand2_1_11.B sg13cmos5l_nand2_1_9.Y 0.31191f
C4406 sg13cmos5l_dfrbpq_1_13.CLK a_14842_11424# 0.01089f
C4407 sg13cmos5l_nand2b_1_0.B sg13cmos5l_nor2b_1_0.B_N 0.06668f
C4408 sg13cmos5l_nand4_1_18.B sg13cmos5l_o21ai_1_20.A1 0.02259f
C4409 sg13cmos5l_buf_1_8.A a_20872_3176# 0.19354f
C4410 sg13cmos5l_dlygate4sd3_1_42.X sg13cmos5l_nor3_1_2.Y 0.11233f
C4411 sg13cmos5l_a21oi_1_18.B1 sg13cmos5l_a21oi_1_14.Y 0.13521f
C4412 sg13cmos5l_buf_1_5.A a_18948_5416# 0.01734f
C4413 a_18374_18262# VDD 0.20743f
C4414 sg13cmos5l_buf_1_25.A sg13cmos5l_nor4_1_2.Y 0.223f
C4415 sg13cmos5l_nand4_1_18.B sg13cmos5l_buf_1_54.A 0.04935f
C4416 a_20294_11898# a_20580_11464# 0.26205f
C4417 a_16550_19770# a_17355_19892# 0.07916f
C4418 a_16836_20088# a_17253_19749# 0.28324f
C4419 sg13cmos5l_inv_1_17.Y sg13cmos5l_dlygate4sd3_1_28.A 0.04026f
C4420 sg13cmos5l_o21ai_1_7.Y sg13cmos5l_o21ai_1_21.A2 0.02294f
C4421 a_4838_9186# a_5124_9504# 0.26205f
C4422 sg13cmos5l_a21oi_1_19.Y sg13cmos5l_a21oi_1_19.A2 0.02064f
C4423 sg13cmos5l_o21ai_1_21.Y sg13cmos5l_dfrbpq_1_23.D 0.0271f
C4424 sg13cmos5l_nand3b_1_3.C sg13cmos5l_dlygate4sd3_1_51.X 0.01567f
C4425 sg13cmos5l_inv_1_15.Y sg13cmos5l_inv_1_1.A 0.11321f
C4426 sg13cmos5l_nor3_1_6.Y sg13cmos5l_and4_1_1.A 0.66424f
C4427 a_14244_20088# code0 0.03766f
C4428 sg13cmos5l_buf_1_54.A code0 0.01444f
C4429 sg13cmos5l_dlygate4sd3_1_37.A VDD 0.24073f
C4430 sg13cmos5l_a21oi_1_2.B1 bp8 0.02268f
C4431 sg13cmos5l_a21oi_1_4.A2 sg13cmos5l_nand2_1_15.Y 0.01475f
C4432 sg13cmos5l_o21ai_1_25.B1 a_15023_17869# 0.02239f
C4433 sg13cmos5l_inv_1_4.Y a_20580_8440# 0.01224f
C4434 sg13cmos5l_nand4_1_1.C bp0 0.0215f
C4435 sg13cmos5l_a21oi_1_7.A2 sg13cmos5l_dfrbpq_1_7.D 0.02421f
C4436 sg13cmos5l_o21ai_1_7.B1 sg13cmos5l_o21ai_1_20.A1 0.01984f
C4437 sg13cmos5l_o21ai_1_23.B1 bn0 0.01501f
C4438 a_9062_19770# a_9765_19749# 0.02453f
C4439 sg13cmos5l_a21oi_1_8.A1 a_8021_5412# 0.03521f
C4440 sg13cmos5l_nor2_1_7.Y sg13cmos5l_dlygate4sd3_1_62.A 0.0166f
C4441 sg13cmos5l_mux2_1_1.A1 sg13cmos5l_dfrbpq_1_45.Q 0.23604f
C4442 sg13cmos5l_a22oi_1_0.B2 sg13cmos5l_inv_1_18.Y 0.11647f
C4443 sg13cmos5l_buf_1_1.A sg13cmos5l_buf_1_7.X 0.06816f
C4444 sg13cmos5l_a21oi_1_9.A1 a_11393_6352# 0.01339f
C4445 a_18574_14751# sg13cmos5l_inv_1_16.A 0.10784f
C4446 sg13cmos5l_dfrbpq_1_18.Q a_11674_12936# 0.35184f
C4447 sg13cmos5l_inv_1_31.A a_21215_15967# 0.03605f
C4448 sg13cmos5l_inv_1_13.Y sg13cmos5l_nor3_1_7.Y 0.02491f
C4449 sg13cmos5l_nand4_1_8.B sg13cmos5l_and4_1_1.A 0.11425f
C4450 sg13cmos5l_inv_1_5.A sg13cmos5l_inv_1_4.Y 0.50525f
C4451 sg13cmos5l_a21oi_1_9.A1 a_11278_6351# 0.01691f
C4452 sg13cmos5l_a21oi_1_7.A2 a_20580_9952# 0.01124f
C4453 sg13cmos5l_nand4_1_15.B sg13cmos5l_a21oi_1_4.A2 0.06342f
C4454 sg13cmos5l_mux2_1_1.A0 a_9557_11460# 0.10375f
C4455 sg13cmos5l_nor3_1_1.Y a_11278_6351# 0.02241f
C4456 a_19077_10677# a_19825_10775# 0.01058f
C4457 a_19919_10775# a_20176_10918# 0.23043f
C4458 a_13738_17476# bn0 0.01375f
C4459 sg13cmos5l_buf_1_15.A a_5578_12940# 0.03315f
C4460 sg13cmos5l_dlygate4sd3_1_82.X VDD 0.21512f
C4461 a_4736_9318# VDD 0.08727f
C4462 sg13cmos5l_a21oi_1_2.A2 a_17316_8440# 0.03553f
C4463 sg13cmos5l_dfrbpq_1_11.D a_17835_8447# 0.02328f
C4464 sg13cmos5l_a21oi_1_10.Y a_10042_6130# 0.29912f
C4465 sg13cmos5l_o21ai_1_25.Y sg13cmos5l_dfrbpq_1_41.CLK 0.25721f
C4466 a_16319_9456# a_16970_9344# 0.01562f
C4467 sg13cmos5l_buf_1_7.X a_15983_6239# 0.01396f
C4468 sg13cmos5l_inv_1_16.Y sg13cmos5l_inv_1_13.Y 0.02192f
C4469 sg13cmos5l_buf_1_26.A code0 0.022f
C4470 sg13cmos5l_inv_1_32.Y sg13cmos5l_inv_1_24.A 0.04429f
C4471 a_21099_9959# VDD 0.20566f
C4472 sg13cmos5l_nor3_1_6.Y sg13cmos5l_and2_1_6.A 0.03728f
C4473 a_8006_7678# sg13cmos5l_nand2b_1_4.B 0.02087f
C4474 sg13cmos5l_a21oi_1_4.A1 sg13cmos5l_buf_1_53.A 0.19024f
C4475 sg13cmos5l_nand2_1_13.Y VDD 0.32967f
C4476 sg13cmos5l_nand4_1_1.B sg13cmos5l_nand4_1_18.C 0.01838f
C4477 sg13cmos5l_mux2_1_0.A1 a_7736_13726# 0.0169f
C4478 a_21866_16276# a_21911_16043# 0.18486f
C4479 sg13cmos5l_a21oi_1_9.Y a_9646_6351# 0.02689f
C4480 sg13cmos5l_o21ai_1_25.Y a_14052_17933# 0.02588f
C4481 sg13cmos5l_o21ai_1_11.Y a_6490_16714# 0.02847f
C4482 a_14218_18226# bn2 0.06947f
C4483 sg13cmos5l_o21ai_1_3.Y a_16167_9404# 0.02661f
C4484 a_7068_6126# a_7989_6320# 0.24169f
C4485 a_13212_5773# a_13191_5499# 0.20773f
C4486 sg13cmos5l_buf_1_7.X bn9 0.03096f
C4487 sg13cmos5l_dlygate4sd3_1_56.X a_10694_18258# 0.18155f
C4488 sg13cmos5l_buf_1_13.A sg13cmos5l_dfrbpq_1_2.D 0.07829f
C4489 sg13cmos5l_nand2_1_12.Y sg13cmos5l_nor2_1_16.Y 0.03672f
C4490 a_20997_13701# bn7 0.04375f
C4491 a_4932_19024# a_5349_19031# 0.28418f
C4492 a_4646_19458# a_5451_19031# 0.07916f
C4493 sg13cmos5l_dlygate4sd3_1_81.X sg13cmos5l_a21oi_1_20.Y 0.05228f
C4494 a_20398_13239# a_20513_13238# 0.3854f
C4495 a_11072_13058# VDD 0.08266f
C4496 sg13cmos5l_dfrbpq_1_15.Q a_6671_7751# 0.02701f
C4497 sg13cmos5l_a21oi_1_25.Y a_16763_17508# 0.10005f
C4498 a_13198_9228# VDD 0.17245f
C4499 sg13cmos5l_nor3_1_6.Y a_9350_12210# 0.0118f
C4500 sg13cmos5l_inv_1_1.A sg13cmos5l_buf_1_7.X 0.9689f
C4501 sg13cmos5l_nor2b_1_2.Y a_14938_6888# 0.01174f
C4502 sg13cmos5l_nand3b_1_0.C VDD 0.5532f
C4503 sg13cmos5l_nand2_1_0.A sg13cmos5l_nand2_1_0.B 0.17832f
C4504 sg13cmos5l_nand4_1_16.D sg13cmos5l_nand4_1_1.C 0.15145f
C4505 a_20580_11464# a_20868_11885# 0.24435f
C4506 a_9147_13028# VDD 0.19494f
C4507 a_10326_14484# VDD 0.01746f
C4508 sg13cmos5l_o21ai_1_4.Y sg13cmos5l_o21ai_1_0.B1 0.01987f
C4509 sg13cmos5l_nand4_1_15.B sg13cmos5l_buf_1_57.A 0.02066f
C4510 sg13cmos5l_dfrbpq_1_19.CLK a_5349_19031# 0.19312f
C4511 sg13cmos5l_dfrbpq_1_13.CLK sg13cmos5l_o21ai_1_0.Y 0.01658f
C4512 a_5998_17775# sg13cmos5l_dfrbpq_1_23.D 0.10664f
C4513 sg13cmos5l_dfrbpq_1_28.RESET_B sg13cmos5l_buf_1_53.A 0.0943f
C4514 sg13cmos5l_inv_1_17.Y sg13cmos5l_dfrbpq_1_7.D 0.02109f
C4515 sg13cmos5l_buf_1_13.X bp1 0.01897f
C4516 sg13cmos5l_a21oi_1_27.A1 sg13cmos5l_dfrbpq_1_13.CLK 0.11105f
C4517 a_4952_17549# a_5222_17508# 0.18796f
C4518 a_10330_9154# VDD 0.26939f
C4519 sg13cmos5l_nor2b_1_0.B_N a_12016_10190# 0.04537f
C4520 a_11840_9389# sg13cmos5l_nand3_1_0.A 0.17339f
C4521 a_12614_6166# a_12726_6230# 0.3854f
C4522 sg13cmos5l_buf_1_15.A sg13cmos5l_buf_1_16.A 0.01512f
C4523 sg13cmos5l_a21oi_1_1.A2 a_19077_7653# 0.03771f
C4524 sg13cmos5l_inv_1_18.Y a_14061_8784# 0.15377f
C4525 sg13cmos5l_a21oi_1_11.Y a_12726_6230# 0.01383f
C4526 sg13cmos5l_a21oi_1_9.A1 sg13cmos5l_o21ai_1_4.Y 0.07207f
C4527 sg13cmos5l_inv_1_32.Y bn0 0.07946f
C4528 a_21366_10766# sg13cmos5l_buf_1_9.A 0.11726f
C4529 sg13cmos5l_dfrbpq_1_41.CLK valid 1.17634f
C4530 sg13cmos5l_dfrbpq_1_24.Q a_11393_13238# 0.03185f
C4531 sg13cmos5l_buf_8_2.A a_18470_17946# 0.04809f
C4532 sg13cmos5l_nor3_1_4.A sg13cmos5l_buf_1_22.A 0.04788f
C4533 sg13cmos5l_a21oi_1_9.A1 a_12726_6230# 0.11486f
C4534 sg13cmos5l_dfrbpq_1_9.Q a_19733_6924# 0.0445f
C4535 sg13cmos5l_buf_8_2.A sg13cmos5l_o21ai_1_20.A1 0.04142f
C4536 sg13cmos5l_a21oi_1_23.A2 sg13cmos5l_inv_1_16.A 0.0991f
C4537 sg13cmos5l_nand2_1_6.A sg13cmos5l_nand2b_1_3.Y 0.04642f
C4538 a_14661_19749# a_14532_19783# 0.01562f
C4539 a_20984_10702# sg13cmos5l_buf_1_9.A 0.02424f
C4540 sg13cmos5l_buf_1_45.X bn2 0.22587f
C4541 sg13cmos5l_dfrbpq_1_37.D bn6 0.03612f
C4542 sg13cmos5l_buf_8_2.A sg13cmos5l_buf_1_54.A 0.04435f
C4543 a_10053_12189# a_10155_12332# 0.36168f
C4544 sg13cmos5l_a21oi_1_0.A2 a_18634_10921# 0.01975f
C4545 sg13cmos5l_dfrbpq_1_9.Q sg13cmos5l_dlygate4sd3_1_29.A 0.05833f
C4546 sg13cmos5l_buf_1_7.X sg13cmos5l_buf_1_2.A 0.11704f
C4547 sg13cmos5l_a21oi_1_25.A2 sg13cmos5l_buf_1_42.A 0.14773f
C4548 sg13cmos5l_inv_1_12.A sg13cmos5l_inv_1_12.Y 0.2121f
C4549 sg13cmos5l_mux2_1_1.A1 a_9636_12528# 0.042f
C4550 a_10365_7194# sg13cmos5l_dfrbpq_1_47.Q 0.11694f
C4551 sg13cmos5l_nand4_1_6.B bn4 0.13788f
C4552 a_15690_15996# a_16172_15960# 0.01735f
C4553 sg13cmos5l_o21ai_1_7.Y sg13cmos5l_nand3b_1_3.C 0.05885f
C4554 a_14920_14484# bn5 0.0675f
C4555 sg13cmos5l_inv_1_5.A sg13cmos5l_nand3_1_0.Y 0.39545f
C4556 sg13cmos5l_nor3_1_2.B sg13cmos5l_o21ai_1_6.Y 0.11505f
C4557 sg13cmos5l_buf_8_2.A sg13cmos5l_a21oi_1_3.Y 0.01426f
C4558 sg13cmos5l_buf_8_2.A a_14181_17519# 0.02002f
C4559 sg13cmos5l_buf_1_66.X sg13cmos5l_nand4_1_6.B 0.13011f
C4560 sg13cmos5l_a21oi_1_2.A2 sg13cmos5l_nand3_1_0.C 0.10903f
C4561 sg13cmos5l_dlygate4sd3_1_16.A VDD 0.36889f
C4562 sg13cmos5l_nand4_1_17.Y bn4 0.01857f
C4563 sg13cmos5l_mux2_1_0.A1 a_8118_13790# 0.01344f
C4564 a_17126_7362# a_17829_6935# 0.02431f
C4565 sg13cmos5l_a21oi_1_2.A2 a_16950_9972# 0.04265f
C4566 a_18188_4614# VDD 0.18133f
C4567 sg13cmos5l_dfrbpq_1_3.D a_18094_9375# 0.01682f
C4568 sg13cmos5l_nor2b_1_1.A a_8830_17874# 0.10603f
C4569 sg13cmos5l_nand4_1_3.D a_16469_14484# 0.01541f
C4570 sg13cmos5l_a21oi_1_4.A1 sg13cmos5l_nand4_1_3.D 0.04965f
C4571 sg13cmos5l_nor4_1_0.C clk 0.02481f
C4572 sg13cmos5l_o21ai_1_11.Y sg13cmos5l_nor2_1_7.Y 0.02241f
C4573 sg13cmos5l_buf_1_66.X a_7858_16742# 0.05708f
C4574 sg13cmos5l_nand3_1_2.A sg13cmos5l_buf_1_14.A 0.17238f
C4575 sg13cmos5l_inv_1_15.Y sg13cmos5l_nand4_1_18.D 0.02441f
C4576 a_13212_5773# a_14039_5459# 0.26205f
C4577 sg13cmos5l_dfrbpq_1_18.Q a_11656_15272# 0.01033f
C4578 sg13cmos5l_and4_1_1.A sg13cmos5l_dfrbpq_1_24.Q 0.60391f
C4579 sg13cmos5l_buf_1_26.A sg13cmos5l_buf_8_2.A 0.85924f
C4580 sg13cmos5l_o21ai_1_1.Y sg13cmos5l_inv_1_11.Y 0.11623f
C4581 a_7310_12400# a_7416_12404# 0.28837f
C4582 sg13cmos5l_nand4_1_7.B a_15690_15996# 0.03339f
C4583 sg13cmos5l_dfrbpq_1_41.CLK sg13cmos5l_nand4_1_15.B 0.01866f
C4584 sg13cmos5l_nand2b_1_1.A_N VDD 1.9828f
C4585 sg13cmos5l_nor3_1_0.Y sg13cmos5l_o21ai_1_1.B1 0.35949f
C4586 sg13cmos5l_nor2_1_2.A a_8878_7191# 0.10665f
C4587 sg13cmos5l_nand4_1_6.B VDD 0.51619f
C4588 a_4932_19024# a_6097_19381# 0.25046f
C4589 a_21063_16083# VDD 0.20435f
C4590 sg13cmos5l_nor2_1_2.B clk 0.0225f
C4591 a_13676_12936# VDD 0.18066f
C4592 sg13cmos5l_nor2_1_7.Y sg13cmos5l_nand4_1_3.B 0.10646f
C4593 sg13cmos5l_nand4_1_15.B sg13cmos5l_nand4_1_1.A 0.02903f
C4594 a_20554_12433# a_20997_12189# 0.02241f
C4595 a_20294_12210# a_20580_12528# 0.26205f
C4596 a_21099_11471# a_22096_11702# 0.03546f
C4597 sg13cmos5l_dlygate4sd3_1_58.X a_8783_19381# 0.02092f
C4598 a_6640_9406# a_7050_9484# 0.07015f
C4599 a_15358_14850# a_15684_14850# 0.01251f
C4600 sg13cmos5l_nand3_1_2.Y bn2 0.14019f
C4601 sg13cmos5l_buf_8_2.A sg13cmos5l_o21ai_1_9.B1 0.02946f
C4602 sg13cmos5l_nor4_1_4.C sg13cmos5l_buf_1_20.A 0.02917f
C4603 sg13cmos5l_nand4_1_17.Y VDD 0.63253f
C4604 sg13cmos5l_dfrbpq_1_5.CLK a_19077_10677# 0.19469f
C4605 a_13384_14484# VDD 0.21625f
C4606 a_9466_18226# a_9848_18262# 0.04548f
C4607 sg13cmos5l_dfrbpq_1_23.D a_5792_17594# 0.01501f
C4608 sg13cmos5l_o21ai_1_5.A2 a_11372_10662# 0.15584f
C4609 sg13cmos5l_inv_1_15.A sg13cmos5l_inv_1_24.Y 0.01002f
C4610 sg13cmos5l_buf_1_1.A bp4 0.02313f
C4611 sg13cmos5l_buf_1_63.A sg13cmos5l_nand2_1_12.Y 0.19946f
C4612 sg13cmos5l_a21o_1_2.B1 sg13cmos5l_o21ai_1_9.B1 0.016f
C4613 sg13cmos5l_o21ai_1_3.Y sg13cmos5l_o21ai_1_1.Y 0.0152f
C4614 a_6394_17472# sg13cmos5l_o21ai_1_11.Y 0.31848f
C4615 sg13cmos5l_buf_1_15.A a_12929_13238# 0.01202f
C4616 sg13cmos5l_buf_1_16.A sg13cmos5l_dlygate4sd3_1_1.A 0.09794f
C4617 sg13cmos5l_nand4_1_18.B sg13cmos5l_inv_1_15.Y 0.11446f
C4618 sg13cmos5l_nand2_1_0.B a_12826_9154# 0.01244f
C4619 sg13cmos5l_o21ai_1_15.B1 a_10172_19000# 0.01087f
C4620 sg13cmos5l_o21ai_1_14.Y sg13cmos5l_o21ai_1_21.Y 0.15894f
C4621 sg13cmos5l_buf_8_2.A a_17243_17508# 0.01616f
C4622 sg13cmos5l_buf_1_15.A sg13cmos5l_buf_1_22.A 0.01072f
C4623 sg13cmos5l_nand4_1_16.D sg13cmos5l_dlygate4sd3_1_81.X 0.08796f
C4624 a_2156_19734# sg13cmos5l_dlygate4sd3_1_64.X 0.19688f
C4625 sg13cmos5l_inv_1_15.A bn7 0.1231f
C4626 a_9350_12210# a_9924_12223# 0.18486f
C4627 sg13cmos5l_or4_1_1.X sg13cmos5l_nand4_1_15.B 0.0578f
C4628 a_10155_12332# a_11152_12430# 0.03412f
C4629 a_11368_16878# bn3 0.01742f
C4630 a_1294_19959# a_1409_19960# 0.3854f
C4631 sg13cmos5l_dfrbpq_1_37.D sg13cmos5l_dfrbpq_1_30.D 0.34501f
C4632 sg13cmos5l_nand4_1_1.A sg13cmos5l_a21oi_1_15.A2 0.23363f
C4633 a_11840_5498# VDD 0.06193f
C4634 sg13cmos5l_nand3_1_2.Y sg13cmos5l_buf_1_14.A 0.01488f
C4635 sg13cmos5l_nand3_1_0.Y sg13cmos5l_dlygate4sd3_1_29.X 0.02093f
C4636 sg13cmos5l_buf_1_15.A sg13cmos5l_dfrbpq_1_45.Q 0.02165f
C4637 sg13cmos5l_a21oi_1_2.A2 a_18021_11471# 0.01925f
C4638 sg13cmos5l_nand4_1_8.B a_10696_15272# 0.01262f
C4639 sg13cmos5l_nand4_1_1.B bp0 0.0205f
C4640 a_16556_15960# sg13cmos5l_nand4_1_16.D 0.19246f
C4641 sg13cmos5l_o21ai_1_25.Y bn3 0.01472f
C4642 sg13cmos5l_a21oi_1_7.A2 sg13cmos5l_buf_1_13.X 0.02174f
C4643 a_4568_15238# a_4838_15238# 0.18796f
C4644 sg13cmos5l_buf_1_1.A a_22042_15202# 0.01934f
C4645 sg13cmos5l_buf_1_66.X sg13cmos5l_o21ai_1_11.A2 0.02476f
C4646 sg13cmos5l_a21oi_1_2.A2 a_15804_7638# 0.0445f
C4647 sg13cmos5l_buf_8_2.A a_15690_17508# 0.01007f
C4648 sg13cmos5l_and4_1_0.D sg13cmos5l_a21oi_1_9.B1 0.1427f
C4649 sg13cmos5l_or2_1_1.X sg13cmos5l_nand2_1_6.A 0.01042f
C4650 bp4 bn9 0.03423f
C4651 bp5 bp3 0.54131f
C4652 sg13cmos5l_nor3_1_2.B sg13cmos5l_a21o_1_0.X 0.05382f
C4653 sg13cmos5l_mux2_1_0.A1 sg13cmos5l_a21oi_1_27.A1 0.02437f
C4654 sg13cmos5l_a21oi_1_3.A2 sg13cmos5l_buf_1_13.X 0.28176f
C4655 a_17412_6928# a_17931_6935# 0.20754f
C4656 a_17829_6935# a_17700_7349# 0.01562f
C4657 a_13676_19734# sg13cmos5l_inv_1_32.Y 0.03055f
C4658 sg13cmos5l_inv_1_1.A bp4 0.01717f
C4659 sg13cmos5l_nand2_1_15.Y a_14842_13342# 0.01727f
C4660 sg13cmos5l_nand4_1_5.D sg13cmos5l_inv_1_24.Y 0.01023f
C4661 sg13cmos5l_inv_1_1.Y a_20580_8440# 0.04528f
C4662 sg13cmos5l_o21ai_1_28.A1 sg13cmos5l_inv_1_24.Y 0.10356f
C4663 sg13cmos5l_o21ai_1_5.A2 sg13cmos5l_nand2_1_19.A 0.0432f
C4664 sg13cmos5l_nor3_1_6.Y sg13cmos5l_inv_1_20.Y 0.02285f
C4665 sg13cmos5l_a21o_1_1.A2 sg13cmos5l_nor3_1_2.A 0.15751f
C4666 sg13cmos5l_buf_1_13.X a_17098_6130# 0.03883f
C4667 sg13cmos5l_o21ai_1_11.A2 VDD 0.39728f
C4668 sg13cmos5l_buf_1_16.A sg13cmos5l_buf_1_54.A 0.02785f
C4669 sg13cmos5l_buf_1_13.A sg13cmos5l_buf_1_0.A 0.08055f
C4670 sg13cmos5l_o21ai_1_1.B1 a_14842_11424# 0.02241f
C4671 a_10980_18576# a_11499_18380# 0.20773f
C4672 sg13cmos5l_inv_1_20.Y sg13cmos5l_inv_1_9.Y 0.53416f
C4673 sg13cmos5l_dfrbpq_1_15.CLK a_5318_13410# 0.04467f
C4674 sg13cmos5l_inv_1_8.A a_14724_6480# 0.01945f
C4675 a_21084_16357# a_21866_16276# 0.24435f
C4676 sg13cmos5l_dfrbpq_1_19.CLK a_7941_19031# 0.2213f
C4677 sg13cmos5l_a21oi_1_24.A1 a_11499_18380# 0.01467f
C4678 a_12381_13912# a_12463_13726# 0.01126f
C4679 sg13cmos5l_nor3_1_2.A sg13cmos5l_dlygate4sd3_1_43.X 0.0335f
C4680 sg13cmos5l_nor4_1_1.D sg13cmos5l_dfrbpq_1_18.Q 0.02867f
C4681 sg13cmos5l_inv_1_17.A a_22241_9376# 0.02401f
C4682 sg13cmos5l_buf_1_14.A sg13cmos5l_nand3_1_1.Y 1.49231f
C4683 a_12394_18988# a_12837_19031# 0.02241f
C4684 sg13cmos5l_inv_1_36.A sg13cmos5l_o21ai_1_9.Y 0.71247f
C4685 a_6394_17472# a_6968_17549# 0.01948f
C4686 sg13cmos5l_o21ai_1_11.Y a_6113_17774# 0.05362f
C4687 sg13cmos5l_inv_1_17.Y a_19930_12936# 0.01954f
C4688 sg13cmos5l_o21ai_1_13.B1 a_12140_19734# 0.02033f
C4689 sg13cmos5l_nor4_1_1.D a_8411_15532# 0.03152f
C4690 sg13cmos5l_buf_1_2.A bp4 0.51965f
C4691 sg13cmos5l_buf_1_57.A a_12616_14484# 0.01195f
C4692 sg13cmos5l_dfrbpq_1_27.Q bn8 0.02732f
C4693 sg13cmos5l_inv_1_17.Y a_19733_6924# 0.01971f
C4694 sg13cmos5l_nand2_1_0.A sg13cmos5l_inv_1_18.Y 0.01924f
C4695 sg13cmos5l_dlygate4sd3_1_15.X a_13749_9386# 0.05744f
C4696 a_4454_14922# a_5259_14495# 0.07916f
C4697 sg13cmos5l_o21ai_1_5.A1 a_10053_12189# 0.02067f
C4698 sg13cmos5l_o21ai_1_20.B1 sg13cmos5l_nand3_1_5.Y 0.2374f
C4699 bn3 valid 0.02228f
C4700 a_14532_19783# bn2 0.02728f
C4701 sg13cmos5l_buf_1_15.A sg13cmos5l_buf_1_53.A 0.02411f
C4702 sg13cmos5l_buf_1_26.A sg13cmos5l_buf_1_16.A 0.06269f
C4703 sg13cmos5l_nand2b_1_0.B sg13cmos5l_buf_1_10.A 0.02121f
C4704 sg13cmos5l_inv_1_17.Y sg13cmos5l_dlygate4sd3_1_29.A 0.12677f
C4705 sg13cmos5l_buf_1_0.A bp7 0.12664f
C4706 sg13cmos5l_a21oi_1_0.A2 sg13cmos5l_inv_1_14.Y 0.01854f
C4707 a_11152_12430# a_11562_12508# 0.07015f
C4708 sg13cmos5l_dfrbpq_1_19.D a_4727_16043# 0.17108f
C4709 a_9096_15996# a_9190_15996# 0.02125f
C4710 sg13cmos5l_o21ai_1_7.A2 sg13cmos5l_dfrbpq_1_24.RESET_B 0.20985f
C4711 sg13cmos5l_a21oi_1_0.A2 a_18928_7166# 0.01111f
C4712 sg13cmos5l_inv_1_17.Y sg13cmos5l_buf_1_13.X 0.05345f
C4713 sg13cmos5l_nor4_1_2.Y valid 0.32616f
C4714 sg13cmos5l_inv_1_13.Y sg13cmos5l_a21oi_1_7.A2 0.01681f
C4715 sg13cmos5l_o21ai_1_11.A2 a_6418_15230# 0.04801f
C4716 sg13cmos5l_dfrbpq_1_20.Q a_4932_19024# 0.01999f
C4717 sg13cmos5l_buf_8_2.A sg13cmos5l_inv_1_15.Y 0.60282f
C4718 sg13cmos5l_dfrbpq_1_24.RESET_B sg13cmos5l_mux2_1_0.A1 0.01438f
C4719 sg13cmos5l_o21ai_1_0.A2 sg13cmos5l_a21oi_1_9.A2 0.04142f
C4720 sg13cmos5l_a21oi_1_18.B1 a_16172_15960# 0.15728f
C4721 a_21089_19960# sg13cmos5l_dfrbpq_1_39.Q 0.05712f
C4722 sg13cmos5l_dfrbpq_1_13.CLK a_10607_5773# 0.017f
C4723 a_15496_5498# a_15680_5498# 0.05762f
C4724 sg13cmos5l_dfrbpq_1_18.Q a_11562_12508# 0.07933f
C4725 a_17931_6935# a_18671_7285# 0.17382f
C4726 VDD bn4 0.33235f
C4727 sg13cmos5l_a21oi_1_27.B1 sg13cmos5l_or4_1_1.X 0.39409f
C4728 a_20104_3176# bp7 0.16246f
C4729 a_20503_16710# a_21063_16964# 0.17382f
C4730 sg13cmos5l_dlygate4sd3_1_29.A a_18778_6130# 0.28803f
C4731 sg13cmos5l_o21ai_1_23.A2 a_13400_15238# 0.01105f
C4732 a_12632_17549# bn1 0.01079f
C4733 sg13cmos5l_dfrbpq_1_20.Q sg13cmos5l_dfrbpq_1_19.CLK 1.22606f
C4734 sg13cmos5l_dfrbpq_1_5.CLK a_21531_13342# 0.77947f
C4735 sg13cmos5l_dlygate4sd3_1_38.X sg13cmos5l_dlygate4sd3_1_37.A 0.0846f
C4736 sg13cmos5l_buf_1_16.A a_17243_17508# 0.01705f
C4737 sg13cmos5l_nand3_1_4.Y a_9394_8814# 0.04833f
C4738 sg13cmos5l_buf_1_30.A VDD 0.20591f
C4739 sg13cmos5l_dfrbpq_1_5.CLK a_20580_12528# 0.06108f
C4740 sg13cmos5l_buf_1_66.X VDD 1.58882f
C4741 sg13cmos5l_nand4_1_0.C clk 0.12404f
C4742 sg13cmos5l_inv_1_15.A a_21911_18649# 0.05047f
C4743 sg13cmos5l_buf_1_63.A sg13cmos5l_dfrbpq_1_41.CLK 0.04311f
C4744 sg13cmos5l_inv_1_8.A sg13cmos5l_buf_1_13.A 0.47579f
C4745 sg13cmos5l_nand2_1_2.Y sg13cmos5l_dlygate4sd3_1_25.A 0.02764f
C4746 a_10694_18258# a_11268_18271# 0.18486f
C4747 sg13cmos5l_buf_1_15.A a_8844_15424# 0.02074f
C4748 sg13cmos5l_a21oi_1_18.B1 sg13cmos5l_nand4_1_7.B 0.52698f
C4749 sg13cmos5l_buf_1_5.A a_18374_10698# 0.01914f
C4750 a_22096_12430# a_22506_12508# 0.07015f
C4751 sg13cmos5l_dlygate4sd3_1_24.A bp3 0.01904f
C4752 sg13cmos5l_dfrbpq_1_15.CLK sg13cmos5l_dlygate4sd3_1_37.A 0.07408f
C4753 sg13cmos5l_dfrbpq_1_13.CLK sg13cmos5l_nand2_1_19.A 0.46841f
C4754 sg13cmos5l_buf_1_5.A sg13cmos5l_buf_1_0.A 0.02508f
C4755 sg13cmos5l_dfrbpq_1_19.CLK a_9450_19020# 0.01245f
C4756 a_18095_19847# a_18352_19990# 0.23043f
C4757 sg13cmos5l_a21oi_1_18.B1 sg13cmos5l_nand4_1_3.B 0.07678f
C4758 sg13cmos5l_dfrbpq_1_15.Q a_6487_6126# 0.0247f
C4759 a_12420_19024# a_13679_19381# 0.01412f
C4760 sg13cmos5l_nand4_1_7.B a_15900_16754# 0.01376f
C4761 sg13cmos5l_a21oi_1_4.A1 sg13cmos5l_mux2_1_0.S 0.03801f
C4762 a_10864_19990# VDD 0.13526f
C4763 a_4740_14488# a_5905_14845# 0.25046f
C4764 a_5028_14909# a_5259_14495# 0.07823f
C4765 sg13cmos5l_dfrbpq_1_27.Q a_22096_13942# 0.04583f
C4766 sg13cmos5l_o21ai_1_4.A1 sg13cmos5l_o21ai_1_0.B1 0.01927f
C4767 sg13cmos5l_a21oi_1_19.A2 a_17051_15996# 0.0744f
C4768 a_4744_19808# a_5230_19959# 0.01642f
C4769 a_19066_15960# sg13cmos5l_buf_1_53.A 0.04706f
C4770 sg13cmos5l_dfrbpq_1_28.D sg13cmos5l_dlygate4sd3_1_71.X 0.14029f
C4771 sg13cmos5l_nand2_1_19.Y sg13cmos5l_inv_1_36.Y 0.27847f
C4772 a_10607_19847# a_11274_20068# 0.09257f
C4773 sg13cmos5l_nor2_1_2.A sg13cmos5l_nor2_1_2.Y 0.06561f
C4774 sg13cmos5l_a21o_1_2.X a_6256_14726# 0.01866f
C4775 sg13cmos5l_a21oi_1_4.A2 sg13cmos5l_nor3_1_6.Y 0.06158f
C4776 sg13cmos5l_buf_1_1.A a_21531_13342# 0.0548f
C4777 a_16330_5380# VDD 0.10015f
C4778 sg13cmos5l_a21oi_1_1.A2 a_18863_11821# 0.0126f
C4779 sg13cmos5l_buf_1_15.A sg13cmos5l_nand4_1_3.D 0.0331f
C4780 sg13cmos5l_a21o_1_2.A1 sg13cmos5l_nor4_1_1.D 0.06913f
C4781 sg13cmos5l_dlygate4sd3_1_65.A sg13cmos5l_o21ai_1_22.Y 0.05345f
C4782 sg13cmos5l_buf_8_2.A sg13cmos5l_buf_1_7.X 0.11897f
C4783 a_15016_5498# VDD 0.14956f
C4784 sg13cmos5l_dlygate4sd3_1_16.A a_22506_8436# 0.01289f
C4785 sg13cmos5l_buf_1_7.X a_20554_4873# 0.18533f
C4786 sg13cmos5l_a21oi_1_4.A2 sg13cmos5l_inv_1_9.Y 0.02255f
C4787 a_11374_17775# sg13cmos5l_o21ai_1_22.B1 0.10697f
C4788 sg13cmos5l_a21oi_1_9.A1 sg13cmos5l_o21ai_1_4.A1 0.0688f
C4789 sg13cmos5l_a21oi_1_7.A2 sg13cmos5l_buf_1_9.A 0.68216f
C4790 sg13cmos5l_buf_1_7.X a_19534_4839# 0.01858f
C4791 a_9260_11424# a_9557_11460# 0.03494f
C4792 VDD bp6 0.19413f
C4793 sg13cmos5l_buf_1_57.A sg13cmos5l_nand2_1_15.B 0.06756f
C4794 sg13cmos5l_inv_1_2.A a_19995_9190# 0.66515f
C4795 sg13cmos5l_nand4_1_8.B sg13cmos5l_a21oi_1_4.A2 0.29818f
C4796 sg13cmos5l_a21oi_1_4.A2 a_15358_14850# 0.13974f
C4797 sg13cmos5l_nand4_1_18.C sg13cmos5l_inv_1_12.Y 0.3727f
C4798 sg13cmos5l_nand3_1_8.Y a_17224_12972# 0.01562f
C4799 sg13cmos5l_inv_1_2.A a_19649_4840# 0.03635f
C4800 sg13cmos5l_a21oi_1_3.A2 sg13cmos5l_buf_1_9.A 0.01911f
C4801 sg13cmos5l_dfrbpq_1_13.CLK a_12844_5850# 0.01003f
C4802 sg13cmos5l_nor4_1_2.Y sg13cmos5l_a21oi_1_15.A2 0.04687f
C4803 sg13cmos5l_mux2_1_0.S sg13cmos5l_mux2_1_1.A1 1.63409f
C4804 a_16070_5850# a_16773_5423# 0.02431f
C4805 sg13cmos5l_nand4_1_18.B sg13cmos5l_dlygate4sd3_1_58.X 0.29506f
C4806 sg13cmos5l_o21ai_1_18.A2 sg13cmos5l_nand4_1_15.B 0.10757f
C4807 sg13cmos5l_buf_1_20.A a_11648_10830# 0.03168f
C4808 sg13cmos5l_mux2_1_0.A1 a_8337_13362# 0.0683f
C4809 sg13cmos5l_buf_1_16.A sg13cmos5l_a21oi_1_6.Y 0.17033f
C4810 sg13cmos5l_inv_1_17.A a_21866_16904# 0.01153f
C4811 a_8218_19738# sg13cmos5l_o21ai_1_19.Y 0.30692f
C4812 a_7524_19024# a_7941_19031# 0.28418f
C4813 a_7238_19458# a_7812_19445# 0.18486f
C4814 sg13cmos5l_inv_1_36.A a_14446_11727# 0.01686f
C4815 a_22241_6352# VDD 0.20584f
C4816 sg13cmos5l_nor4_1_2.Y sg13cmos5l_nor2_1_16.Y 0.21357f
C4817 sg13cmos5l_nand2_1_12.A sg13cmos5l_buf_1_59.A 0.25405f
C4818 a_21531_13342# bn9 0.04864f
C4819 a_20294_8874# VDD 0.5236f
C4820 a_19169_18448# a_19173_17519# 0.01248f
C4821 sg13cmos5l_dfrbpq_1_28.RESET_B a_20294_14922# 0.10122f
C4822 sg13cmos5l_buf_1_54.A sg13cmos5l_buf_1_53.A 0.01105f
C4823 a_20580_12528# bn9 0.01048f
C4824 sg13cmos5l_buf_1_25.A a_12420_19024# 0.02409f
C4825 sg13cmos5l_buf_1_65.A sg13cmos5l_and4_1_1.A 1.06899f
C4826 sg13cmos5l_dfrbpq_1_24.RESET_B sg13cmos5l_nand3_1_5.Y 0.03084f
C4827 sg13cmos5l_dfrbpq_1_19.CLK sg13cmos5l_buf_1_47.X 0.0473f
C4828 sg13cmos5l_buf_1_16.A sg13cmos5l_inv_1_15.Y 0.27869f
C4829 sg13cmos5l_buf_1_5.A sg13cmos5l_dlygate4sd3_1_25.A 0.12831f
C4830 sg13cmos5l_dfrbpq_1_19.CLK a_5397_18416# 0.01856f
C4831 sg13cmos5l_buf_1_24.A a_11670_19044# 0.0262f
C4832 sg13cmos5l_inv_1_1.A busy 0.16696f
C4833 sg13cmos5l_nand2_1_1.A sg13cmos5l_nor3_1_6.Y 0.01362f
C4834 sg13cmos5l_inv_1_36.A a_8006_13726# 0.01037f
C4835 a_13936_19262# a_14346_19020# 0.07015f
C4836 sg13cmos5l_nand4_1_7.B sg13cmos5l_inv_1_1.A 0.01515f
C4837 sg13cmos5l_inv_1_17.A a_20580_14040# 0.01312f
C4838 sg13cmos5l_nand4_1_18.B sg13cmos5l_inv_1_36.A 0.11115f
C4839 a_19450_18226# sg13cmos5l_dlygate4sd3_1_72.A 0.01237f
C4840 sg13cmos5l_nand4_1_8.B sg13cmos5l_buf_1_57.A 0.26145f
C4841 sg13cmos5l_o21ai_1_5.A2 a_11152_12430# 0.02126f
C4842 sg13cmos5l_nand2_1_11.B sg13cmos5l_a21oi_1_12.Y 0.22093f
C4843 sg13cmos5l_nand3_1_0.B sg13cmos5l_nand2b_1_3.B 0.01422f
C4844 sg13cmos5l_nand2_1_1.A sg13cmos5l_inv_1_9.Y 0.02237f
C4845 sg13cmos5l_dfrbpq_1_39.D sg13cmos5l_a21oi_1_24.Y 0.32664f
C4846 sg13cmos5l_a21oi_1_2.A2 a_19829_3900# 0.0831f
C4847 a_16832_16082# VDD 0.07265f
C4848 sg13cmos5l_nand4_1_7.B a_12812_15960# 0.02321f
C4849 sg13cmos5l_a21oi_1_2.B1 sg13cmos5l_dlygate4sd3_1_1.A 0.31311f
C4850 sg13cmos5l_o21ai_1_5.A2 sg13cmos5l_a21o_1_0.A2 0.13635f
C4851 sg13cmos5l_inv_1_1.A sg13cmos5l_nand4_1_3.B 0.09542f
C4852 a_13014_17532# sg13cmos5l_dlygate4sd3_1_97.X 0.13601f
C4853 sg13cmos5l_dfrbpq_1_28.D a_17621_12972# 0.09955f
C4854 a_14698_6385# a_14438_6162# 0.45119f
C4855 sg13cmos5l_dlygate4sd3_1_69.A VDD 0.27918f
C4856 a_17615_5773# VDD 0.17597f
C4857 a_9062_19770# a_9636_19783# 0.18486f
C4858 sg13cmos5l_nand2b_1_1.A_N sg13cmos5l_nand2_1_6.A 0.31597f
C4859 a_18470_19458# a_18756_19024# 0.26205f
C4860 sg13cmos5l_buf_1_1.A a_22506_12508# 0.04635f
C4861 sg13cmos5l_inv_1_17.Y sg13cmos5l_buf_1_9.A 0.0464f
C4862 a_20503_15960# a_20716_16434# 0.23043f
C4863 sg13cmos5l_inv_1_31.A a_18756_17512# 0.05263f
C4864 sg13cmos5l_buf_1_7.X a_21839_4727# 0.10878f
C4865 sg13cmos5l_nand4_1_12.Y sg13cmos5l_nand4_1_1.B 0.44215f
C4866 sg13cmos5l_dfrbpq_1_13.CLK a_10053_12189# 0.21508f
C4867 sg13cmos5l_o21ai_1_5.A2 sg13cmos5l_dfrbpq_1_18.Q 0.03952f
C4868 sg13cmos5l_dlygate4sd3_1_65.A sg13cmos5l_a21oi_1_24.A1 0.02487f
C4869 sg13cmos5l_a21oi_1_6.Y a_21839_10309# 0.01091f
C4870 a_11770_17472# sg13cmos5l_nor2_1_12.Y 0.01912f
C4871 a_17604_11464# a_18769_11821# 0.25046f
C4872 sg13cmos5l_buf_1_42.A sg13cmos5l_nand3_1_8.Y 0.0313f
C4873 sg13cmos5l_o21ai_1_5.A2 a_8411_15532# 0.03133f
C4874 sg13cmos5l_nor2_1_10.Y sg13cmos5l_o21ai_1_17.Y 0.01907f
C4875 sg13cmos5l_nand4_1_1.B a_18286_16935# 0.01541f
C4876 a_7726_10887# VDD 0.15839f
C4877 a_16773_5423# a_16875_5423# 0.3643f
C4878 sg13cmos5l_nor3_1_6.Y a_4714_14452# 0.01277f
C4879 sg13cmos5l_dfrbpq_1_13.CLK a_13191_5499# 0.01931f
C4880 sg13cmos5l_buf_1_42.A sg13cmos5l_nand4_1_1.C 1.47217f
C4881 sg13cmos5l_inv_1_31.A sg13cmos5l_dlygate4sd3_1_72.A 0.13223f
C4882 a_20503_16710# a_20974_16746# 0.16704f
C4883 sg13cmos5l_inv_1_12.A a_21745_10309# 0.01416f
C4884 sg13cmos5l_o21ai_1_7.Y sg13cmos5l_o21ai_1_10.A2 0.02668f
C4885 sg13cmos5l_a21oi_1_2.B1 a_21466_7642# 0.01093f
C4886 sg13cmos5l_a21oi_1_2.A2 sg13cmos5l_buf_1_13.X 0.31508f
C4887 sg13cmos5l_a21oi_1_0.A2 a_18382_6351# 0.01368f
C4888 sg13cmos5l_dlygate4sd3_1_4.A a_20868_4663# 0.01929f
C4889 sg13cmos5l_inv_1_12.A sg13cmos5l_nand3_1_0.B 0.01637f
C4890 sg13cmos5l_buf_1_65.A a_9350_12210# 0.05171f
C4891 sg13cmos5l_nor3_1_4.A sg13cmos5l_mux2_1_0.S 0.44111f
C4892 sg13cmos5l_a21oi_1_9.B1 a_11278_6351# 0.11056f
C4893 sg13cmos5l_inv_1_24.Y a_12040_15272# 0.04962f
C4894 sg13cmos5l_o21ai_1_5.A1 sg13cmos5l_a21o_1_2.A1 0.03965f
C4895 sg13cmos5l_dlygate4sd3_1_54.A a_10906_18984# 0.28662f
C4896 sg13cmos5l_nor3_1_6.Y sg13cmos5l_nand4_1_1.A 0.20821f
C4897 sg13cmos5l_buf_1_63.A bn3 0.02444f
C4898 sg13cmos5l_inv_1_1.A sg13cmos5l_buf_1_21.A 0.01891f
C4899 sg13cmos5l_a21oi_1_6.A2 sg13cmos5l_buf_1_13.X 0.04596f
C4900 sg13cmos5l_buf_1_16.A sg13cmos5l_buf_1_7.X 0.34885f
C4901 a_20494_15423# a_20609_15424# 0.3854f
C4902 a_20997_8447# VDD 0.2458f
C4903 sg13cmos5l_dfrbpq_1_28.RESET_B a_21099_14495# 0.28031f
C4904 sg13cmos5l_o21ai_1_18.B1 code5 0.0219f
C4905 sg13cmos5l_inv_1_15.A sg13cmos5l_buf_1_13.X 0.02607f
C4906 a_18374_7674# VDD 0.52442f
C4907 sg13cmos5l_dlygate4sd3_1_80.X a_13782_15302# 0.112f
C4908 a_16064_17594# VDD 0.07639f
C4909 a_21640_3900# bp2 0.06618f
C4910 sg13cmos5l_inv_1_0.A bp7 0.03561f
C4911 a_17621_7972# VDD 0.20158f
C4912 sg13cmos5l_nand4_1_8.B sg13cmos5l_nand4_1_1.A 0.15116f
C4913 sg13cmos5l_a21oi_1_27.B1 sg13cmos5l_o21ai_1_18.A2 0.18194f
C4914 sg13cmos5l_buf_1_24.A sg13cmos5l_o21ai_1_22.Y 0.01803f
C4915 sg13cmos5l_dfrbpq_1_28.RESET_B a_19173_17519# 0.07068f
C4916 sg13cmos5l_a21oi_1_24.A1 a_13686_18326# 0.01039f
C4917 sg13cmos5l_buf_1_63.A sg13cmos5l_nor4_1_2.Y 0.09326f
C4918 a_16172_14448# a_15968_14570# 0.01689f
C4919 sg13cmos5l_inv_1_1.Y a_20294_10386# 0.03011f
C4920 sg13cmos5l_o21ai_1_20.A1 sg13cmos5l_o21ai_1_22.B1 0.69899f
C4921 sg13cmos5l_inv_1_8.A sg13cmos5l_nor2b_1_0.B_N 0.31207f
C4922 a_19048_3900# sg13cmos5l_inv_1_0.A 0.18698f
C4923 sg13cmos5l_inv_1_7.Y a_17704_3986# 0.02464f
C4924 sg13cmos5l_nand3_1_0.A a_16188_9150# 0.01022f
C4925 sg13cmos5l_nand2_1_13.A sg13cmos5l_nand3_1_0.B 0.12521f
C4926 sg13cmos5l_a21oi_1_2.B1 sg13cmos5l_a21oi_1_3.Y 0.4004f
C4927 sg13cmos5l_o21ai_1_5.A2 sg13cmos5l_nand2_1_19.Y 0.86669f
C4928 a_16566_8460# VDD 0.15856f
C4929 a_20554_4873# bp4 0.01743f
C4930 sg13cmos5l_a21oi_1_4.A1 sg13cmos5l_inv_1_24.Y 0.02173f
C4931 sg13cmos5l_nor2_1_2.B sg13cmos5l_dlygate4sd3_1_43.X 0.28066f
C4932 a_6094_19959# sg13cmos5l_dfrbpq_1_20.Q 0.01596f
C4933 sg13cmos5l_nor2_1_15.Y a_14052_16421# 0.01828f
C4934 a_10872_17488# VDD 0.01799f
C4935 a_16742_15234# a_17316_15247# 0.18486f
C4936 sg13cmos5l_a21oi_1_1.A2 a_19930_12936# 0.0118f
C4937 sg13cmos5l_inv_1_36.Y sg13cmos5l_nand2b_1_0.B 0.05891f
C4938 sg13cmos5l_inv_1_5.A a_16356_5416# 0.06155f
C4939 sg13cmos5l_inv_1_20.Y sg13cmos5l_dlygate4sd3_1_15.X 0.17726f
C4940 sg13cmos5l_dfrbpq_1_19.CLK sg13cmos5l_dlygate4sd3_1_54.A 0.01743f
C4941 a_19930_15960# VDD 0.26025f
C4942 a_18756_19024# a_19044_19445# 0.24435f
C4943 sg13cmos5l_nand3_1_8.Y a_22506_14020# 0.01559f
C4944 sg13cmos5l_inv_1_12.Y bp0 0.01277f
C4945 sg13cmos5l_inv_1_31.A a_19275_17519# 0.0408f
C4946 sg13cmos5l_inv_1_5.A sg13cmos5l_inv_1_8.Y 0.08782f
C4947 sg13cmos5l_a21oi_1_4.A1 sg13cmos5l_dlygate4sd3_1_45.X 0.04971f
C4948 sg13cmos5l_inv_1_14.Y sg13cmos5l_inv_1_7.Y 0.03171f
C4949 sg13cmos5l_buf_1_24.A sg13cmos5l_nand2_1_9.Y 0.02052f
C4950 sg13cmos5l_dfrbpq_1_28.D sg13cmos5l_a21oi_1_0.A2 0.01363f
C4951 code2 code1 0.18025f
C4952 sg13cmos5l_or4_1_1.X sg13cmos5l_nand4_1_8.B 0.01606f
C4953 sg13cmos5l_dfrbpq_1_13.CLK sg13cmos5l_a21o_1_0.A2 0.17909f
C4954 sg13cmos5l_a21oi_1_1.A2 sg13cmos5l_dlygate4sd3_1_29.A 0.02107f
C4955 sg13cmos5l_nor2_1_10.Y a_9848_18262# 0.01333f
C4956 sg13cmos5l_dlygate4sd3_1_69.A a_12118_17886# 0.07658f
C4957 sg13cmos5l_buf_8_2.A sg13cmos5l_inv_1_36.A 0.14306f
C4958 sg13cmos5l_dfrbpq_1_20.Q a_3895_18222# 0.01712f
C4959 sg13cmos5l_a21oi_1_27.A1 a_9557_11460# 0.03576f
C4960 sg13cmos5l_buf_1_57.A sg13cmos5l_dfrbpq_1_24.Q 0.05239f
C4961 a_17872_5654# a_18282_5412# 0.07015f
C4962 sg13cmos5l_a21oi_1_1.A2 sg13cmos5l_buf_1_13.X 0.03879f
C4963 sg13cmos5l_a21o_1_2.B1 sg13cmos5l_inv_1_36.A 0.01679f
C4964 a_16193_19286# sg13cmos5l_a21oi_1_26.A1 0.01914f
C4965 sg13cmos5l_buf_1_5.A sg13cmos5l_inv_1_0.A 0.03153f
C4966 a_20294_8874# a_20997_8447# 0.02431f
C4967 sg13cmos5l_buf_1_57.A sg13cmos5l_inv_1_25.Y 0.13003f
C4968 sg13cmos5l_a21oi_1_26.Y sg13cmos5l_a21oi_1_26.A1 0.61536f
C4969 sg13cmos5l_inv_1_16.A sg13cmos5l_inv_1_12.A 0.02122f
C4970 sg13cmos5l_o21ai_1_0.A2 sg13cmos5l_and4_1_0.D 0.29787f
C4971 sg13cmos5l_inv_1_13.Y sg13cmos5l_a21oi_1_2.A2 0.13224f
C4972 sg13cmos5l_a21oi_1_10.A2 a_8872_6294# 0.02486f
C4973 sg13cmos5l_o21ai_1_5.A2 sg13cmos5l_a21o_1_2.A1 0.01138f
C4974 sg13cmos5l_inv_1_2.A a_21099_9959# 0.02257f
C4975 a_20997_9959# a_21745_10309# 0.01058f
C4976 sg13cmos5l_a21oi_1_2.Y VDD 0.36887f
C4977 sg13cmos5l_buf_1_15.A sg13cmos5l_mux2_1_0.S 0.06699f
C4978 sg13cmos5l_a21oi_1_10.A1 sg13cmos5l_a21oi_1_10.Y 0.14009f
C4979 sg13cmos5l_nand4_1_7.B sg13cmos5l_nand4_1_18.D 0.02063f
C4980 a_4936_7806# VDD 0.17923f
C4981 sg13cmos5l_nor3_1_6.Y a_17604_11464# 0.01006f
C4982 sg13cmos5l_nor4_1_0.C sg13cmos5l_inv_1_18.Y 0.26568f
C4983 a_14536_14484# bn6 0.06954f
C4984 a_21215_17016# a_21084_16710# 0.28418f
C4985 sg13cmos5l_buf_1_0.A a_20580_4968# 0.02278f
C4986 sg13cmos5l_dlygate4sd3_1_18.A a_18374_10698# 0.04123f
C4987 sg13cmos5l_a21oi_1_2.A2 sg13cmos5l_dlygate4sd3_1_18.X 0.24437f
C4988 a_8783_19381# a_9450_19020# 0.09257f
C4989 sg13cmos5l_o21ai_1_7.B1 a_5349_19031# 0.02991f
C4990 sg13cmos5l_a21oi_1_4.A1 a_15208_12972# 0.02219f
C4991 sg13cmos5l_a21oi_1_10.A1 a_9077_6460# 0.04926f
C4992 sg13cmos5l_nand2_1_13.Y sg13cmos5l_dlygate4sd3_1_13.X 0.05005f
C4993 sg13cmos5l_o21ai_1_20.B1 sg13cmos5l_dfrbpq_1_19.CLK 0.16686f
C4994 sg13cmos5l_a21oi_1_4.A2 sg13cmos5l_and2_1_3.X 0.11068f
C4995 a_20890_15202# sg13cmos5l_inv_1_31.Y 0.04421f
C4996 a_22506_8436# VDD 0.27509f
C4997 sg13cmos5l_a21oi_1_26.Y a_16193_19286# 0.04903f
C4998 sg13cmos5l_a21oi_1_6.A2 sg13cmos5l_inv_1_13.Y 0.0251f
C4999 sg13cmos5l_dfrbpq_1_28.RESET_B bn7 0.02923f
C5000 sg13cmos5l_inv_1_15.A sg13cmos5l_inv_1_13.Y 0.06094f
C5001 sg13cmos5l_inv_1_9.Y a_17604_11464# 0.04423f
C5002 a_6470_11898# a_7275_11471# 0.07916f
C5003 a_13304_18262# a_13574_18262# 0.18796f
C5004 sg13cmos5l_nand4_1_3.B sg13cmos5l_nand4_1_18.D 0.18252f
C5005 a_18730_17476# VDD 0.09467f
C5006 sg13cmos5l_o21ai_1_6.B1 a_9394_8814# 0.06513f
C5007 sg13cmos5l_buf_1_42.A sg13cmos5l_dlygate4sd3_1_81.X 0.24235f
C5008 sg13cmos5l_a21oi_1_2.B1 a_17318_11898# 0.04467f
C5009 a_14763_19892# VDD 0.20455f
C5010 sg13cmos5l_buf_1_24.A a_10980_18576# 0.02833f
C5011 sg13cmos5l_o21ai_1_23.B1 sg13cmos5l_o21ai_1_5.A1 0.01506f
C5012 sg13cmos5l_inv_1_24.Y bn1 0.01584f
C5013 sg13cmos5l_buf_1_5.A a_19338_6924# 0.05428f
C5014 sg13cmos5l_nand3_1_0.B sg13cmos5l_dfrbpq_1_2.D 0.01659f
C5015 sg13cmos5l_o21ai_1_20.Y a_4114_17886# 0.06016f
C5016 sg13cmos5l_o21ai_1_9.Y a_5660_14040# 0.01087f
C5017 sg13cmos5l_dfrbpq_1_28.RESET_B a_20272_17750# 0.10061f
C5018 sg13cmos5l_nor3_1_6.Y sg13cmos5l_and2_1_5.X 0.08949f
C5019 sg13cmos5l_nand2_1_1.Y sg13cmos5l_nand2b_1_0.B 0.47715f
C5020 a_17835_8447# VDD 0.20578f
C5021 a_6442_10666# a_6272_10830# 0.01906f
C5022 sg13cmos5l_a21oi_1_24.A2 VDD 0.59351f
C5023 sg13cmos5l_buf_1_45.X sg13cmos5l_nand4_1_1.B 0.01707f
C5024 sg13cmos5l_a21oi_1_24.A1 a_16197_18237# 0.01015f
C5025 sg13cmos5l_dfrbpq_1_17.Q a_7260_8802# 0.01123f
C5026 sg13cmos5l_inv_1_15.Y sg13cmos5l_buf_1_53.A 0.02152f
C5027 sg13cmos5l_o21ai_1_1.B1 sg13cmos5l_nor2_1_0.Y 0.01227f
C5028 a_19738_9912# VDD 0.27492f
C5029 sg13cmos5l_buf_1_24.A sg13cmos5l_a21oi_1_24.A1 0.65505f
C5030 sg13cmos5l_buf_1_24.A code1 0.02124f
C5031 sg13cmos5l_a21oi_1_2.B1 sg13cmos5l_dfrbpq_1_0.D 0.34837f
C5032 sg13cmos5l_inv_1_6.Y VDD 0.49075f
C5033 sg13cmos5l_o21ai_1_8.B1 sg13cmos5l_o21ai_1_11.A2 0.18985f
C5034 sg13cmos5l_a21oi_1_2.Y bp6 0.05278f
C5035 a_18544_15454# a_18954_15532# 0.07015f
C5036 sg13cmos5l_buf_1_13.A sg13cmos5l_nor2b_1_2.Y 0.07662f
C5037 sg13cmos5l_o21ai_1_20.A1 a_10428_17874# 0.01437f
C5038 sg13cmos5l_o21ai_1_28.A1 sg13cmos5l_buf_1_20.A 0.02508f
C5039 sg13cmos5l_nand2_1_18.A a_12814_13239# 0.05931f
C5040 sg13cmos5l_buf_8_2.A a_18682_16714# 0.01187f
C5041 a_15983_6239# a_16240_6382# 0.23043f
C5042 a_14724_6480# a_15012_6175# 0.24435f
C5043 busy code0 2.03788f
C5044 bn6 bn5 0.06162f
C5045 sg13cmos5l_nand4_1_18.B sg13cmos5l_nand4_1_3.B 1.38287f
C5046 sg13cmos5l_a21oi_1_12.A2 a_9674_15532# 0.01306f
C5047 a_19275_19031# a_20272_19262# 0.03546f
C5048 sg13cmos5l_nand4_1_7.B code0 0.01723f
C5049 sg13cmos5l_inv_1_31.A a_21080_17549# 0.0229f
C5050 a_18662_5850# VDD 0.52277f
C5051 sg13cmos5l_dfrbpq_1_13.CLK sg13cmos5l_nand2_1_19.Y 0.06901f
C5052 sg13cmos5l_nor2_1_7.Y sg13cmos5l_o21ai_1_12.Y 0.08719f
C5053 sg13cmos5l_nand4_1_16.D sg13cmos5l_inv_1_24.A 0.01354f
C5054 sg13cmos5l_nor2_1_12.Y a_12216_17488# 0.01277f
C5055 sg13cmos5l_buf_1_66.X a_7064_14525# 0.01467f
C5056 sg13cmos5l_o21ai_1_0.Y sg13cmos5l_o21ai_1_0.B1 0.19003f
C5057 sg13cmos5l_inv_1_31.A bn3 0.01832f
C5058 sg13cmos5l_o21ai_1_7.B1 sg13cmos5l_o21ai_1_11.Y 0.29089f
C5059 sg13cmos5l_nor2_1_2.A sg13cmos5l_a21oi_1_8.A1 0.05993f
C5060 sg13cmos5l_dfrbpq_1_41.CLK sg13cmos5l_inv_1_25.Y 0.06965f
C5061 sg13cmos5l_inv_1_15.A sg13cmos5l_dfrbpq_1_30.Q 0.01275f
C5062 a_9734_17508# VDD 0.20864f
C5063 sg13cmos5l_buf_1_25.A a_19921_19381# 0.01022f
C5064 sg13cmos5l_buf_1_7.X a_20294_11898# 0.09436f
C5065 sg13cmos5l_nand3_1_0.A a_12512_8522# 0.0112f
C5066 sg13cmos5l_dlygate4sd3_1_15.X sg13cmos5l_nand2_1_0.B 0.17555f
C5067 a_5230_19959# code6 0.0104f
C5068 sg13cmos5l_dfrbpq_1_20.Q a_5303_18649# 0.01769f
C5069 sg13cmos5l_nand2_1_6.A VDD 0.66386f
C5070 sg13cmos5l_o21ai_1_17.Y sg13cmos5l_buf_8_2.A 0.03142f
C5071 sg13cmos5l_buf_1_26.A a_12632_17549# 0.01041f
C5072 sg13cmos5l_o21ai_1_14.A1 a_8338_16742# 0.06248f
C5073 sg13cmos5l_dlygate4sd3_1_38.X VDD 0.34067f
C5074 sg13cmos5l_inv_1_6.Y bp6 0.02239f
C5075 sg13cmos5l_o21ai_1_0.Y sg13cmos5l_a21oi_1_11.Y 0.0328f
C5076 sg13cmos5l_buf_1_45.X a_12939_19031# 0.30329f
C5077 sg13cmos5l_a21oi_1_13.Y a_19829_14020# 0.09955f
C5078 sg13cmos5l_a21oi_1_9.A1 sg13cmos5l_o21ai_1_0.Y 0.17182f
C5079 sg13cmos5l_o21ai_1_20.B1 a_6858_19020# 0.0611f
C5080 sg13cmos5l_o21ai_1_17.B1 a_10980_18576# 0.0509f
C5081 sg13cmos5l_a21oi_1_2.A2 sg13cmos5l_buf_1_9.A 0.0257f
C5082 sg13cmos5l_nand2_1_13.A a_10155_12332# 0.03061f
C5083 sg13cmos5l_dlygate4sd3_1_72.A sg13cmos5l_inv_1_25.Y 0.02869f
C5084 sg13cmos5l_o21ai_1_0.Y sg13cmos5l_nor3_1_1.Y 0.28949f
C5085 a_7064_14525# VDD 0.26034f
C5086 a_8037_9959# VDD 0.24781f
C5087 sg13cmos5l_buf_1_8.A a_20294_4650# 0.03127f
C5088 sg13cmos5l_buf_1_0.A sg13cmos5l_inv_1_7.A 0.01555f
C5089 sg13cmos5l_buf_1_14.A clk 0.1602f
C5090 sg13cmos5l_nand2_1_15.B a_13015_13686# 0.02455f
C5091 sg13cmos5l_o21ai_1_17.B1 a_12394_18988# 0.02982f
C5092 sg13cmos5l_a21oi_1_24.Y bn5 0.03508f
C5093 sg13cmos5l_nor3_1_2.B a_11014_9508# 0.02812f
C5094 sg13cmos5l_inv_1_4.Y a_17126_7362# 0.01746f
C5095 a_21215_17016# a_21911_17137# 0.02431f
C5096 sg13cmos5l_o21ai_1_17.B1 sg13cmos5l_a21oi_1_24.A1 0.09842f
C5097 sg13cmos5l_inv_1_24.Y sg13cmos5l_nor3_1_4.A 0.08798f
C5098 sg13cmos5l_dlygate4sd3_1_33.X VDD 0.44495f
C5099 sg13cmos5l_a21oi_1_12.Y a_8960_16082# 0.02454f
C5100 a_18662_5850# bp6 0.02232f
C5101 sg13cmos5l_dlygate4sd3_1_98.A bn4 0.01488f
C5102 sg13cmos5l_a21oi_1_2.A2 a_17412_6928# 0.02245f
C5103 sg13cmos5l_inv_1_15.A sg13cmos5l_buf_1_9.A 0.0217f
C5104 sg13cmos5l_nand3b_1_3.C sg13cmos5l_a21oi_1_4.A2 0.30591f
C5105 sg13cmos5l_dfrbpq_1_15.CLK VDD 2.66836f
C5106 sg13cmos5l_dfrbpq_1_45.Q a_8411_12252# 0.03912f
C5107 sg13cmos5l_nand4_1_18.B sg13cmos5l_buf_1_21.A 0.05351f
C5108 a_22696_10830# VDD 0.12688f
C5109 sg13cmos5l_a21oi_1_2.B1 sg13cmos5l_a21oi_1_6.Y 0.01716f
C5110 a_4607_18528# a_4476_18222# 0.28418f
C5111 a_7044_11885# a_7275_11471# 0.07823f
C5112 sg13cmos5l_nand4_1_1.B sg13cmos5l_buf_1_42.A 0.23931f
C5113 a_6756_11464# a_7921_11821# 0.25046f
C5114 sg13cmos5l_a21o_1_1.A2 sg13cmos5l_nand4_1_0.C 0.03237f
C5115 sg13cmos5l_nand4_1_8.B bn3 0.01858f
C5116 sg13cmos5l_buf_1_25.A a_14744_19061# 0.01606f
C5117 sg13cmos5l_nand4_1_3.B a_14423_14113# 0.01639f
C5118 sg13cmos5l_nand3_1_4.Y sg13cmos5l_nor4_1_0.C 0.02104f
C5119 sg13cmos5l_inv_1_1.Y a_20580_6928# 0.05096f
C5120 sg13cmos5l_or4_1_1.X sg13cmos5l_inv_1_25.Y 0.03924f
C5121 a_19829_3900# bp8 0.01066f
C5122 sg13cmos5l_dfrbpq_1_24.RESET_B a_10906_18984# 0.03789f
C5123 a_17578_11428# VDD 0.09639f
C5124 sg13cmos5l_buf_1_21.A code0 0.20854f
C5125 sg13cmos5l_a21oi_1_18.B1 a_20294_13722# 0.01538f
C5126 sg13cmos5l_a21oi_1_8.A2 a_7850_6320# 0.01661f
C5127 sg13cmos5l_buf_1_15.A a_5416_9948# 0.17818f
C5128 sg13cmos5l_nand3_1_2.Y sg13cmos5l_o21ai_1_28.Y 0.01619f
C5129 sg13cmos5l_inv_1_11.Y VDD 0.30048f
C5130 sg13cmos5l_inv_1_32.Y sg13cmos5l_o21ai_1_5.A1 0.07148f
C5131 a_22030_19287# a_22145_19286# 0.3854f
C5132 a_15488_9361# a_15820_9186# 0.07015f
C5133 a_17030_8874# a_17290_8404# 0.45119f
C5134 sg13cmos5l_nand4_1_6.B sg13cmos5l_nand2_1_12.A 0.01338f
C5135 a_19246_19959# a_19361_19960# 0.3854f
C5136 sg13cmos5l_inv_1_15.Y sg13cmos5l_a21oi_1_2.B1 0.20452f
C5137 sg13cmos5l_nor2_1_2.B sg13cmos5l_nand3_1_4.Y 0.01678f
C5138 sg13cmos5l_buf_1_15.A sg13cmos5l_a21oi_1_12.A2 0.14161f
C5139 sg13cmos5l_nand4_1_5.D sg13cmos5l_dfrbpq_1_30.Q 0.12204f
C5140 sg13cmos5l_inv_1_15.Y sg13cmos5l_nand4_1_3.D 0.07591f
C5141 a_15783_7892# VDD 0.20582f
C5142 sg13cmos5l_dlygate4sd3_1_0.A a_22522_3864# 0.05154f
C5143 sg13cmos5l_dfrbpq_1_18.Q sg13cmos5l_mux2_1_0.A1 0.03085f
C5144 sg13cmos5l_nand4_1_8.B sg13cmos5l_nor4_1_2.Y 0.01753f
C5145 sg13cmos5l_buf_1_13.A a_15012_6175# 0.01928f
C5146 a_18954_15532# sg13cmos5l_dlygate4sd3_1_77.A 0.08193f
C5147 sg13cmos5l_buf_1_15.A code5 0.03651f
C5148 sg13cmos5l_dlygate4sd3_1_98.A VDD 0.17949f
C5149 sg13cmos5l_nand4_1_3.B a_9558_13790# 0.01358f
C5150 sg13cmos5l_nor3_1_0.Y a_15208_11546# 0.0127f
C5151 a_15983_6239# a_15889_6239# 0.16704f
C5152 a_16448_10034# VDD 0.0747f
C5153 sg13cmos5l_a21oi_1_2.B1 a_20113_5773# 0.01427f
C5154 sg13cmos5l_o21ai_1_21.A2 sg13cmos5l_or4_1_1.X 0.31839f
C5155 a_15597_12256# VDD 0.29734f
C5156 a_12812_15960# a_13096_15996# 0.06897f
C5157 a_22241_7864# a_22522_7642# 0.18796f
C5158 sg13cmos5l_and2_1_3.X sg13cmos5l_nand4_1_1.A 0.03154f
C5159 sg13cmos5l_inv_1_1.A sg13cmos5l_a21oi_1_5.A2 0.07208f
C5160 sg13cmos5l_o21ai_1_3.Y VDD 0.45701f
C5161 sg13cmos5l_dfrbpq_1_28.RESET_B a_21911_18649# 0.07331f
C5162 sg13cmos5l_dfrbpq_1_30.D bn5 0.02735f
C5163 a_6286_8703# a_6401_8702# 0.3854f
C5164 a_12597_11722# sg13cmos5l_nand2_1_0.A 0.1362f
C5165 sg13cmos5l_dlygate4sd3_1_20.A a_22330_10666# 0.01439f
C5166 sg13cmos5l_dfrbpq_1_24.RESET_B a_4932_19024# 0.28859f
C5167 a_18470_19458# sg13cmos5l_a21oi_1_19.Y 0.01925f
C5168 sg13cmos5l_o21ai_1_8.B1 VDD 0.3554f
C5169 sg13cmos5l_buf_1_43.X bn6 0.01765f
C5170 sg13cmos5l_dfrbpq_1_5.CLK sg13cmos5l_dfrbpq_1_37.D 0.02499f
C5171 sg13cmos5l_buf_8_2.A a_21531_13342# 0.35221f
C5172 a_10710_14020# VDD 0.01715f
C5173 sg13cmos5l_buf_8_2.A a_20580_12528# 0.02885f
C5174 sg13cmos5l_buf_1_10.A sg13cmos5l_buf_1_0.A 0.0127f
C5175 a_20294_14922# a_20580_14488# 0.26205f
C5176 sg13cmos5l_nand3b_1_3.C sg13cmos5l_buf_1_57.A 0.03706f
C5177 sg13cmos5l_o21ai_1_7.B1 a_5230_19959# 0.0145f
C5178 sg13cmos5l_buf_8_2.A busy 0.03443f
C5179 sg13cmos5l_buf_1_21.A a_14423_14113# 0.01382f
C5180 sg13cmos5l_dfrbpq_1_13.RESET_B sg13cmos5l_nand2b_1_1.A_N 0.05506f
C5181 sg13cmos5l_buf_1_47.X a_12812_15960# 0.15442f
C5182 sg13cmos5l_buf_8_2.A sg13cmos5l_nand4_1_7.B 0.04956f
C5183 sg13cmos5l_a21oi_1_1.A2 sg13cmos5l_buf_1_9.A 0.04407f
C5184 sg13cmos5l_dfrbpq_1_19.CLK sg13cmos5l_dfrbpq_1_24.RESET_B 0.78419f
C5185 sg13cmos5l_nand2_1_13.A sg13cmos5l_inv_1_36.Y 0.04546f
C5186 sg13cmos5l_buf_1_45.X sg13cmos5l_dfrbpq_1_44.Q 0.03689f
C5187 a_20580_8440# a_21745_8797# 0.25046f
C5188 sg13cmos5l_nand2_1_13.A a_11562_12508# 0.0106f
C5189 a_20868_8861# a_21099_8447# 0.07823f
C5190 sg13cmos5l_o21ai_1_25.Y a_13679_19381# 0.01036f
C5191 sg13cmos5l_buf_8_2.A sg13cmos5l_nand4_1_3.B 0.20715f
C5192 a_9546_9948# VDD 0.28258f
C5193 sg13cmos5l_a21oi_1_26.A2 bn5 0.02716f
C5194 sg13cmos5l_a21oi_1_26.A1 a_15780_18576# 0.0129f
C5195 sg13cmos5l_nor3_1_2.B sg13cmos5l_nand3_1_0.A 0.02573f
C5196 a_3415_16710# VDD 0.17523f
C5197 sg13cmos5l_inv_1_13.Y sg13cmos5l_dlygate4sd3_1_76.A 0.14978f
C5198 a_21084_16710# a_21866_16904# 0.24435f
C5199 sg13cmos5l_a21o_1_2.B1 sg13cmos5l_nand4_1_3.B 0.02838f
C5200 a_19361_19960# a_19173_19031# 0.01281f
C5201 sg13cmos5l_buf_1_20.A a_10685_12972# 0.02832f
C5202 sg13cmos5l_nor3_1_6.Y a_19448_12214# 0.01446f
C5203 sg13cmos5l_buf_1_15.A sg13cmos5l_inv_1_24.Y 0.0229f
C5204 a_18634_7897# a_19077_7653# 0.02241f
C5205 a_19236_5837# bp6 0.0215f
C5206 a_21084_18222# bn4 0.02261f
C5207 sg13cmos5l_buf_1_20.A a_10316_12936# 0.06263f
C5208 a_5303_18649# a_5397_18416# 0.45119f
C5209 a_18106_17472# a_18470_17946# 0.01503f
C5210 sg13cmos5l_a21oi_1_3.A2 a_16840_12972# 0.03153f
C5211 a_9610_12433# a_9350_12210# 0.45119f
C5212 a_8015_11821# a_7921_11821# 0.16704f
C5213 sg13cmos5l_a21oi_1_27.B1 a_9348_20088# 0.01074f
C5214 sg13cmos5l_inv_1_12.A sg13cmos5l_nand2_1_1.Y 0.03435f
C5215 sg13cmos5l_a21oi_1_25.Y sg13cmos5l_a21oi_1_18.B1 0.16963f
C5216 sg13cmos5l_inv_1_36.A a_12929_13238# 0.01277f
C5217 sg13cmos5l_nand3b_1_1.Y sg13cmos5l_nand4_1_15.B 0.38114f
C5218 sg13cmos5l_a21oi_1_2.B1 sg13cmos5l_buf_1_7.X 0.6018f
C5219 a_10214_10386# a_10474_9916# 0.45119f
C5220 a_8520_8436# a_8614_8436# 0.02125f
C5221 a_19720_3176# bp8 0.17924f
C5222 sg13cmos5l_inv_1_32.Y sg13cmos5l_o21ai_1_5.A2 0.11381f
C5223 sg13cmos5l_o21ai_1_9.B1 sg13cmos5l_mux2_1_0.S 0.01216f
C5224 a_18123_11471# VDD 0.20455f
C5225 sg13cmos5l_nand3_1_0.B sg13cmos5l_buf_1_0.A 0.02299f
C5226 sg13cmos5l_inv_1_17.A sg13cmos5l_buf_1_10.A 0.02036f
C5227 sg13cmos5l_nand3_1_2.A sg13cmos5l_nand2_1_2.Y 0.17759f
C5228 sg13cmos5l_inv_1_36.A sg13cmos5l_buf_1_22.A 0.48493f
C5229 sg13cmos5l_buf_1_4.A VDD 0.52304f
C5230 a_19642_6130# a_20024_6166# 0.04548f
C5231 sg13cmos5l_dfrbpq_1_40.Q a_20110_19959# 0.01515f
C5232 sg13cmos5l_inv_1_1.Y sg13cmos5l_nand3_1_8.Y 0.0186f
C5233 sg13cmos5l_buf_1_66.X a_12896_13897# 0.0188f
C5234 sg13cmos5l_inv_1_3.Y VDD 0.35841f
C5235 sg13cmos5l_dfrbpq_1_24.RESET_B a_4950_15302# 0.03283f
C5236 sg13cmos5l_a21oi_1_8.A2 a_7895_6553# 0.04573f
C5237 sg13cmos5l_nand3_1_0.C a_16319_9456# 0.02471f
C5238 sg13cmos5l_a21oi_1_18.B1 sg13cmos5l_nand4_1_18.A 0.25651f
C5239 a_21084_18222# VDD 0.07263f
C5240 sg13cmos5l_buf_1_5.A a_19361_6352# 0.02814f
C5241 sg13cmos5l_buf_8_2.A sg13cmos5l_buf_1_21.A 0.10832f
C5242 sg13cmos5l_dfrbpq_1_34.Q a_21089_19960# 0.01605f
C5243 a_9761_6352# a_9765_5423# 0.01248f
C5244 sg13cmos5l_dfrbpq_1_41.CLK sg13cmos5l_nand3b_1_3.C 0.16286f
C5245 sg13cmos5l_nor2b_1_0.B_N a_15405_11808# 0.02968f
C5246 sg13cmos5l_a21oi_1_27.B1 a_9070_18447# 0.05567f
C5247 sg13cmos5l_nand2b_1_1.A_N a_13390_7863# 0.01626f
C5248 sg13cmos5l_inv_1_15.A a_17028_15552# 0.01319f
C5249 sg13cmos5l_nand2_1_13.A sg13cmos5l_nand2_1_1.Y 0.0226f
C5250 sg13cmos5l_inv_1_20.Y sg13cmos5l_buf_1_14.A 0.04033f
C5251 sg13cmos5l_dfrbpq_1_24.RESET_B a_6858_19020# 0.01062f
C5252 sg13cmos5l_buf_1_26.A a_18106_17472# 0.03816f
C5253 a_13738_17476# a_13764_17512# 0.24169f
C5254 a_20554_13945# a_20997_13701# 0.02241f
C5255 a_13727_13992# sg13cmos5l_dfrbpq_1_13.CLK 0.22344f
C5256 sg13cmos5l_dfrbpq_1_13.CLK sg13cmos5l_nand2b_1_0.B 0.02954f
C5257 a_12896_13897# VDD 0.29187f
C5258 sg13cmos5l_buf_1_42.A a_16374_16754# 0.01851f
C5259 sg13cmos5l_a21oi_1_21.A1 a_17811_19368# 0.01162f
C5260 a_20997_14495# a_20868_14909# 0.01562f
C5261 sg13cmos5l_a21o_1_2.A1 sg13cmos5l_mux2_1_0.A1 0.05578f
C5262 a_20580_14488# a_21099_14495# 0.20754f
C5263 sg13cmos5l_inv_1_25.Y bn3 0.0589f
C5264 sg13cmos5l_dlygate4sd3_1_72.A a_19534_16263# 0.02354f
C5265 sg13cmos5l_dlygate4sd3_1_24.A a_22241_7864# 0.01621f
C5266 sg13cmos5l_o21ai_1_7.B1 sg13cmos5l_dfrbpq_1_20.Q 0.20727f
C5267 sg13cmos5l_inv_1_8.A sg13cmos5l_buf_1_10.A 0.42648f
C5268 sg13cmos5l_inv_1_20.Y a_15610_9912# 0.0145f
C5269 sg13cmos5l_dlygate4sd3_1_14.A VDD 0.19196f
C5270 sg13cmos5l_o21ai_1_25.Y sg13cmos5l_buf_1_25.A 0.01465f
C5271 a_5386_7897# sg13cmos5l_dlygate4sd3_1_43.X 0.01227f
C5272 sg13cmos5l_nor4_1_0.Y a_14328_7992# 0.01178f
C5273 sg13cmos5l_a21oi_1_7.A2 bn8 0.02159f
C5274 sg13cmos5l_buf_1_6.A sg13cmos5l_inv_1_0.A 0.23984f
C5275 sg13cmos5l_o21ai_1_5.A1 sg13cmos5l_nand2_1_13.A 0.07365f
C5276 sg13cmos5l_buf_1_4.A bp6 0.05235f
C5277 sg13cmos5l_inv_1_18.A a_12545_9376# 0.02543f
C5278 sg13cmos5l_nand4_1_15.B a_16742_15234# 0.03237f
C5279 sg13cmos5l_nand2b_1_1.A_N sg13cmos5l_dfrbpq_1_13.D 0.12637f
C5280 sg13cmos5l_nand4_1_12.Y sg13cmos5l_a21oi_1_19.Y 0.03275f
C5281 sg13cmos5l_nand4_1_7.B a_17240_13730# 0.01114f
C5282 sg13cmos5l_nor4_1_2.Y sg13cmos5l_dfrbpq_1_24.Q 0.56508f
C5283 a_7498_18226# sg13cmos5l_o21ai_1_14.Y 0.02953f
C5284 sg13cmos5l_buf_1_10.A sg13cmos5l_a22oi_1_2.Y 0.08186f
C5285 a_21839_8797# a_21745_8797# 0.16704f
C5286 sg13cmos5l_dfrbpq_1_13.Q sg13cmos5l_dfrbpq_1_47.Q 0.03264f
C5287 a_4454_14922# a_4714_14452# 0.45119f
C5288 sg13cmos5l_buf_1_16.A a_16172_15960# 0.18679f
C5289 sg13cmos5l_dfrbpq_1_13.CLK a_10917_9959# 0.2269f
C5290 sg13cmos5l_buf_1_45.X sg13cmos5l_dlygate4sd3_1_80.X 0.26467f
C5291 sg13cmos5l_buf_1_65.A sg13cmos5l_buf_1_57.A 0.124f
C5292 a_18660_7992# a_18948_7687# 0.24435f
C5293 a_4917_16904# VDD 0.09487f
C5294 sg13cmos5l_nor3_1_6.Y a_19534_13239# 0.01203f
C5295 sg13cmos5l_nand3_1_3.Y sg13cmos5l_dfrbpq_1_13.Q 0.03937f
C5296 a_21911_17137# a_21866_16904# 0.18486f
C5297 sg13cmos5l_a21oi_1_25.Y a_19275_19031# 0.02169f
C5298 sg13cmos5l_nand3b_1_3.C sg13cmos5l_or4_1_1.X 0.01581f
C5299 a_18470_17946# a_19173_17519# 0.02431f
C5300 sg13cmos5l_a21oi_1_4.A2 a_16091_9948# 0.05561f
C5301 sg13cmos5l_o21ai_1_0.A2 a_11014_9508# 0.03437f
C5302 sg13cmos5l_o21ai_1_0.A1 sg13cmos5l_dfrbpq_1_47.Q 0.01612f
C5303 sg13cmos5l_a21oi_1_26.A2 sg13cmos5l_buf_1_43.X 0.04709f
C5304 sg13cmos5l_o21ai_1_0.A1 a_12632_8477# 0.01109f
C5305 sg13cmos5l_a21oi_1_2.Y sg13cmos5l_inv_1_6.Y 0.01506f
C5306 sg13cmos5l_nand2_1_13.Y sg13cmos5l_nor3_1_7.Y 0.01201f
C5307 sg13cmos5l_nor2_1_10.Y sg13cmos5l_buf_1_47.X 0.46378f
C5308 sg13cmos5l_inv_1_16.A sg13cmos5l_nand4_1_18.C 0.01932f
C5309 sg13cmos5l_nand4_1_12.Y a_17039_18335# 0.01839f
C5310 sg13cmos5l_nand2_1_12.A bn4 0.13845f
C5311 a_14661_19749# sg13cmos5l_dfrbpq_1_41.CLK 0.20209f
C5312 sg13cmos5l_buf_1_21.A sg13cmos5l_nor3_1_2.B 0.23472f
C5313 a_10214_10386# a_10788_10373# 0.18486f
C5314 sg13cmos5l_nand4_1_18.D sg13cmos5l_a21oi_1_5.A2 0.02345f
C5315 sg13cmos5l_inv_1_1.Y sg13cmos5l_dlygate4sd3_1_3.A 0.09569f
C5316 sg13cmos5l_a21oi_1_3.A2 sg13cmos5l_dfrbpq_1_11.D 0.02088f
C5317 sg13cmos5l_inv_1_32.Y a_13958_19770# 0.18371f
C5318 sg13cmos5l_buf_1_16.A sg13cmos5l_nand4_1_7.B 0.09189f
C5319 sg13cmos5l_a21o_1_0.X a_10500_9952# 0.01263f
C5320 sg13cmos5l_a21oi_1_2.B1 a_20554_6892# 0.01289f
C5321 a_19048_12248# VDD 0.20486f
C5322 a_17733_8447# a_18481_8797# 0.01058f
C5323 a_15223_7638# a_15694_7674# 0.16704f
C5324 sg13cmos5l_nand3_1_0.B sg13cmos5l_dlygate4sd3_1_25.A 0.34262f
C5325 sg13cmos5l_dfrbpq_1_35.D sg13cmos5l_buf_1_24.A 0.02603f
C5326 a_8576_10901# sg13cmos5l_a21o_1_1.A2 0.08427f
C5327 sg13cmos5l_dfrbpq_1_27.Q VDD 0.3595f
C5328 sg13cmos5l_a21oi_1_26.A1 valid 0.03816f
C5329 sg13cmos5l_inv_1_2.A VDD 1.72289f
C5330 sg13cmos5l_a21oi_1_9.A1 a_10607_5773# 0.03817f
C5331 sg13cmos5l_a21o_1_1.A2 a_7620_9952# 0.03445f
C5332 sg13cmos5l_inv_1_32.Y a_13764_17512# 0.02704f
C5333 a_19342_10215# sg13cmos5l_dfrbpq_1_11.Q 0.02962f
C5334 sg13cmos5l_inv_1_1.Y a_20586_10996# 0.02745f
C5335 sg13cmos5l_inv_1_32.Y sg13cmos5l_dfrbpq_1_13.CLK 0.10399f
C5336 sg13cmos5l_dlygate4sd3_1_13.X VDD 0.32457f
C5337 sg13cmos5l_inv_1_20.Y a_16954_11424# 0.06057f
C5338 sg13cmos5l_buf_1_25.A valid 0.25117f
C5339 sg13cmos5l_a21oi_1_27.B1 sg13cmos5l_nand3b_1_1.Y 0.01757f
C5340 sg13cmos5l_dfrbpq_1_34.Q a_22234_19738# 0.30122f
C5341 a_18778_6130# sg13cmos5l_dfrbpq_1_1.D 0.04698f
C5342 sg13cmos5l_nand2_1_12.A VDD 0.32079f
C5343 sg13cmos5l_nand3_1_0.C sg13cmos5l_dfrbpq_1_9.D 0.09281f
C5344 sg13cmos5l_dfrbpq_1_35.Q sg13cmos5l_dfrbpq_1_37.D 0.01554f
C5345 sg13cmos5l_buf_1_7.X a_16773_5423# 0.04773f
C5346 sg13cmos5l_nand2_1_11.B sg13cmos5l_a21oi_1_4.A1 0.11827f
C5347 sg13cmos5l_dlygate4sd3_1_80.X sg13cmos5l_nand3_1_2.Y 0.0108f
C5348 sg13cmos5l_a21oi_1_26.Y valid 0.01418f
C5349 a_17914_9912# a_17633_10214# 0.18796f
C5350 sg13cmos5l_dfrbpq_1_24.RESET_B a_7524_19024# 0.28586f
C5351 sg13cmos5l_inv_1_7.A sg13cmos5l_inv_1_0.A 0.96883f
C5352 sg13cmos5l_nand3_1_0.C sg13cmos5l_a21oi_1_3.Y 0.01726f
C5353 a_14181_17519# a_14283_17519# 0.3643f
C5354 sg13cmos5l_a21oi_1_9.Y a_10607_5773# 0.0266f
C5355 sg13cmos5l_nand2_1_2.Y sg13cmos5l_nand3_1_1.Y 0.03463f
C5356 sg13cmos5l_nand2b_1_1.A_N a_12430_6980# 0.05567f
C5357 a_15404_6888# VDD 0.17928f
C5358 sg13cmos5l_a21oi_1_4.A2 bn2 0.02706f
C5359 sg13cmos5l_inv_1_3.Y a_17615_5773# 0.03357f
C5360 sg13cmos5l_inv_1_17.Y bn8 0.07775f
C5361 sg13cmos5l_nand3_1_6.C sg13cmos5l_buf_1_20.A 0.01048f
C5362 sg13cmos5l_buf_1_9.A bp8 0.01761f
C5363 a_22096_14726# a_21839_14845# 0.23043f
C5364 a_20580_14488# bn7 0.01736f
C5365 sg13cmos5l_o21ai_1_5.A2 sg13cmos5l_nand2_1_13.A 0.25296f
C5366 sg13cmos5l_inv_1_17.A a_20554_11428# 0.01625f
C5367 sg13cmos5l_o21ai_1_11.B1 sg13cmos5l_o21ai_1_11.A2 0.48295f
C5368 sg13cmos5l_dfrbpq_1_37.D a_22005_16904# 0.01194f
C5369 sg13cmos5l_buf_1_14.A sg13cmos5l_nand2_1_0.B 0.11104f
C5370 a_3894_9972# a_3782_9948# 0.3854f
C5371 sg13cmos5l_dlygate4sd3_1_28.A a_21466_7642# 0.01257f
C5372 sg13cmos5l_nand3_1_1.Y a_13400_10706# 0.01437f
C5373 sg13cmos5l_buf_1_26.A a_14283_17519# 0.01444f
C5374 sg13cmos5l_dlygate4sd3_1_82.X code1 0.02207f
C5375 sg13cmos5l_inv_1_2.A bp6 0.36961f
C5376 sg13cmos5l_o21ai_1_21.A2 sg13cmos5l_o21ai_1_18.A2 0.18186f
C5377 a_21070_7863# sg13cmos5l_dfrbpq_1_8.D 0.10673f
C5378 sg13cmos5l_a21oi_1_4.A1 sg13cmos5l_buf_1_20.A 0.02423f
C5379 sg13cmos5l_buf_8_2.A a_22126_9375# 0.01156f
C5380 sg13cmos5l_nand4_1_18.A a_18398_13338# 0.01878f
C5381 sg13cmos5l_nand3_1_0.B bp0 0.39215f
C5382 sg13cmos5l_dfrbpq_1_13.CLK a_12016_10190# 0.0114f
C5383 sg13cmos5l_dlygate4sd3_1_22.A a_21269_9484# 0.10558f
C5384 a_20586_7972# a_21070_7863# 0.01641f
C5385 sg13cmos5l_dfrbpq_1_13.RESET_B VDD 9.62324f
C5386 sg13cmos5l_a21oi_1_2.B1 bp4 0.05443f
C5387 sg13cmos5l_a21o_1_2.X a_4740_14488# 0.03615f
C5388 sg13cmos5l_buf_1_15.A sg13cmos5l_nand2_1_18.A 0.12683f
C5389 sg13cmos5l_dfrbpq_1_13.CLK sg13cmos5l_nand2b_1_3.B 0.01388f
C5390 sg13cmos5l_a21oi_1_7.A2 a_19995_9190# 0.01833f
C5391 sg13cmos5l_o21ai_1_0.A2 sg13cmos5l_o21ai_1_4.Y 0.02505f
C5392 sg13cmos5l_o21ai_1_0.A2 sg13cmos5l_nand3_1_0.A 0.4752f
C5393 a_21256_3900# VDD 0.1883f
C5394 sg13cmos5l_o21ai_1_0.A2 a_12726_6230# 0.02694f
C5395 sg13cmos5l_nand4_1_18.B sg13cmos5l_nor3_1_0.Y 0.01897f
C5396 sg13cmos5l_inv_1_17.A a_22005_16043# 0.03276f
C5397 sg13cmos5l_a21oi_1_4.A2 sg13cmos5l_buf_1_14.A 0.19512f
C5398 sg13cmos5l_buf_1_1.A sg13cmos5l_dlygate4sd3_1_22.A 0.03226f
C5399 a_22522_17472# VDD 0.25802f
C5400 a_15494_18258# a_16197_18237# 0.02453f
C5401 sg13cmos5l_buf_1_29.A a_1192_14484# 0.19688f
C5402 sg13cmos5l_inv_1_2.A a_20294_8874# 0.03905f
C5403 sg13cmos5l_buf_1_13.A sg13cmos5l_inv_1_4.Y 0.01181f
C5404 sg13cmos5l_buf_1_63.A a_12420_19024# 0.04946f
C5405 sg13cmos5l_dfrbpq_1_45.Q sg13cmos5l_mux2_1_1.A0 0.14357f
C5406 sg13cmos5l_buf_1_65.A sg13cmos5l_or4_1_1.X 0.0351f
C5407 a_16188_9150# a_17015_9577# 0.26205f
C5408 a_7736_13726# a_8006_13726# 0.18796f
C5409 sg13cmos5l_inv_1_3.Y a_17621_7972# 0.03198f
C5410 a_20506_19738# sg13cmos5l_buf_1_24.A 0.06305f
C5411 a_20997_6935# VDD 0.24644f
C5412 sg13cmos5l_buf_1_13.A a_18952_4688# 0.18553f
C5413 sg13cmos5l_buf_1_20.A sg13cmos5l_mux2_1_1.A1 0.08378f
C5414 sg13cmos5l_dfrbpq_1_24.D a_5318_13410# 0.17815f
C5415 sg13cmos5l_o21ai_1_6.B1 sg13cmos5l_nor4_1_0.C 0.29124f
C5416 sg13cmos5l_a21oi_1_9.A1 a_12844_5850# 0.0391f
C5417 sg13cmos5l_a21o_1_1.A2 a_8879_10309# 0.02931f
C5418 sg13cmos5l_buf_1_45.X sg13cmos5l_inv_1_24.A 0.09598f
C5419 sg13cmos5l_nand2b_1_4.B a_8061_7194# 0.20369f
C5420 sg13cmos5l_nand3b_1_3.C bn3 0.04225f
C5421 sg13cmos5l_dfrbpq_1_9.D a_15804_7638# 0.03234f
C5422 sg13cmos5l_a21oi_1_10.Y clk 0.06767f
C5423 sg13cmos5l_dlygate4sd3_1_45.X sg13cmos5l_o21ai_1_9.B1 0.27457f
C5424 sg13cmos5l_dlygate4sd3_1_38.X a_8037_9959# 0.01325f
C5425 sg13cmos5l_buf_1_45.X sg13cmos5l_a21oi_1_19.Y 0.42497f
C5426 a_18478_10215# a_18272_10034# 0.01604f
C5427 a_15104_7849# a_15223_7638# 0.09257f
C5428 sg13cmos5l_nor2_1_2.B a_7850_6320# 0.01193f
C5429 sg13cmos5l_buf_1_45.X a_13228_13722# 0.09622f
C5430 sg13cmos5l_nand4_1_6.B sg13cmos5l_nand2_1_9.Y 0.06563f
C5431 sg13cmos5l_nor3_1_2.A a_7750_9508# 0.06145f
C5432 sg13cmos5l_nand2_1_0.A a_13478_11460# 0.02015f
C5433 sg13cmos5l_nand3_1_2.A sg13cmos5l_nor2b_1_0.B_N 0.02304f
C5434 sg13cmos5l_o21ai_1_25.B1 code0 0.92672f
C5435 sg13cmos5l_dfrbpq_1_24.RESET_B a_8783_19381# 0.11524f
C5436 sg13cmos5l_inv_1_31.A a_20503_16710# 0.02255f
C5437 a_15280_17750# a_15023_17869# 0.23043f
C5438 a_7334_10386# a_8139_9959# 0.07916f
C5439 sg13cmos5l_dfrbpq_1_24.RESET_B a_3895_18222# 0.10903f
C5440 sg13cmos5l_dfrbpq_1_15.CLK sg13cmos5l_dlygate4sd3_1_38.X 0.15949f
C5441 sg13cmos5l_nand4_1_5.D a_16840_16878# 0.02837f
C5442 sg13cmos5l_buf_8_2.A a_7275_11471# 0.0112f
C5443 sg13cmos5l_dlygate4sd3_1_22.A bn9 0.02333f
C5444 sg13cmos5l_buf_1_66.X sg13cmos5l_o21ai_1_11.B1 0.02059f
C5445 sg13cmos5l_dfrbpq_1_29.Q sg13cmos5l_inv_1_25.Y 0.09334f
C5446 a_4682_16276# a_4727_16043# 0.18486f
C5447 sg13cmos5l_inv_1_17.A a_22096_11702# 0.06097f
C5448 sg13cmos5l_buf_1_20.A bn1 0.01601f
C5449 a_13390_7863# VDD 0.16228f
C5450 a_16950_9972# a_16838_9948# 0.3854f
C5451 a_16568_9989# a_16091_9948# 0.01473f
C5452 sg13cmos5l_nand3b_1_3.C sg13cmos5l_nor4_1_2.Y 0.23978f
C5453 sg13cmos5l_dfrbpq_1_15.CLK a_8037_9959# 0.20087f
C5454 sg13cmos5l_buf_1_45.X a_17039_18335# 0.10926f
C5455 sg13cmos5l_dlygate4sd3_1_43.X a_5931_7796# 0.02405f
C5456 sg13cmos5l_nand4_1_15.B a_17316_15247# 0.02972f
C5457 sg13cmos5l_nand3_1_1.Y sg13cmos5l_buf_1_5.A 0.02674f
C5458 sg13cmos5l_buf_1_25.A sg13cmos5l_nor2_1_16.Y 0.02096f
C5459 sg13cmos5l_buf_1_26.A sg13cmos5l_dfrbpq_1_38.Q 0.01214f
C5460 sg13cmos5l_buf_1_17.X a_3392_10034# 0.04123f
C5461 a_7964_17064# VDD 0.01784f
C5462 sg13cmos5l_o21ai_1_20.B1 code6 0.0161f
C5463 sg13cmos5l_nand2b_1_0.B a_14746_9912# 0.05228f
C5464 sg13cmos5l_inv_1_17.Y a_19995_9190# 0.06956f
C5465 sg13cmos5l_inv_1_16.A bp0 0.01329f
C5466 sg13cmos5l_a21oi_1_0.A2 a_18769_11821# 0.01356f
C5467 a_18948_5416# a_19365_5423# 0.28418f
C5468 a_18662_5850# a_19236_5837# 0.18486f
C5469 sg13cmos5l_nand2_1_13.A sg13cmos5l_dfrbpq_1_13.CLK 0.03246f
C5470 sg13cmos5l_a21oi_1_4.A1 a_7416_12404# 0.0468f
C5471 sg13cmos5l_a21oi_1_19.Y a_16299_18380# 0.02611f
C5472 sg13cmos5l_o21ai_1_11.B1 VDD 0.24989f
C5473 a_3200_16283# a_3319_15960# 0.09257f
C5474 sg13cmos5l_buf_8_2.A sg13cmos5l_a21oi_1_5.A2 0.23141f
C5475 a_19173_17519# a_19921_17869# 0.01058f
C5476 sg13cmos5l_a21oi_1_2.Y sg13cmos5l_buf_1_4.A 0.02063f
C5477 sg13cmos5l_dfrbpq_1_13.D VDD 0.22136f
C5478 a_18952_3176# VDD 0.21186f
C5479 sg13cmos5l_dfrbpq_1_41.CLK bn2 0.75188f
C5480 sg13cmos5l_inv_1_32.Y bn6 0.01382f
C5481 a_15760_19990# code2 0.0111f
C5482 sg13cmos5l_dlygate4sd3_1_64.X sg13cmos5l_o21ai_1_21.Y 0.01647f
C5483 sg13cmos5l_buf_1_47.X sg13cmos5l_buf_8_2.A 0.04382f
C5484 sg13cmos5l_nand3_1_2.Y sg13cmos5l_inv_1_24.A 0.03479f
C5485 sg13cmos5l_buf_1_42.A a_15976_12972# 0.18619f
C5486 sg13cmos5l_buf_1_7.X a_19077_7653# 0.05373f
C5487 a_13478_16434# VDD 0.52323f
C5488 a_8520_8436# VDD 0.24788f
C5489 sg13cmos5l_buf_1_45.X bn0 0.56076f
C5490 sg13cmos5l_buf_1_10.A sg13cmos5l_a21o_1_0.A1 0.02351f
C5491 a_1690_19738# code9 0.04692f
C5492 a_12016_10190# a_11759_10309# 0.23043f
C5493 a_16299_18380# a_17039_18335# 0.17382f
C5494 sg13cmos5l_o21ai_1_0.B1 a_13191_5499# 0.02308f
C5495 sg13cmos5l_nand4_1_1.B sg13cmos5l_and4_1_1.A 0.12077f
C5496 sg13cmos5l_buf_1_2.A a_20294_4650# 0.01734f
C5497 sg13cmos5l_inv_1_2.A a_20997_8447# 0.22459f
C5498 sg13cmos5l_dfrbpq_1_28.RESET_B sg13cmos5l_dfrbpq_1_30.Q 0.02979f
C5499 sg13cmos5l_nand4_1_6.B code1 0.06784f
C5500 sg13cmos5l_buf_1_53.A busy 0.03456f
C5501 sg13cmos5l_buf_1_45.X a_15503_19847# 0.11282f
C5502 a_17318_11898# a_18021_11471# 0.02431f
C5503 sg13cmos5l_buf_1_42.A sg13cmos5l_inv_1_24.A 0.01048f
C5504 a_19830_12278# VDD 0.16164f
C5505 sg13cmos5l_a21oi_1_2.A2 a_16167_9404# 0.01114f
C5506 a_8006_13726# a_8118_13790# 0.3854f
C5507 sg13cmos5l_nand4_1_7.B sg13cmos5l_buf_1_53.A 0.01388f
C5508 a_8714_20068# sg13cmos5l_o21ai_1_7.A2 0.01408f
C5509 a_22096_7166# VDD 0.13571f
C5510 sg13cmos5l_nand4_1_18.D sg13cmos5l_nand4_1_18.A 0.08595f
C5511 sg13cmos5l_a21oi_1_19.Y sg13cmos5l_buf_1_42.A 0.10105f
C5512 a_11670_19044# VDD 0.16124f
C5513 a_14152_14484# busy 0.07758f
C5514 sg13cmos5l_buf_1_5.A sg13cmos5l_inv_1_4.Y 0.02685f
C5515 sg13cmos5l_a21oi_1_21.A1 code2 0.01699f
C5516 sg13cmos5l_buf_1_13.A sg13cmos5l_nand3_1_0.Y 0.4738f
C5517 a_8830_17874# a_9054_17874# 0.01261f
C5518 sg13cmos5l_dfrbpq_1_24.D a_5892_13397# 0.01656f
C5519 sg13cmos5l_mux2_1_0.S a_8411_12252# 0.02257f
C5520 sg13cmos5l_buf_1_4.A sg13cmos5l_inv_1_6.Y 0.0306f
C5521 sg13cmos5l_dfrbpq_1_13.RESET_B a_7726_10887# 0.01332f
C5522 a_20110_19959# sg13cmos5l_a21oi_1_25.Y 0.01849f
C5523 sg13cmos5l_inv_1_3.Y sg13cmos5l_inv_1_6.Y 0.01936f
C5524 sg13cmos5l_buf_1_20.A sg13cmos5l_nor3_1_4.A 0.23326f
C5525 a_15935_7944# a_15804_7638# 0.28418f
C5526 sg13cmos5l_nand3_1_0.C a_16725_7832# 0.02725f
C5527 sg13cmos5l_nand3b_1_1.C a_8830_17874# 0.05844f
C5528 sg13cmos5l_inv_1_36.A a_12987_12214# 0.01886f
C5529 sg13cmos5l_o21ai_1_17.Y sg13cmos5l_o21ai_1_22.B1 0.10529f
C5530 a_15690_15996# bn5 0.05411f
C5531 a_22030_19287# sg13cmos5l_inv_1_15.A 0.10798f
C5532 sg13cmos5l_inv_1_15.Y sg13cmos5l_nand3_1_0.C 0.04866f
C5533 a_15690_17508# sg13cmos5l_dfrbpq_1_38.Q 0.10314f
C5534 a_6286_16263# a_6401_16262# 0.3854f
C5535 a_7908_10373# a_8139_9959# 0.07823f
C5536 a_7620_9952# a_8785_10309# 0.25046f
C5537 sg13cmos5l_dfrbpq_1_24.RESET_B a_5303_18649# 0.12755f
C5538 a_13575_13940# a_14378_13880# 0.07823f
C5539 a_15780_18576# valid 0.02469f
C5540 sg13cmos5l_nand2b_1_0.B sg13cmos5l_o21ai_1_1.B1 1.22064f
C5541 a_17622_10766# VDD 0.15926f
C5542 sg13cmos5l_dlygate4sd3_1_64.X a_7354_16714# 0.01605f
C5543 a_21099_13844# a_21839_13799# 0.17382f
C5544 sg13cmos5l_nor2_1_2.B a_7895_6553# 0.0324f
C5545 sg13cmos5l_o21ai_1_11.B1 a_6418_15230# 0.02423f
C5546 a_6958_19959# a_7073_19960# 0.3854f
C5547 a_21358_5679# sg13cmos5l_dfrbpq_1_0.D 0.11094f
C5548 a_13575_13940# a_13596_13686# 0.20754f
C5549 sg13cmos5l_nand4_1_18.B sg13cmos5l_nand4_1_18.A 0.17835f
C5550 sg13cmos5l_dfrbpq_1_15.Q a_6881_7190# 0.05446f
C5551 sg13cmos5l_dlygate4sd3_1_82.X a_16474_18984# 0.05411f
C5552 sg13cmos5l_buf_1_65.A bn3 0.10305f
C5553 sg13cmos5l_inv_1_8.A sg13cmos5l_inv_1_36.Y 0.0522f
C5554 sg13cmos5l_nand2_1_1.A a_16954_11424# 0.01016f
C5555 sg13cmos5l_buf_1_16.A a_18954_15532# 0.01381f
C5556 a_3592_19106# VDD 0.15088f
C5557 sg13cmos5l_o21ai_1_25.B1 sg13cmos5l_buf_8_2.A 0.02669f
C5558 sg13cmos5l_o21ai_1_3.Y a_16448_10034# 0.04111f
C5559 sg13cmos5l_buf_1_13.X a_16875_5423# 0.02962f
C5560 a_16836_20088# a_18095_19847# 0.01412f
C5561 sg13cmos5l_o21ai_1_7.B1 sg13cmos5l_o21ai_1_20.B1 0.06456f
C5562 a_12430_6980# VDD 0.19701f
C5563 sg13cmos5l_dlygate4sd3_1_55.X sg13cmos5l_inv_1_25.Y 0.01329f
C5564 a_5126_7674# a_5412_7992# 0.26205f
C5565 sg13cmos5l_inv_1_15.Y sg13cmos5l_inv_1_24.Y 0.02659f
C5566 sg13cmos5l_buf_1_1.A bp3 0.1505f
C5567 a_12045_11808# VDD 0.30479f
C5568 sg13cmos5l_nor2b_1_0.B_N sg13cmos5l_nand3_1_1.Y 0.01815f
C5569 a_12344_6166# VDD 0.27521f
C5570 a_9062_19770# VDD 0.52456f
C5571 sg13cmos5l_o21ai_1_26.B1 a_13686_18326# 0.11597f
C5572 a_20015_17869# a_20682_17508# 0.09257f
C5573 sg13cmos5l_buf_1_53.A sg13cmos5l_buf_1_21.A 0.01008f
C5574 a_21640_3176# VDD 0.17924f
C5575 sg13cmos5l_a21oi_1_21.A1 sg13cmos5l_buf_1_24.A 3.10078f
C5576 sg13cmos5l_buf_1_63.A sg13cmos5l_buf_1_25.A 0.13526f
C5577 a_22049_10888# a_22330_10666# 0.18796f
C5578 sg13cmos5l_a22oi_1_0.A2 sg13cmos5l_o21ai_1_0.A1 0.46184f
C5579 sg13cmos5l_a21oi_1_15.A2 sg13cmos5l_dfrbpq_1_28.D 0.0106f
C5580 sg13cmos5l_nand2b_1_3.Y sg13cmos5l_dfrbpq_1_47.Q 0.487f
C5581 sg13cmos5l_nand4_1_8.B a_13400_15238# 0.01295f
C5582 a_4744_19808# code7 0.07419f
C5583 a_9348_20088# a_10607_19847# 0.01412f
C5584 a_12426_9948# a_12808_10034# 0.01648f
C5585 a_12632_8477# a_12902_8436# 0.18796f
C5586 sg13cmos5l_inv_1_2.A sg13cmos5l_a21oi_1_2.Y 0.99108f
C5587 sg13cmos5l_buf_1_7.X a_20176_7894# 0.11191f
C5588 a_20384_16921# VDD 0.27605f
C5589 sg13cmos5l_nand2_1_13.A a_10016_13854# 0.01484f
C5590 sg13cmos5l_a21oi_1_5.A2 sg13cmos5l_a21oi_1_15.Y 0.01393f
C5591 sg13cmos5l_dlygate4sd3_1_28.A a_21370_6130# 0.29414f
C5592 sg13cmos5l_nor3_1_6.Y sg13cmos5l_a21oi_1_0.A2 0.04425f
C5593 sg13cmos5l_a21oi_1_8.Y VDD 0.16329f
C5594 sg13cmos5l_nand3_1_3.Y sg13cmos5l_nand2b_1_3.Y 0.02797f
C5595 sg13cmos5l_buf_1_15.A sg13cmos5l_nand2_1_11.B 0.12213f
C5596 sg13cmos5l_a21oi_1_7.A2 a_21099_9959# 0.05179f
C5597 a_7068_6126# VDD 0.07546f
C5598 sg13cmos5l_buf_8_2.A a_17015_9577# 0.01407f
C5599 sg13cmos5l_buf_1_45.X sg13cmos5l_dfrbpq_1_34.Q 0.02419f
C5600 a_17604_11464# a_17892_11885# 0.24435f
C5601 sg13cmos5l_o21ai_1_18.B1 a_11499_18380# 0.03733f
C5602 sg13cmos5l_buf_1_7.X a_18575_8797# 0.0168f
C5603 sg13cmos5l_o21ai_1_25.Y valid 0.02301f
C5604 sg13cmos5l_a21oi_1_2.A2 sg13cmos5l_dfrbpq_1_11.D 0.08523f
C5605 a_9176_13726# a_9446_13726# 0.18796f
C5606 a_21160_12972# VDD 0.18693f
C5607 a_12792_17064# sg13cmos5l_o21ai_1_24.Y 0.01519f
C5608 sg13cmos5l_buf_1_59.A a_12694_16742# 0.03676f
C5609 sg13cmos5l_buf_1_1.A a_22506_9948# 0.02745f
C5610 sg13cmos5l_o21ai_1_11.A2 a_7484_15976# 0.01131f
C5611 sg13cmos5l_o21ai_1_22.Y VDD 0.33072f
C5612 a_10508_10662# a_10774_10694# 0.01818f
C5613 sg13cmos5l_nand2_1_9.Y bn4 0.20186f
C5614 sg13cmos5l_o21ai_1_14.A1 sg13cmos5l_or4_1_1.X 0.30659f
C5615 sg13cmos5l_o21ai_1_7.B1 sg13cmos5l_o21ai_1_12.Y 0.38184f
C5616 sg13cmos5l_nand4_1_18.B sg13cmos5l_a21oi_1_27.A1 0.06309f
C5617 sg13cmos5l_nand4_1_6.B sg13cmos5l_nor4_1_4.C 0.06566f
C5618 a_17015_9577# a_16970_9344# 0.18486f
C5619 sg13cmos5l_buf_1_59.A a_13409_16936# 0.01347f
C5620 sg13cmos5l_a21oi_1_26.A2 a_16283_17508# 0.08326f
C5621 bp3 bn9 0.2816f
C5622 sg13cmos5l_mux2_1_0.S sg13cmos5l_mux2_1_1.X 0.09006f
C5623 sg13cmos5l_a21oi_1_3.A2 sg13cmos5l_nand2_1_13.Y 0.17369f
C5624 sg13cmos5l_inv_1_11.Y sg13cmos5l_inv_1_3.Y 0.03775f
C5625 a_4952_17549# VDD 0.28347f
C5626 sg13cmos5l_mux2_1_0.A1 sg13cmos5l_nand2_1_13.A 0.03599f
C5627 sg13cmos5l_buf_1_16.A sg13cmos5l_a21oi_1_5.A2 0.03076f
C5628 sg13cmos5l_o21ai_1_14.Y a_8338_16742# 0.06016f
C5629 sg13cmos5l_nor3_1_7.Y VDD 0.21548f
C5630 a_21366_10766# VDD 0.16031f
C5631 sg13cmos5l_nand4_1_0.C sg13cmos5l_o21ai_1_6.B1 0.38747f
C5632 sg13cmos5l_inv_1_1.A bp3 0.02939f
C5633 sg13cmos5l_buf_1_15.A sg13cmos5l_buf_1_20.A 0.07581f
C5634 a_15804_7638# a_16725_7832# 0.24169f
C5635 sg13cmos5l_inv_1_2.A sg13cmos5l_inv_1_6.Y 0.17604f
C5636 sg13cmos5l_nand2_1_1.Y sg13cmos5l_dlygate4sd3_1_25.A 0.01342f
C5637 sg13cmos5l_o21ai_1_13.B1 a_10906_18984# 0.01515f
C5638 sg13cmos5l_nand4_1_3.B sg13cmos5l_nand4_1_3.D 0.16805f
C5639 sg13cmos5l_a21oi_1_25.A2 sg13cmos5l_nor4_1_2.Y 0.03559f
C5640 a_20984_10702# VDD 0.25431f
C5641 sg13cmos5l_buf_1_7.X a_18922_5380# 0.19838f
C5642 a_8879_10309# a_8785_10309# 0.16704f
C5643 sg13cmos5l_dfrbpq_1_24.RESET_B code6 0.03135f
C5644 sg13cmos5l_o21ai_1_18.A2 sg13cmos5l_buf_1_65.A 0.12214f
C5645 sg13cmos5l_a21oi_1_16.A2 VDD 0.61607f
C5646 sg13cmos5l_dfrbpq_1_24.RESET_B sg13cmos5l_nor2_1_10.Y 0.02443f
C5647 sg13cmos5l_buf_1_10.A sg13cmos5l_dfrbpq_1_6.D 0.19472f
C5648 a_6682_15960# sg13cmos5l_o21ai_1_12.Y 0.29313f
C5649 a_14423_14113# a_14517_13880# 0.45119f
C5650 sg13cmos5l_buf_1_24.A sg13cmos5l_o21ai_1_28.A1 0.0293f
C5651 sg13cmos5l_inv_1_1.Y a_20609_15424# 0.0235f
C5652 sg13cmos5l_buf_1_66.X a_12886_15230# 0.08219f
C5653 sg13cmos5l_a21oi_1_21.A1 sg13cmos5l_o21ai_1_17.B1 0.13208f
C5654 a_17253_19749# a_17338_18984# 0.0121f
C5655 sg13cmos5l_nand2_1_9.Y VDD 0.38781f
C5656 a_20503_18222# a_20716_18258# 0.23043f
C5657 sg13cmos5l_inv_1_16.Y VDD 0.42507f
C5658 sg13cmos5l_inv_1_2.A a_18662_5850# 0.0228f
C5659 sg13cmos5l_nor2_1_7.Y a_5546_15532# 0.01295f
C5660 sg13cmos5l_nor3_1_2.A a_8206_9375# 0.01094f
C5661 a_21754_5376# sg13cmos5l_dlygate4sd3_1_2.A 0.30567f
C5662 sg13cmos5l_dfrbpq_1_2.D a_15223_7638# 0.017f
C5663 sg13cmos5l_inv_1_20.Y sg13cmos5l_a21oi_1_4.B1 0.66685f
C5664 sg13cmos5l_inv_1_36.A sg13cmos5l_mux2_1_0.S 0.38273f
C5665 sg13cmos5l_and2_1_5.X sg13cmos5l_buf_1_14.A 0.06127f
C5666 sg13cmos5l_dfrbpq_1_34.Q a_19642_19738# 0.01096f
C5667 a_16836_20088# a_18001_19847# 0.25046f
C5668 a_17355_19892# a_17124_19783# 0.07823f
C5669 sg13cmos5l_o21ai_1_28.A1 a_12136_16082# 0.03531f
C5670 sg13cmos5l_nand4_1_7.B a_11180_15198# 0.02975f
C5671 sg13cmos5l_o21ai_1_0.A1 a_13042_4646# 0.05966f
C5672 sg13cmos5l_o21ai_1_1.B1 a_12016_10190# 0.03064f
C5673 a_3879_16083# a_4682_16276# 0.07823f
C5674 a_20207_5773# a_20874_5412# 0.09257f
C5675 sg13cmos5l_buf_1_3.A a_19720_3176# 0.18852f
C5676 a_13862_6166# VDD 0.20729f
C5677 sg13cmos5l_dlygate4sd3_1_42.X a_6401_8702# 0.01066f
C5678 sg13cmos5l_nand2_1_0.A sg13cmos5l_a22oi_1_0.B2 0.03961f
C5679 a_12886_15230# VDD 0.01306f
C5680 sg13cmos5l_a21oi_1_4.A2 sg13cmos5l_nand3_1_8.Y 0.22587f
C5681 sg13cmos5l_a21oi_1_2.Y a_20997_6935# 0.01613f
C5682 sg13cmos5l_o21ai_1_26.B1 sg13cmos5l_buf_1_24.A 0.01904f
C5683 sg13cmos5l_dlygate4sd3_1_64.X a_5792_17594# 0.0128f
C5684 sg13cmos5l_a21oi_1_24.A1 bn4 0.01856f
C5685 bn3 bn2 0.0685f
C5686 bn4 code1 0.02275f
C5687 sg13cmos5l_dfrbpq_1_19.CLK sg13cmos5l_o21ai_1_13.B1 0.21618f
C5688 a_21215_17016# a_21215_15967# 0.05604f
C5689 a_14746_9912# a_14465_10214# 0.18796f
C5690 sg13cmos5l_buf_1_0.A bp5 0.05406f
C5691 sg13cmos5l_buf_1_7.X sg13cmos5l_dlygate4sd3_1_28.A 0.11582f
C5692 sg13cmos5l_a21oi_1_13.A2 sg13cmos5l_nand4_1_18.A 0.32574f
C5693 sg13cmos5l_dlygate4sd3_1_16.A a_22522_9154# 0.0241f
C5694 sg13cmos5l_dfrbpq_1_28.RESET_B a_17028_15552# 0.2905f
C5695 sg13cmos5l_nor2_1_15.Y sg13cmos5l_o21ai_1_28.A1 0.03179f
C5696 sg13cmos5l_dlygate4sd3_1_3.A a_22522_6130# 0.02406f
C5697 sg13cmos5l_nand2_1_1.Y bp0 0.0449f
C5698 sg13cmos5l_a21oi_1_4.A2 sg13cmos5l_nand4_1_1.C 0.01019f
C5699 a_12984_15552# VDD 0.01962f
C5700 sg13cmos5l_nor4_1_0.Y sg13cmos5l_dfrbpq_1_13.Q 0.20281f
C5701 sg13cmos5l_a21oi_1_14.Y bn7 0.01556f
C5702 a_18104_18262# sg13cmos5l_dfrbpq_1_33.Q 0.32882f
C5703 sg13cmos5l_o21ai_1_0.A2 sg13cmos5l_o21ai_1_4.A1 0.01265f
C5704 sg13cmos5l_nand4_1_6.B a_16476_16754# 0.01365f
C5705 sg13cmos5l_or4_1_1.X sg13cmos5l_o21ai_1_10.A2 0.63238f
C5706 sg13cmos5l_a21oi_1_15.A2 sg13cmos5l_dlygate4sd3_1_13.A 0.02013f
C5707 sg13cmos5l_nand4_1_8.B sg13cmos5l_o21ai_1_23.A2 0.14394f
C5708 sg13cmos5l_buf_8_2.A sg13cmos5l_o21ai_1_24.Y 0.06596f
C5709 sg13cmos5l_inv_1_1.Y bp7 0.04981f
C5710 sg13cmos5l_nand4_1_18.B sg13cmos5l_dfrbpq_1_24.RESET_B 0.0385f
C5711 a_7310_12400# VDD 0.10504f
C5712 sg13cmos5l_buf_1_15.A a_9765_19749# 0.0371f
C5713 a_10980_18576# VDD 0.07364f
C5714 sg13cmos5l_o21ai_1_0.A1 sg13cmos5l_nor4_1_0.Y 0.08255f
C5715 sg13cmos5l_nor4_1_2.Y bn2 0.05508f
C5716 a_21099_12332# VDD 0.20406f
C5717 a_18094_9375# a_18209_9376# 0.3854f
C5718 sg13cmos5l_buf_1_0.A a_21185_7864# 0.01567f
C5719 a_12394_18988# VDD 0.09727f
C5720 sg13cmos5l_or2_1_1.X sg13cmos5l_nand3_1_3.Y 0.07938f
C5721 sg13cmos5l_inv_1_2.A sg13cmos5l_inv_1_11.Y 0.05132f
C5722 VDD code1 0.56191f
C5723 sg13cmos5l_a21oi_1_24.A1 VDD 0.5332f
C5724 sg13cmos5l_a21oi_1_27.B1 a_10124_11424# 0.17449f
C5725 sg13cmos5l_inv_1_3.Y sg13cmos5l_buf_1_4.A 0.49712f
C5726 sg13cmos5l_buf_1_15.A sg13cmos5l_dfrbpq_1_30.Q 0.36435f
C5727 sg13cmos5l_inv_1_31.A a_17717_19020# 0.02204f
C5728 sg13cmos5l_buf_1_25.A sg13cmos5l_nand2_1_15.B 0.01006f
C5729 sg13cmos5l_o21ai_1_13.B1 a_11558_19020# 0.01577f
C5730 sg13cmos5l_dfrbpq_1_13.RESET_B sg13cmos5l_dlygate4sd3_1_38.X 0.11073f
C5731 a_8955_9228# sg13cmos5l_nand2b_1_5.Y 0.20916f
C5732 a_7484_15976# VDD 0.01784f
C5733 sg13cmos5l_dlygate4sd3_1_50.X sg13cmos5l_o21ai_1_10.B1 0.01089f
C5734 sg13cmos5l_buf_1_13.A sg13cmos5l_inv_1_0.Y 0.01115f
C5735 a_19336_3176# sample 0.15509f
C5736 sg13cmos5l_o21ai_1_7.B1 sg13cmos5l_dfrbpq_1_24.RESET_B 0.12666f
C5737 sg13cmos5l_inv_1_31.A sg13cmos5l_a21oi_1_26.A1 0.04576f
C5738 sg13cmos5l_o21ai_1_1.B1 a_14230_7670# 0.02423f
C5739 a_20294_10386# a_20554_9916# 0.45119f
C5740 sg13cmos5l_nand2_1_1.A a_19718_12214# 0.07169f
C5741 sg13cmos5l_buf_1_7.X a_20464_5654# 0.09834f
C5742 sg13cmos5l_dfrbpq_1_5.CLK a_21099_11471# 0.0208f
C5743 sg13cmos5l_dfrbpq_1_5.CLK bn5 0.02455f
C5744 sg13cmos5l_dfrbpq_1_13.RESET_B a_8037_9959# 0.05759f
C5745 sg13cmos5l_a21oi_1_18.B1 bn5 0.02181f
C5746 sg13cmos5l_o21ai_1_5.A2 sg13cmos5l_inv_1_8.A 0.0223f
C5747 sg13cmos5l_dfrbpq_1_18.Q a_11464_15366# 0.04831f
C5748 a_4064_15366# VDD 0.08955f
C5749 a_21063_18476# a_21911_18649# 0.07916f
C5750 sg13cmos5l_inv_1_31.A sg13cmos5l_buf_1_25.A 0.01709f
C5751 a_17931_6935# VDD 0.20327f
C5752 sg13cmos5l_inv_1_17.A bp5 0.21176f
C5753 a_4127_17016# a_4823_17137# 0.02431f
C5754 sg13cmos5l_dfrbpq_1_13.RESET_B sg13cmos5l_dlygate4sd3_1_33.X 0.22972f
C5755 sg13cmos5l_buf_1_13.X sg13cmos5l_a21oi_1_3.Y 0.04217f
C5756 sg13cmos5l_inv_1_31.A a_21063_16964# 0.04511f
C5757 sg13cmos5l_o21ai_1_0.B1 a_12712_4782# 0.01838f
C5758 sg13cmos5l_nor3_1_2.Y a_7750_9508# 0.04093f
C5759 a_19336_15366# VDD 0.13786f
C5760 sg13cmos5l_dfrbpq_1_15.CLK sg13cmos5l_dfrbpq_1_13.RESET_B 0.88366f
C5761 sg13cmos5l_dfrbpq_1_2.D a_16631_8065# 0.1613f
C5762 sg13cmos5l_dlygate4sd3_1_58.X code5 0.02114f
C5763 sg13cmos5l_nand2_1_1.A sg13cmos5l_nand3_1_8.Y 0.01755f
C5764 a_5829_7653# a_6577_7751# 0.01058f
C5765 a_6928_7894# a_7338_7972# 0.07015f
C5766 sg13cmos5l_a21oi_1_18.B1 sg13cmos5l_a21oi_1_23.A2 0.06346f
C5767 sg13cmos5l_nand3b_1_1.Y sg13cmos5l_inv_1_25.Y 0.01275f
C5768 sg13cmos5l_nor2_1_2.A a_6487_6126# 0.01162f
C5769 sg13cmos5l_inv_1_17.A a_22522_7642# 0.01799f
C5770 sg13cmos5l_nand4_1_15.B sg13cmos5l_nand2_1_15.Y 0.14059f
C5771 sg13cmos5l_buf_1_3.A a_22241_3328# 0.01397f
C5772 sg13cmos5l_nand2b_1_0.B sg13cmos5l_dlygate4sd3_1_9.A 0.07454f
C5773 sg13cmos5l_dlygate4sd3_1_76.A bn8 0.01916f
C5774 sg13cmos5l_nand2_1_0.A a_13014_8460# 0.06384f
C5775 sg13cmos5l_nor2_1_12.Y sg13cmos5l_nand4_1_1.B 0.08221f
C5776 sg13cmos5l_nand3b_1_3.C a_4646_19458# 0.02525f
C5777 sg13cmos5l_o21ai_1_21.A2 sg13cmos5l_nand3b_1_1.Y 0.27349f
C5778 sg13cmos5l_o21ai_1_5.A1 a_13782_15302# 0.01937f
C5779 sg13cmos5l_buf_1_25.A sg13cmos5l_nand4_1_8.B 0.11555f
C5780 sg13cmos5l_buf_1_42.A a_17984_13854# 0.01331f
C5781 sg13cmos5l_buf_1_7.X sg13cmos5l_dfrbpq_1_7.D 0.02328f
C5782 a_20554_4873# a_20294_4650# 0.45119f
C5783 sg13cmos5l_buf_8_2.A sg13cmos5l_dlygate4sd3_1_22.A 0.44109f
C5784 sg13cmos5l_buf_1_66.X sg13cmos5l_nor4_1_4.C 0.01926f
C5785 sg13cmos5l_buf_1_21.A a_12987_12214# 0.0119f
C5786 sg13cmos5l_inv_1_31.A sg13cmos5l_a21oi_1_13.Y 0.02833f
C5787 sg13cmos5l_o21ai_1_5.A2 bp0 0.11091f
C5788 sg13cmos5l_nand4_1_18.A sg13cmos5l_a21oi_1_15.Y 0.02143f
C5789 a_19160_9190# sg13cmos5l_dlygate4sd3_1_22.A 0.28177f
C5790 a_12906_18556# VDD 0.2878f
C5791 VDD bp1 0.48603f
C5792 sg13cmos5l_buf_1_9.A a_20554_8404# 0.01622f
C5793 sg13cmos5l_nand2b_1_1.A_N sg13cmos5l_dfrbpq_1_15.Q 0.02786f
C5794 sg13cmos5l_nor3_1_2.B sg13cmos5l_dlygate4sd3_1_8.X 0.03789f
C5795 sg13cmos5l_o21ai_1_20.A1 a_4114_17886# 0.0571f
C5796 sg13cmos5l_nand4_1_16.D a_15400_15272# 0.06623f
C5797 a_19246_19959# VDD 0.15803f
C5798 a_1690_19738# comp 0.29895f
C5799 sg13cmos5l_a21oi_1_27.B1 sg13cmos5l_dlygate4sd3_1_50.A 0.01231f
C5800 sg13cmos5l_nand3b_1_3.C a_14283_16007# 0.03206f
C5801 sg13cmos5l_dfrbpq_1_21.D sg13cmos5l_dfrbpq_1_24.RESET_B 0.08695f
C5802 sg13cmos5l_buf_1_7.X a_20580_9952# 0.03545f
C5803 a_13936_19262# VDD 0.13585f
C5804 sg13cmos5l_o21ai_1_19.B1 VDD 0.27998f
C5805 sg13cmos5l_nand4_1_18.B a_8337_13362# 0.10471f
C5806 sg13cmos5l_dfrbpq_1_30.Q a_19066_15960# 0.01465f
C5807 a_22522_3106# bp5 0.0102f
C5808 a_3296_19902# VDD 0.06988f
C5809 sg13cmos5l_inv_1_2.A sg13cmos5l_buf_1_4.A 0.02745f
C5810 sg13cmos5l_inv_1_1.Y a_20580_14040# 0.04984f
C5811 sg13cmos5l_nand3_1_8.Y sg13cmos5l_nand4_1_1.A 1.16943f
C5812 a_11397_18237# a_11489_17774# 0.01281f
C5813 sg13cmos5l_buf_1_0.A a_21070_7863# 0.0119f
C5814 sg13cmos5l_a21oi_1_10.A2 a_9274_6888# 0.01089f
C5815 sg13cmos5l_nor4_1_4.C VDD 0.77067f
C5816 sg13cmos5l_inv_1_15.A a_18490_9154# 0.01272f
C5817 sg13cmos5l_buf_1_43.X a_17547_15356# 0.05185f
C5818 sg13cmos5l_a21oi_1_0.Y sg13cmos5l_inv_1_0.Y 0.07374f
C5819 sg13cmos5l_buf_1_13.X a_17318_11898# 0.09565f
C5820 sg13cmos5l_buf_1_16.A sg13cmos5l_nand4_1_18.A 0.03381f
C5821 sg13cmos5l_nand4_1_1.C sg13cmos5l_nand4_1_1.A 0.74111f
C5822 sg13cmos5l_mux2_1_0.S sg13cmos5l_mux2_1_1.A0 0.44804f
C5823 sg13cmos5l_dfrbpq_1_13.RESET_B a_9546_9948# 0.01787f
C5824 a_21911_18649# sg13cmos5l_a21oi_1_14.Y 0.18371f
C5825 sg13cmos5l_nand2_1_3.Y a_8993_7190# 0.02921f
C5826 sg13cmos5l_inv_1_13.Y a_18874_9912# 0.0233f
C5827 sg13cmos5l_inv_1_1.Y sg13cmos5l_inv_1_12.Y 0.02044f
C5828 sg13cmos5l_dfrbpq_1_28.RESET_B a_20554_13945# 0.20146f
C5829 sg13cmos5l_dfrbpq_1_9.Q VDD 0.30627f
C5830 sg13cmos5l_o21ai_1_18.A2 sg13cmos5l_o21ai_1_14.A1 0.02068f
C5831 sg13cmos5l_o21ai_1_10.A2 bn3 0.13969f
C5832 sg13cmos5l_o21ai_1_21.B1 sg13cmos5l_o21ai_1_20.Y 0.04292f
C5833 sg13cmos5l_o21ai_1_18.B1 sg13cmos5l_dlygate4sd3_1_65.A 0.01704f
C5834 bp6 bp1 0.0231f
C5835 bp9 comp_clk 0.07983f
C5836 sg13cmos5l_a21oi_1_18.B1 sg13cmos5l_buf_1_43.X 0.08322f
C5837 a_12929_19960# a_13210_19738# 0.18796f
C5838 sg13cmos5l_buf_1_0.A a_15223_7638# 0.01033f
C5839 a_22145_19286# VDD 0.20266f
C5840 sg13cmos5l_dfrbpq_1_15.Q a_7158_8802# 0.01771f
C5841 a_7162_6888# a_6881_7190# 0.18796f
C5842 sg13cmos5l_a21oi_1_9.B1 a_10607_5773# 0.02038f
C5843 sg13cmos5l_buf_1_63.A sg13cmos5l_o21ai_1_25.Y 0.56494f
C5844 sg13cmos5l_dlygate4sd3_1_28.A bp4 0.03426f
C5845 sg13cmos5l_a22oi_1_2.Y a_15622_8412# 0.01571f
C5846 sg13cmos5l_dfrbpq_1_13.CLK sg13cmos5l_inv_1_8.A 0.72936f
C5847 sg13cmos5l_inv_1_1.A bn5 0.60414f
C5848 sg13cmos5l_nor2_1_2.A a_7989_6320# 0.01032f
C5849 sg13cmos5l_dlygate4sd3_1_9.A a_15104_7849# 0.08256f
C5850 sg13cmos5l_inv_1_14.Y a_17872_5654# 0.01367f
C5851 a_14842_9154# VDD 0.26694f
C5852 sg13cmos5l_buf_1_63.A a_12814_19959# 0.03436f
C5853 sg13cmos5l_inv_1_36.Y a_15405_11808# 0.08131f
C5854 sg13cmos5l_inv_1_17.A a_21839_14845# 0.03594f
C5855 a_5124_9504# a_5412_9199# 0.24435f
C5856 sg13cmos5l_nand4_1_3.B sg13cmos5l_mux2_1_0.S 0.40387f
C5857 a_21099_4772# bp2 0.06059f
C5858 a_15141_6141# VDD 0.24765f
C5859 a_19173_19031# VDD 0.2468f
C5860 sg13cmos5l_inv_1_17.A sg13cmos5l_dlygate4sd3_1_24.A 0.11834f
C5861 sg13cmos5l_nand2_1_12.Y sg13cmos5l_nand4_1_1.B 0.03292f
C5862 sg13cmos5l_o21ai_1_23.B1 a_15690_15996# 0.07891f
C5863 sg13cmos5l_buf_1_66.X sg13cmos5l_o21ai_1_28.B1 0.05125f
C5864 sg13cmos5l_inv_1_36.A sg13cmos5l_dlygate4sd3_1_45.X 0.01432f
C5865 a_22241_6352# bp1 0.03208f
C5866 sg13cmos5l_dfrbpq_1_9.Q bp6 0.04448f
C5867 sg13cmos5l_dfrbpq_1_13.CLK sg13cmos5l_inv_1_22.Y 0.07151f
C5868 a_16810_19993# valid 0.0378f
C5869 sg13cmos5l_buf_1_1.A sg13cmos5l_dlygate4sd3_1_20.A 0.11479f
C5870 a_22042_15202# bn7 0.01285f
C5871 sg13cmos5l_nand4_1_18.B sg13cmos5l_nand2_1_19.A 0.06542f
C5872 sg13cmos5l_nand2_1_15.B a_14253_13320# 0.01572f
C5873 a_20716_16746# VDD 0.13589f
C5874 sg13cmos5l_dlygate4sd3_1_72.A a_19035_16750# 0.07368f
C5875 sg13cmos5l_dlygate4sd3_1_9.A sg13cmos5l_nand2b_1_3.B 0.08692f
C5876 a_8637_5682# a_9062_5850# 0.01004f
C5877 a_6756_11464# VDD 0.07916f
C5878 sg13cmos5l_o21ai_1_11.B1 sg13cmos5l_o21ai_1_8.B1 0.01105f
C5879 a_16474_18984# VDD 0.26181f
C5880 sg13cmos5l_o21ai_1_28.B1 VDD 0.32715f
C5881 sg13cmos5l_dfrbpq_1_24.D VDD 0.24853f
C5882 a_20464_5654# bp4 0.02294f
C5883 sg13cmos5l_dlygate4sd3_1_42.A VDD 0.34994f
C5884 sg13cmos5l_buf_1_42.A sg13cmos5l_nand3_1_0.B 0.10225f
C5885 sg13cmos5l_inv_1_24.A sg13cmos5l_and4_1_1.A 0.01863f
C5886 a_18101_14020# sg13cmos5l_dlygate4sd3_1_76.A 0.10092f
C5887 sg13cmos5l_dfrbpq_1_24.RESET_B a_5578_12940# 0.18355f
C5888 sg13cmos5l_buf_1_45.X a_17253_19749# 0.03674f
C5889 code7 code6 0.21008f
C5890 sg13cmos5l_a21oi_1_0.A2 sg13cmos5l_inv_1_5.A 0.05308f
C5891 sg13cmos5l_nor3_1_6.Y sg13cmos5l_dfrbpq_1_28.D 0.6567f
C5892 sg13cmos5l_a21oi_1_15.Y a_17429_12508# 0.05073f
C5893 sg13cmos5l_a21oi_1_27.B1 sg13cmos5l_nand4_1_15.B 0.41073f
C5894 sg13cmos5l_a21oi_1_21.A1 sg13cmos5l_dlygate4sd3_1_82.X 0.02329f
C5895 a_22522_9154# VDD 0.25909f
C5896 sg13cmos5l_buf_1_42.A a_17051_15996# 0.01337f
C5897 sg13cmos5l_a21oi_1_5.A2 sg13cmos5l_a21oi_1_2.B1 0.84843f
C5898 sg13cmos5l_buf_1_9.A sg13cmos5l_dfrbpq_1_9.D 0.0197f
C5899 sg13cmos5l_a21oi_1_6.A2 sg13cmos5l_nand2_1_13.Y 0.32252f
C5900 sg13cmos5l_nand4_1_3.D sg13cmos5l_a21oi_1_5.A2 0.01788f
C5901 sg13cmos5l_a21oi_1_26.A1 sg13cmos5l_inv_1_25.Y 1.11529f
C5902 sg13cmos5l_buf_1_63.A valid 0.17154f
C5903 sg13cmos5l_nand3b_1_3.C sg13cmos5l_nand3b_1_1.Y 0.3124f
C5904 a_5578_12940# a_5604_12976# 0.24169f
C5905 sg13cmos5l_buf_1_9.A sg13cmos5l_a21oi_1_3.Y 1.12508f
C5906 sg13cmos5l_a21oi_1_7.A2 VDD 0.6791f
C5907 sg13cmos5l_buf_1_63.A a_16170_20068# 0.01279f
C5908 sg13cmos5l_inv_1_15.Y sg13cmos5l_buf_1_13.X 0.03822f
C5909 sg13cmos5l_buf_1_16.A sg13cmos5l_dlygate4sd3_1_22.A 0.0151f
C5910 sg13cmos5l_inv_1_31.A a_20974_16746# 0.01121f
C5911 sg13cmos5l_buf_1_25.A sg13cmos5l_inv_1_25.Y 0.10664f
C5912 sg13cmos5l_dlygate4sd3_1_50.X sg13cmos5l_dlygate4sd3_1_50.A 0.19156f
C5913 sg13cmos5l_buf_8_2.A sg13cmos5l_dfrbpq_1_39.D 0.03005f
C5914 a_3415_16710# a_3886_16746# 0.16704f
C5915 sg13cmos5l_dlygate4sd3_1_50.X a_3800_19061# 0.01162f
C5916 sg13cmos5l_inv_1_9.Y a_15820_9186# 0.02268f
C5917 sg13cmos5l_o21ai_1_22.Y a_9734_17508# 0.04621f
C5918 sg13cmos5l_buf_1_0.A a_16631_8065# 0.01347f
C5919 a_4108_18258# VDD 0.13637f
C5920 sg13cmos5l_inv_1_8.A a_15223_7638# 0.01099f
C5921 sg13cmos5l_inv_1_31.A a_15780_18576# 0.04247f
C5922 sg13cmos5l_a21oi_1_3.A2 VDD 0.86124f
C5923 sg13cmos5l_a21oi_1_26.Y sg13cmos5l_inv_1_25.Y 0.02333f
C5924 a_20890_15202# VDD 0.26086f
C5925 a_8006_7678# a_8118_7742# 0.3854f
C5926 sg13cmos5l_buf_1_10.A sg13cmos5l_inv_1_4.Y 0.02108f
C5927 sg13cmos5l_a21oi_1_2.B1 a_20024_6166# 0.05905f
C5928 sg13cmos5l_nand3_1_0.B sg13cmos5l_nand3_1_1.Y 0.22195f
C5929 sg13cmos5l_buf_1_24.A sg13cmos5l_nand3_1_6.C 0.02288f
C5930 sg13cmos5l_buf_1_45.X a_14920_14484# 0.02262f
C5931 sg13cmos5l_dlygate4sd3_1_25.A a_17914_9912# 0.27413f
C5932 sg13cmos5l_o21ai_1_7.A2 sg13cmos5l_o21ai_1_21.Y 0.01556f
C5933 sg13cmos5l_o21ai_1_15.B1 sg13cmos5l_or4_1_1.X 0.16522f
C5934 a_6383_9263# a_6289_9263# 0.16704f
C5935 sg13cmos5l_inv_1_17.A a_21920_17594# 0.01243f
C5936 sg13cmos5l_buf_1_43.X sg13cmos5l_inv_1_1.A 0.08506f
C5937 a_17098_6130# VDD 0.87273f
C5938 sg13cmos5l_nand4_1_1.B sg13cmos5l_buf_1_57.A 0.03428f
C5939 a_20682_19020# VDD 0.27734f
C5940 a_20580_11464# bn8 0.01238f
C5941 sg13cmos5l_inv_1_17.A bn6 0.1686f
C5942 sg13cmos5l_dfrbpq_1_15.CLK a_7068_6126# 0.04746f
C5943 sg13cmos5l_nand2b_1_1.A_N sg13cmos5l_dfrbpq_1_47.Q 0.79705f
C5944 sg13cmos5l_inv_1_8.A a_11759_10309# 0.01122f
C5945 sg13cmos5l_inv_1_17.A a_22330_10666# 0.05159f
C5946 sg13cmos5l_buf_1_13.A a_16356_5416# 0.03945f
C5947 sg13cmos5l_nand2_1_19.Y a_12538_10702# 0.01598f
C5948 a_21839_4727# a_22096_4870# 0.23043f
C5949 a_20580_4968# a_21745_4727# 0.25046f
C5950 a_21099_4772# a_20868_4663# 0.07823f
C5951 sg13cmos5l_nand2b_1_1.A_N sg13cmos5l_nand3_1_3.Y 0.18881f
C5952 code2 bn1 0.02416f
C5953 code3 bn0 0.25172f
C5954 sg13cmos5l_buf_1_13.A sg13cmos5l_inv_1_8.Y 0.63146f
C5955 a_9062_5850# a_9348_5416# 0.26205f
C5956 a_11288_19061# bn3 0.06037f
C5957 sg13cmos5l_nor4_1_0.Y sg13cmos5l_o21ai_1_1.Y 0.02601f
C5958 sg13cmos5l_and4_1_0.D a_13505_7864# 0.01397f
C5959 sg13cmos5l_a21oi_1_27.A1 sg13cmos5l_buf_1_22.A 0.10108f
C5960 a_8015_11821# VDD 0.17393f
C5961 sg13cmos5l_nor4_1_0.Y sg13cmos5l_nand2b_1_3.Y 0.23624f
C5962 sg13cmos5l_nand4_1_3.B sg13cmos5l_a21oi_1_12.A2 0.01474f
C5963 sg13cmos5l_buf_1_57.A sg13cmos5l_o21ai_1_28.Y 0.09971f
C5964 sg13cmos5l_o21ai_1_7.B1 code7 0.06889f
C5965 sg13cmos5l_a21oi_1_0.A2 sg13cmos5l_dlygate4sd3_1_29.X 0.04527f
C5966 sg13cmos5l_dfrbpq_1_24.RESET_B a_7120_13214# 0.09627f
C5967 sg13cmos5l_o21ai_1_18.B1 sg13cmos5l_buf_1_24.A 0.94238f
C5968 sg13cmos5l_buf_1_7.X sg13cmos5l_dlygate4sd3_1_29.A 0.35766f
C5969 sg13cmos5l_o21ai_1_0.A2 sg13cmos5l_o21ai_1_0.Y 0.28275f
C5970 sg13cmos5l_dfrbpq_1_35.D VDD 0.19609f
C5971 sg13cmos5l_a21oi_1_27.B1 sg13cmos5l_o21ai_1_9.A2 0.09634f
C5972 sg13cmos5l_inv_1_2.A a_20997_6935# 0.21832f
C5973 sg13cmos5l_a21oi_1_24.A1 sg13cmos5l_a21oi_1_24.A2 0.11789f
C5974 a_19432_3900# VDD 0.18017f
C5975 a_6209_19960# VDD 0.20205f
C5976 sg13cmos5l_dlygate4sd3_1_29.X sg13cmos5l_inv_1_14.Y 0.01199f
C5977 sg13cmos5l_dfrbpq_1_15.Q VDD 1.26581f
C5978 sg13cmos5l_buf_1_13.X sg13cmos5l_buf_1_7.X 0.54111f
C5979 sg13cmos5l_nor3_1_2.B a_11372_10662# 0.01793f
C5980 sg13cmos5l_nor3_1_6.Y sg13cmos5l_dlygate4sd3_1_13.A 0.02271f
C5981 sg13cmos5l_inv_1_17.Y VDD 0.62817f
C5982 sg13cmos5l_a21oi_1_14.Y a_22523_15532# 0.10509f
C5983 sg13cmos5l_buf_8_2.A sg13cmos5l_nand2_1_19.A 0.07055f
C5984 a_6021_12983# a_6123_12983# 0.3643f
C5985 sg13cmos5l_dfrbpq_1_24.RESET_B a_6256_14726# 0.09622f
C5986 sg13cmos5l_buf_1_9.A sg13cmos5l_dfrbpq_1_0.D 0.04273f
C5987 a_13768_14484# bn0 0.0761f
C5988 sg13cmos5l_nor4_1_2.Y sg13cmos5l_nand3_1_8.Y 0.01323f
C5989 sg13cmos5l_dfrbpq_1_28.RESET_B bn8 0.11129f
C5990 sg13cmos5l_nand4_1_18.D sg13cmos5l_a21oi_1_23.A2 0.04086f
C5991 sg13cmos5l_inv_1_16.Y a_17578_11428# 0.01377f
C5992 a_19336_3176# comp_clk 0.06482f
C5993 a_8411_12252# a_8200_12342# 0.0213f
C5994 sg13cmos5l_a21oi_1_4.A1 a_13596_13686# 0.01359f
C5995 sg13cmos5l_dfrbpq_1_20.D VDD 0.22106f
C5996 sg13cmos5l_nor4_1_2.Y sg13cmos5l_nand4_1_1.C 0.41852f
C5997 sg13cmos5l_dfrbpq_1_41.CLK sg13cmos5l_nand4_1_1.B 0.03174f
C5998 sg13cmos5l_inv_1_31.A a_17706_18556# 0.01008f
C5999 sg13cmos5l_inv_1_36.A sg13cmos5l_nand2_1_18.A 0.29931f
C6000 sg13cmos5l_inv_1_24.Y busy 0.0226f
C6001 sg13cmos5l_nand4_1_6.B sg13cmos5l_a21oi_1_6.A2 0.05683f
C6002 sg13cmos5l_o21ai_1_1.B1 sg13cmos5l_buf_1_0.A 0.02761f
C6003 sg13cmos5l_o21ai_1_15.Y sg13cmos5l_or4_1_1.X 0.03273f
C6004 sg13cmos5l_nand4_1_7.B sg13cmos5l_inv_1_24.Y 0.77408f
C6005 sg13cmos5l_nand2_1_3.Y a_6881_7190# 0.0128f
C6006 sg13cmos5l_nand4_1_1.B sg13cmos5l_nand4_1_1.A 0.71203f
C6007 sg13cmos5l_buf_1_14.A a_16342_10694# 0.06809f
C6008 sg13cmos5l_nand3b_1_1.Y sg13cmos5l_buf_1_65.A 0.04068f
C6009 sg13cmos5l_inv_1_15.A a_21063_16083# 0.01278f
C6010 sg13cmos5l_inv_1_15.A sg13cmos5l_nand4_1_6.B 0.21485f
C6011 sg13cmos5l_buf_1_54.A a_17028_15552# 0.02696f
C6012 sg13cmos5l_buf_1_24.A bn1 0.02233f
C6013 sg13cmos5l_buf_1_63.A sg13cmos5l_nor2_1_16.Y 0.06587f
C6014 a_14283_16007# bn2 0.02227f
C6015 a_14744_19061# sg13cmos5l_inv_1_25.Y 0.01098f
C6016 a_19432_3900# bp6 0.19123f
C6017 sg13cmos5l_dlygate4sd3_1_50.A sg13cmos5l_nor3_1_6.Y 0.046f
C6018 sg13cmos5l_buf_1_10.A sg13cmos5l_nand3_1_0.Y 0.02712f
C6019 a_18778_6130# VDD 0.26091f
C6020 sg13cmos5l_or4_1_1.X a_9096_15996# 0.1504f
C6021 sg13cmos5l_nand3_1_2.A sg13cmos5l_inv_1_36.Y 0.19006f
C6022 sg13cmos5l_inv_1_5.A a_15243_6284# 0.04801f
C6023 a_21080_19061# VDD 0.26166f
C6024 a_21531_13342# bn7 0.0862f
C6025 sg13cmos5l_inv_1_8.A sg13cmos5l_o21ai_1_3.A2 0.02756f
C6026 sg13cmos5l_inv_1_17.Y bp6 0.26682f
C6027 sg13cmos5l_inv_1_20.Y sg13cmos5l_buf_1_5.A 0.07611f
C6028 sg13cmos5l_o21ai_1_18.B1 sg13cmos5l_o21ai_1_17.B1 0.04399f
C6029 sg13cmos5l_nand3_1_0.A a_15804_7638# 0.01368f
C6030 sg13cmos5l_o21ai_1_8.B1 sg13cmos5l_nand2_1_9.Y 0.08069f
C6031 sg13cmos5l_nand2_1_0.A a_12826_9154# 0.02405f
C6032 sg13cmos5l_buf_1_15.A sg13cmos5l_dlygate4sd3_1_65.A 0.62031f
C6033 sg13cmos5l_dfrbpq_1_30.D sg13cmos5l_inv_1_17.A 0.06597f
C6034 sg13cmos5l_a21oi_1_18.B1 sg13cmos5l_o21ai_1_23.B1 0.1403f
C6035 sg13cmos5l_dfrbpq_1_39.D sg13cmos5l_buf_1_16.A 0.0187f
C6036 sg13cmos5l_inv_1_31.A valid 0.02817f
C6037 sg13cmos5l_nand4_1_3.B sg13cmos5l_dlygate4sd3_1_45.X 0.01415f
C6038 sg13cmos5l_inv_1_17.A a_19912_11460# 0.1836f
C6039 a_11648_10830# VDD 0.07405f
C6040 a_9765_5423# a_9636_5837# 0.01562f
C6041 a_9348_5416# a_9867_5423# 0.20754f
C6042 a_19054_18447# sg13cmos5l_dfrbpq_1_39.D 0.10701f
C6043 sg13cmos5l_a21oi_1_0.A2 a_18948_7687# 0.01718f
C6044 sg13cmos5l_nand2_1_18.A a_11552_11546# 0.02331f
C6045 a_19448_12214# a_19718_12214# 0.18796f
C6046 a_9056_11546# VDD 0.07804f
C6047 sg13cmos5l_or4_1_1.X sg13cmos5l_nand4_1_1.B 0.17564f
C6048 sg13cmos5l_dfrbpq_1_13.CLK sg13cmos5l_a21o_1_0.A1 0.03756f
C6049 a_15494_18258# VDD 0.52494f
C6050 sg13cmos5l_dfrbpq_1_41.CLK a_12939_19031# 0.03024f
C6051 sg13cmos5l_inv_1_12.A a_20513_13238# 0.01023f
C6052 sg13cmos5l_nor2_1_15.Y bn1 0.01584f
C6053 sg13cmos5l_a21oi_1_2.Y sg13cmos5l_dfrbpq_1_9.Q 0.09193f
C6054 sg13cmos5l_buf_1_9.A sg13cmos5l_a21oi_1_6.Y 0.5835f
C6055 sg13cmos5l_nand2_1_15.B sg13cmos5l_nand2_1_15.Y 0.13741f
C6056 sg13cmos5l_a21oi_1_4.A2 sg13cmos5l_nand2_1_2.Y 0.09193f
C6057 a_20506_19738# VDD 0.25524f
C6058 sg13cmos5l_inv_1_6.Y bp1 0.32658f
C6059 sg13cmos5l_nor3_1_2.B sg13cmos5l_nor2_1_0.Y 0.014f
C6060 sg13cmos5l_dfrbpq_1_13.Q sg13cmos5l_a21oi_1_9.A2 0.03046f
C6061 sg13cmos5l_buf_1_25.A sg13cmos5l_nand3b_1_3.C 0.01789f
C6062 sg13cmos5l_nand3_1_5.Y sg13cmos5l_o21ai_1_21.Y 0.20476f
C6063 sg13cmos5l_a21oi_1_27.A1 a_9636_12528# 0.06374f
C6064 sg13cmos5l_nand4_1_6.B sg13cmos5l_nand4_1_5.D 0.05939f
C6065 sg13cmos5l_nand3_1_0.B sg13cmos5l_nand3_1_0.Y 0.12924f
C6066 sg13cmos5l_or2_1_1.X sg13cmos5l_nor4_1_0.Y 0.46932f
C6067 a_20997_13701# VDD 0.2465f
C6068 sg13cmos5l_nand4_1_6.B sg13cmos5l_o21ai_1_28.A1 0.02495f
C6069 sg13cmos5l_o21ai_1_17.B1 bn1 0.02252f
C6070 a_7120_13214# a_6863_13333# 0.23043f
C6071 sg13cmos5l_nand4_1_15.B sg13cmos5l_nand2_1_15.B 0.12999f
C6072 sg13cmos5l_buf_1_43.X sg13cmos5l_nand4_1_18.D 0.08268f
C6073 sg13cmos5l_inv_1_15.Y sg13cmos5l_buf_1_9.A 0.19681f
C6074 sg13cmos5l_o21ai_1_0.A1 sg13cmos5l_a21oi_1_9.A2 0.02767f
C6075 a_13676_19734# code3 0.15701f
C6076 sg13cmos5l_dfrbpq_1_19.CLK a_3975_16964# 0.03156f
C6077 sg13cmos5l_nand4_1_17.Y sg13cmos5l_nand4_1_5.D 0.02186f
C6078 sg13cmos5l_dfrbpq_1_28.RESET_B a_22096_13942# 0.09972f
C6079 sg13cmos5l_nand4_1_3.D sg13cmos5l_nand4_1_18.A 0.04655f
C6080 sg13cmos5l_dfrbpq_1_13.RESET_B sg13cmos5l_dfrbpq_1_13.D 0.16074f
C6081 sg13cmos5l_nand3_1_2.A sg13cmos5l_nand2_1_1.Y 0.2857f
C6082 sg13cmos5l_nand4_1_8.B valid 0.13382f
C6083 sg13cmos5l_a21oi_1_3.A2 a_17621_7972# 0.08268f
C6084 sg13cmos5l_dlygate4sd3_1_50.X sg13cmos5l_o21ai_1_9.A2 0.06338f
C6085 a_13409_16936# VDD 0.21241f
C6086 sg13cmos5l_inv_1_8.A sg13cmos5l_o21ai_1_1.B1 0.25766f
C6087 sg13cmos5l_dlygate4sd3_1_13.X a_17622_10766# 0.11447f
C6088 sg13cmos5l_nand4_1_18.B sg13cmos5l_dfrbpq_1_18.Q 0.03399f
C6089 sg13cmos5l_nand4_1_16.D bn6 0.76966f
C6090 sg13cmos5l_a21oi_1_18.B1 a_22096_14726# 0.01483f
C6091 sg13cmos5l_o21ai_1_13.B1 sg13cmos5l_nor2_1_10.Y 0.1427f
C6092 sg13cmos5l_buf_1_45.X sg13cmos5l_o21ai_1_5.A1 0.05556f
C6093 sg13cmos5l_buf_1_13.A a_17290_8404# 0.02799f
C6094 sg13cmos5l_dlygate4sd3_1_0.A bp3 0.01015f
C6095 sg13cmos5l_or4_1_1.X a_9832_16082# 0.02051f
C6096 sg13cmos5l_o21ai_1_1.B1 sg13cmos5l_a22oi_1_2.Y 0.02311f
C6097 sg13cmos5l_nand4_1_18.B sg13cmos5l_buf_1_43.X 0.19818f
C6098 sg13cmos5l_a21oi_1_12.Y VDD 0.5076f
C6099 sg13cmos5l_dlygate4sd3_1_80.X sg13cmos5l_a21oi_1_4.A2 0.08559f
C6100 sg13cmos5l_buf_1_45.X sg13cmos5l_dlygate4sd3_1_97.X 0.06296f
C6101 sg13cmos5l_dfrbpq_1_13.CLK a_15405_11808# 0.01284f
C6102 sg13cmos5l_nand4_1_15.B sg13cmos5l_nor3_1_6.Y 0.01726f
C6103 a_13575_13940# VDD 0.20592f
C6104 sg13cmos5l_nand4_1_12.Y a_17825_17774# 0.0438f
C6105 sg13cmos5l_dlygate4sd3_1_50.X sg13cmos5l_a21oi_1_27.B1 0.05953f
C6106 sg13cmos5l_inv_1_20.Y sg13cmos5l_nor2b_1_0.B_N 0.04928f
C6107 a_11674_12936# a_11393_13238# 0.18796f
C6108 a_13198_9228# sg13cmos5l_a22oi_1_0.A2 0.1521f
C6109 a_6256_14726# a_5999_14845# 0.23043f
C6110 sg13cmos5l_buf_1_45.X a_15400_15272# 0.01939f
C6111 sg13cmos5l_dfrbpq_1_41.CLK sg13cmos5l_dfrbpq_1_48.Q 0.10767f
C6112 a_10694_18258# bn3 0.04119f
C6113 a_3900_16357# VDD 0.07249f
C6114 sg13cmos5l_buf_1_22.A a_11278_13239# 0.1158f
C6115 a_10864_5654# a_10607_5773# 0.23043f
C6116 a_10784_7806# VDD 0.08023f
C6117 sg13cmos5l_buf_8_2.A a_21099_11471# 0.02894f
C6118 a_12632_8477# VDD 0.27554f
C6119 sg13cmos5l_buf_8_2.A bn5 0.50698f
C6120 sg13cmos5l_o21ai_1_5.A1 a_10461_11730# 0.02535f
C6121 sg13cmos5l_dfrbpq_1_47.Q VDD 0.48881f
C6122 a_17296_18478# VDD 0.13573f
C6123 sg13cmos5l_o21ai_1_23.B1 sg13cmos5l_inv_1_1.A 0.55373f
C6124 a_8694_14020# VDD 0.01714f
C6125 a_20580_6928# a_21839_7285# 0.01412f
C6126 sg13cmos5l_dfrbpq_1_29.Q sg13cmos5l_nand3_1_8.Y 0.27484f
C6127 sg13cmos5l_inv_1_0.Y sg13cmos5l_inv_1_7.A 0.01236f
C6128 sg13cmos5l_buf_1_10.A a_13749_9386# 0.01145f
C6129 sg13cmos5l_nand3_1_3.Y VDD 1.06839f
C6130 sg13cmos5l_inv_1_1.Y sg13cmos5l_buf_1_10.A 0.03048f
C6131 sg13cmos5l_buf_1_1.A a_22096_14726# 0.03336f
C6132 a_1294_9375# sg13cmos5l_buf_1_17.A 0.1068f
C6133 a_8337_13362# a_9056_13058# 0.01604f
C6134 sg13cmos5l_buf_1_7.X sg13cmos5l_buf_1_9.A 0.12089f
C6135 sg13cmos5l_inv_1_1.A a_17633_10214# 0.01038f
C6136 sg13cmos5l_o21ai_1_25.Y sg13cmos5l_inv_1_25.Y 0.02272f
C6137 sg13cmos5l_nor3_1_7.Y a_19048_12248# 0.19691f
C6138 sg13cmos5l_nand3_1_5.Y a_5998_17775# 0.01437f
C6139 sg13cmos5l_a21oi_1_13.Y a_20997_14495# 0.01398f
C6140 sg13cmos5l_dfrbpq_1_45.Q a_8337_13362# 0.01129f
C6141 sg13cmos5l_a21oi_1_4.A2 sg13cmos5l_buf_1_5.A 0.05013f
C6142 sg13cmos5l_o21ai_1_5.A1 sg13cmos5l_nand3_1_2.Y 0.1242f
C6143 a_21839_10309# a_22506_9948# 0.09257f
C6144 sg13cmos5l_nand3_1_5.Y a_7836_16362# 0.01589f
C6145 sg13cmos5l_dlygate4sd3_1_80.X sg13cmos5l_buf_1_57.A 0.38092f
C6146 sg13cmos5l_buf_1_7.X a_17412_6928# 0.27699f
C6147 sg13cmos5l_inv_1_15.A bn4 0.01973f
C6148 sg13cmos5l_buf_1_24.A a_11374_17775# 0.03906f
C6149 sg13cmos5l_mux2_1_0.S a_9260_11424# 0.15607f
C6150 sg13cmos5l_buf_1_15.A sg13cmos5l_buf_1_24.A 0.01872f
C6151 sg13cmos5l_inv_1_15.A sg13cmos5l_buf_1_66.X 0.13151f
C6152 sg13cmos5l_nand4_1_1.B bn3 0.0397f
C6153 sg13cmos5l_a21oi_1_2.B1 sg13cmos5l_dlygate4sd3_1_22.A 0.13063f
C6154 a_19430_9190# VDD 0.20776f
C6155 a_20012_14448# VDD 0.2191f
C6156 a_15760_19990# VDD 0.13527f
C6157 a_6670_18447# VDD 0.16079f
C6158 sg13cmos5l_buf_1_13.X a_19077_10677# 0.04941f
C6159 sg13cmos5l_dfrbpq_1_13.RESET_B sg13cmos5l_a21oi_1_8.Y 0.15216f
C6160 sg13cmos5l_a21oi_1_2.A2 VDD 1.4111f
C6161 sg13cmos5l_nand4_1_8.B a_16664_13730# 0.01123f
C6162 a_18374_10698# a_18660_11016# 0.26205f
C6163 sg13cmos5l_o21ai_1_5.A2 sg13cmos5l_nand3_1_2.A 0.08227f
C6164 a_16319_9456# a_16167_9404# 0.3643f
C6165 sg13cmos5l_buf_1_45.X sg13cmos5l_o21ai_1_5.A2 0.14815f
C6166 sg13cmos5l_buf_1_5.A a_18660_7992# 0.01163f
C6167 a_14761_15238# code0 0.03856f
C6168 sg13cmos5l_dlygate4sd3_1_29.X a_18382_6351# 0.11288f
C6169 sg13cmos5l_dfrbpq_1_13.RESET_B a_7068_6126# 0.30454f
C6170 sg13cmos5l_inv_1_16.Y sg13cmos5l_dlygate4sd3_1_13.X 0.08866f
C6171 sg13cmos5l_nand3b_1_1.Y sg13cmos5l_o21ai_1_14.A1 0.08469f
C6172 sg13cmos5l_nand4_1_3.B sg13cmos5l_nand2_1_18.A 0.01531f
C6173 sg13cmos5l_nand2_1_9.Y sg13cmos5l_nand2_1_12.A 0.07059f
C6174 a_7416_12404# a_8411_12252# 0.02903f
C6175 sg13cmos5l_dfrbpq_1_39.Q a_21080_17549# 0.05811f
C6176 sg13cmos5l_a21oi_1_6.A2 VDD 0.80041f
C6177 sg13cmos5l_o21ai_1_9.A2 sg13cmos5l_nor3_1_6.Y 1.45819f
C6178 sg13cmos5l_nor2b_1_1.A a_10696_15272# 0.01571f
C6179 sg13cmos5l_nand4_1_1.B sg13cmos5l_nor4_1_2.Y 0.09942f
C6180 sg13cmos5l_nand2_1_1.Y sg13cmos5l_nand3_1_1.Y 0.80685f
C6181 sg13cmos5l_inv_1_15.A VDD 1.21233f
C6182 sg13cmos5l_dfrbpq_1_39.Q bn3 0.03317f
C6183 a_15496_13760# VDD 0.20367f
C6184 sg13cmos5l_nand2b_1_1.A_N sg13cmos5l_a22oi_1_0.A2 0.01246f
C6185 sg13cmos5l_and2_1_3.X sg13cmos5l_dlygate4sd3_1_13.A 0.01604f
C6186 sg13cmos5l_dfrbpq_1_15.CLK a_6756_11464# 0.10877f
C6187 sg13cmos5l_dlygate4sd3_1_9.A sg13cmos5l_buf_1_0.A 0.18534f
C6188 sg13cmos5l_o21ai_1_11.Y a_6094_16935# 0.04471f
C6189 sg13cmos5l_a21oi_1_21.A1 VDD 0.23057f
C6190 sg13cmos5l_o21ai_1_7.Y a_7090_15230# 0.06016f
C6191 a_6968_17549# a_7238_17508# 0.18796f
C6192 sg13cmos5l_dfrbpq_1_15.CLK sg13cmos5l_dfrbpq_1_24.D 0.28922f
C6193 sg13cmos5l_nor2b_1_2.Y a_15223_7638# 0.02993f
C6194 sg13cmos5l_dfrbpq_1_15.CLK sg13cmos5l_dlygate4sd3_1_42.A 0.03699f
C6195 a_6666_14484# sg13cmos5l_and4_1_1.A 0.09576f
C6196 a_13786_7642# sg13cmos5l_dlygate4sd3_1_9.A 0.27679f
C6197 sg13cmos5l_dfrbpq_1_5.CLK sg13cmos5l_inv_1_12.A 0.65157f
C6198 sg13cmos5l_a21oi_1_18.B1 sg13cmos5l_inv_1_12.A 0.01572f
C6199 sg13cmos5l_nand2b_1_0.B a_14646_10766# 0.02511f
C6200 sg13cmos5l_dfrbpq_1_39.Q a_20974_18258# 0.01819f
C6201 sg13cmos5l_dfrbpq_1_1.D sg13cmos5l_dlygate4sd3_1_1.A 0.04232f
C6202 a_14446_9375# sg13cmos5l_nor2_1_0.Y 0.02891f
C6203 sg13cmos5l_inv_1_25.Y valid 0.02022f
C6204 a_9348_5416# clk 0.03039f
C6205 sg13cmos5l_dlygate4sd3_1_64.X sg13cmos5l_o21ai_1_7.Y 0.02419f
C6206 sg13cmos5l_inv_1_17.Y sg13cmos5l_a21oi_1_2.Y 0.4571f
C6207 sg13cmos5l_nand4_1_6.B a_12232_14484# 0.04402f
C6208 sg13cmos5l_buf_1_63.A a_12128_14570# 0.03016f
C6209 sg13cmos5l_o21ai_1_20.Y VDD 0.47672f
C6210 sg13cmos5l_dfrbpq_1_33.Q VDD 0.2728f
C6211 sg13cmos5l_a21oi_1_2.A2 bp6 0.01952f
C6212 sg13cmos5l_buf_1_20.A sg13cmos5l_inv_1_36.A 0.02765f
C6213 sg13cmos5l_o21ai_1_17.B1 a_11374_17775# 0.01516f
C6214 sg13cmos5l_nand2_1_1.A sg13cmos5l_buf_1_5.A 0.01311f
C6215 sg13cmos5l_buf_1_4.A bp1 0.12867f
C6216 sg13cmos5l_nor2b_1_0.B_N sg13cmos5l_nand2_1_0.B 0.08438f
C6217 sg13cmos5l_o21ai_1_19.Y a_7941_19031# 0.01109f
C6218 sg13cmos5l_a21oi_1_17.Y VDD 0.45577f
C6219 sg13cmos5l_a21oi_1_27.B1 sg13cmos5l_nor3_1_6.Y 0.23203f
C6220 sg13cmos5l_a21oi_1_4.A2 a_15976_12972# 0.01689f
C6221 sg13cmos5l_dlygate4sd3_1_42.X a_5124_9504# 0.0168f
C6222 sg13cmos5l_o21ai_1_28.A1 bn4 0.1564f
C6223 a_21099_6935# a_21839_7285# 0.17382f
C6224 a_14661_19749# a_14744_19061# 0.0121f
C6225 sg13cmos5l_inv_1_32.Y sg13cmos5l_inv_1_1.A 0.01565f
C6226 sg13cmos5l_buf_8_2.A sg13cmos5l_buf_1_43.X 0.08156f
C6227 sg13cmos5l_a21o_1_2.B1 a_8411_15532# 0.014f
C6228 sg13cmos5l_buf_1_0.A a_20488_3176# 0.0481f
C6229 sg13cmos5l_inv_1_17.A a_21761_15424# 0.03238f
C6230 sg13cmos5l_nand2b_1_1.A_N sg13cmos5l_nand2_1_3.Y 0.23303f
C6231 sg13cmos5l_buf_1_21.A sg13cmos5l_nand2_1_18.A 0.4393f
C6232 sg13cmos5l_dfrbpq_1_28.RESET_B a_18374_18262# 0.01532f
C6233 sg13cmos5l_o21ai_1_21.Y a_4594_17886# 0.06016f
C6234 a_21646_15423# bn6 0.04466f
C6235 sg13cmos5l_o21ai_1_5.A2 sg13cmos5l_nand3_1_2.Y 0.33781f
C6236 sg13cmos5l_a21oi_1_4.A2 sg13cmos5l_inv_1_24.A 0.06444f
C6237 sg13cmos5l_a22oi_1_0.B2 sg13cmos5l_dlygate4sd3_1_15.X 0.83715f
C6238 sg13cmos5l_a21oi_1_27.B1 sg13cmos5l_nand4_1_8.B 0.04935f
C6239 sg13cmos5l_buf_1_63.A sg13cmos5l_nand2_1_15.B 0.11284f
C6240 a_7073_19960# VDD 0.20378f
C6241 a_14244_20088# code2 0.02106f
C6242 a_7162_6888# VDD 0.27696f
C6243 sg13cmos5l_buf_1_7.X a_18671_7285# 0.13291f
C6244 sg13cmos5l_inv_1_17.Y a_19738_9912# 0.02594f
C6245 sg13cmos5l_nand4_1_15.B sg13cmos5l_dfrbpq_1_24.Q 0.02768f
C6246 sg13cmos5l_o21ai_1_26.B1 bn4 0.03822f
C6247 sg13cmos5l_nand4_1_5.D VDD 1.21432f
C6248 sg13cmos5l_nand2_1_15.B a_12616_14484# 0.03002f
C6249 sg13cmos5l_nor3_1_2.B sg13cmos5l_a21o_1_0.A2 0.40069f
C6250 sg13cmos5l_o21ai_1_28.A1 VDD 0.49761f
C6251 sg13cmos5l_buf_1_16.A bn5 0.21381f
C6252 sg13cmos5l_nand3_1_8.Y a_17608_13760# 0.0119f
C6253 a_6209_16936# a_6490_16714# 0.18796f
C6254 sg13cmos5l_a21oi_1_1.A2 VDD 1.0348f
C6255 sg13cmos5l_buf_1_63.A sg13cmos5l_inv_1_31.A 0.03262f
C6256 sg13cmos5l_and4_1_1.A sg13cmos5l_a21oi_1_27.A2 0.17699f
C6257 sg13cmos5l_nand3b_1_1.Y sg13cmos5l_o21ai_1_10.A2 0.09217f
C6258 sg13cmos5l_inv_1_1.Y a_20554_11428# 0.01448f
C6259 sg13cmos5l_buf_1_13.X a_20176_10918# 0.11435f
C6260 a_20997_4629# VDD 0.25026f
C6261 a_14218_19993# a_14244_20088# 0.24169f
C6262 sg13cmos5l_buf_1_45.X a_13958_19770# 0.07807f
C6263 a_8021_5412# VDD 0.18959f
C6264 sg13cmos5l_nor3_1_2.C a_8955_9228# 0.18767f
C6265 a_13764_16000# a_14181_16007# 0.28418f
C6266 a_13478_16434# a_14052_16421# 0.18486f
C6267 a_18756_19024# bn3 0.02184f
C6268 sg13cmos5l_or4_1_0.C a_8602_9154# 0.06243f
C6269 sg13cmos5l_o21ai_1_0.A2 a_12844_5850# 0.01169f
C6270 sg13cmos5l_nand3_1_4.Y sg13cmos5l_nand2b_1_4.B 0.10019f
C6271 sg13cmos5l_inv_1_1.Y sg13cmos5l_inv_1_16.A 0.01439f
C6272 sg13cmos5l_buf_1_0.A sg13cmos5l_buf_1_8.A 0.04028f
C6273 sg13cmos5l_buf_8_2.A sg13cmos5l_nand2_1_19.Y 0.06108f
C6274 sg13cmos5l_a21o_1_1.A2 sg13cmos5l_or4_1_0.D 0.04118f
C6275 sg13cmos5l_buf_1_1.A a_21754_5376# 0.05632f
C6276 a_17434_14448# a_17153_14750# 0.18796f
C6277 sg13cmos5l_inv_1_36.A sg13cmos5l_inv_1_18.A 0.03292f
C6278 a_7310_12400# a_7482_12214# 0.03097f
C6279 sg13cmos5l_dfrbpq_1_15.Q sg13cmos5l_nand2_1_6.A 0.03413f
C6280 sg13cmos5l_buf_1_42.A a_18670_16263# 0.02253f
C6281 sg13cmos5l_nor4_1_1.D a_10833_14874# 0.20338f
C6282 sg13cmos5l_buf_1_25.A bn2 0.15852f
C6283 sg13cmos5l_nand2_1_1.A sg13cmos5l_inv_1_12.Y 0.02862f
C6284 sg13cmos5l_nor2_1_2.B sg13cmos5l_a21oi_1_8.A2 0.45643f
C6285 sg13cmos5l_buf_1_45.X a_13764_17512# 0.31655f
C6286 a_5036_13686# sg13cmos5l_o21ai_1_9.Y 0.0242f
C6287 sg13cmos5l_dfrbpq_1_13.CLK sg13cmos5l_nand3_1_2.A 0.12607f
C6288 sg13cmos5l_dfrbpq_1_15.CLK a_8015_11821# 0.02919f
C6289 sg13cmos5l_buf_1_45.X sg13cmos5l_dfrbpq_1_13.CLK 0.05586f
C6290 sg13cmos5l_o21ai_1_26.B1 VDD 0.55491f
C6291 sg13cmos5l_and2_1_5.X sg13cmos5l_nand2_1_2.Y 0.13738f
C6292 sg13cmos5l_dfrbpq_1_5.CLK a_19530_11460# 0.02005f
C6293 a_15790_7191# a_15905_7190# 0.3854f
C6294 sg13cmos5l_inv_1_8.A sg13cmos5l_dlygate4sd3_1_9.A 0.0418f
C6295 sg13cmos5l_nor3_1_6.Y a_9765_12972# 0.03095f
C6296 sg13cmos5l_dfrbpq_1_3.D sg13cmos5l_buf_1_13.A 0.10646f
C6297 sg13cmos5l_buf_1_57.A sg13cmos5l_inv_1_24.A 0.50197f
C6298 sg13cmos5l_nor3_1_2.A sg13cmos5l_nor2_1_2.B 0.03376f
C6299 sg13cmos5l_nor3_1_2.Y sg13cmos5l_nor3_1_2.A 0.22443f
C6300 sg13cmos5l_a21oi_1_4.A2 bn0 0.01496f
C6301 sg13cmos5l_a21oi_1_1.A2 bp6 0.20499f
C6302 a_6487_6126# a_7047_6380# 0.17382f
C6303 a_12631_5376# a_12844_5850# 0.23043f
C6304 sg13cmos5l_buf_1_9.A bp4 0.10969f
C6305 a_19361_6352# a_19365_5423# 0.01248f
C6306 a_20580_14488# bn8 0.01197f
C6307 sg13cmos5l_buf_1_63.A sg13cmos5l_nand4_1_8.B 0.02219f
C6308 a_4031_15967# VDD 0.24605f
C6309 sg13cmos5l_a22oi_1_2.Y sg13cmos5l_dlygate4sd3_1_9.A 0.01866f
C6310 sg13cmos5l_dfrbpq_1_28.Q a_20294_12210# 0.02633f
C6311 sg13cmos5l_dfrbpq_1_5.CLK a_22005_18416# 0.02087f
C6312 sg13cmos5l_inv_1_12.A bn9 0.08946f
C6313 a_14244_20088# sg13cmos5l_buf_1_24.A 0.01996f
C6314 sg13cmos5l_dfrbpq_1_15.CLK sg13cmos5l_dfrbpq_1_15.Q 0.11162f
C6315 sg13cmos5l_nand2b_1_1.A_N sg13cmos5l_nor4_1_0.Y 0.109f
C6316 sg13cmos5l_buf_1_15.A sg13cmos5l_buf_1_59.A 0.0176f
C6317 sg13cmos5l_nand4_1_18.B sg13cmos5l_o21ai_1_23.B1 0.15091f
C6318 a_19169_18448# sg13cmos5l_nand4_1_17.Y 0.01386f
C6319 a_16550_19770# a_16836_20088# 0.26205f
C6320 sg13cmos5l_inv_1_1.A sg13cmos5l_inv_1_12.A 0.16276f
C6321 sg13cmos5l_dfrbpq_1_13.CLK a_10461_11730# 0.04021f
C6322 sg13cmos5l_nand4_1_12.Y sg13cmos5l_a21oi_1_24.Y 0.0263f
C6323 sg13cmos5l_nand3_1_8.Y a_17621_12972# 0.05562f
C6324 a_13786_7642# sg13cmos5l_a21oi_1_9.A1 0.01334f
C6325 sg13cmos5l_nand3b_1_3.C a_3800_19061# 0.01323f
C6326 sg13cmos5l_a21oi_1_2.B1 bp3 0.03777f
C6327 sg13cmos5l_o21ai_1_5.A1 a_10508_10662# 0.18468f
C6328 a_5216_13058# VDD 0.0869f
C6329 sg13cmos5l_buf_8_2.A sg13cmos5l_a21o_1_2.A1 0.04182f
C6330 sg13cmos5l_o21ai_1_23.B1 code0 0.01295f
C6331 sg13cmos5l_nand4_1_15.B sg13cmos5l_and2_1_3.X 0.02277f
C6332 sg13cmos5l_inv_1_17.Y sg13cmos5l_inv_1_11.Y 0.50463f
C6333 sg13cmos5l_and4_1_0.D sg13cmos5l_dfrbpq_1_13.Q 0.1519f
C6334 sg13cmos5l_a21oi_1_27.A2 a_9350_12210# 0.01664f
C6335 sg13cmos5l_a21o_1_2.B1 sg13cmos5l_a21o_1_2.A1 0.65097f
C6336 a_8218_19738# VDD 0.2762f
C6337 sg13cmos5l_o21ai_1_15.B1 a_9824_19106# 0.01241f
C6338 sg13cmos5l_mux2_1_1.A1 a_9147_13028# 0.18268f
C6339 sg13cmos5l_o21ai_1_7.Y sg13cmos5l_o21ai_1_5.A1 0.01862f
C6340 sg13cmos5l_nand2b_1_3.Y sg13cmos5l_a21oi_1_9.A2 0.2267f
C6341 sg13cmos5l_dfrbpq_1_41.CLK a_14926_16935# 0.02045f
C6342 sg13cmos5l_nand3_1_2.Y sg13cmos5l_dfrbpq_1_13.CLK 0.02047f
C6343 sg13cmos5l_mux2_1_0.S sg13cmos5l_a21oi_1_27.A1 0.14381f
C6344 sg13cmos5l_nand4_1_1.A sg13cmos5l_inv_1_12.Y 0.26924f
C6345 a_6958_16935# a_7073_16936# 0.3854f
C6346 sg13cmos5l_a21oi_1_27.B1 a_9924_12223# 0.01651f
C6347 sg13cmos5l_buf_1_24.A sg13cmos5l_buf_1_26.A 0.35011f
C6348 sg13cmos5l_o21ai_1_0.A1 sg13cmos5l_and4_1_0.D 0.15885f
C6349 sg13cmos5l_inv_1_2.A sg13cmos5l_dfrbpq_1_9.Q 0.35737f
C6350 sg13cmos5l_buf_1_13.X sg13cmos5l_dfrbpq_1_5.Q 0.02595f
C6351 sg13cmos5l_nand4_1_1.A a_15976_12972# 0.15442f
C6352 sg13cmos5l_buf_1_57.A bn0 0.02557f
C6353 sg13cmos5l_inv_1_12.Y sg13cmos5l_dfrbpq_1_11.Q 0.05079f
C6354 a_19077_10677# a_18948_10711# 0.01562f
C6355 a_13478_17946# bn0 0.05669f
C6356 a_9765_5423# VDD 0.25073f
C6357 sg13cmos5l_buf_1_15.A a_5318_13410# 0.03682f
C6358 sg13cmos5l_buf_1_16.A sg13cmos5l_buf_1_43.X 0.05513f
C6359 a_1690_9154# VDD 0.3038f
C6360 a_20974_6351# a_21089_6352# 0.3854f
C6361 sg13cmos5l_inv_1_31.A a_19450_18226# 0.0332f
C6362 sg13cmos5l_inv_1_15.A a_18374_7674# 0.01166f
C6363 sg13cmos5l_dlygate4sd3_1_76.A VDD 0.17734f
C6364 sg13cmos5l_a21oi_1_3.A2 sg13cmos5l_inv_1_3.Y 0.11937f
C6365 sg13cmos5l_dlygate4sd3_1_54.A code5 0.01905f
C6366 sg13cmos5l_nand4_1_18.B a_8830_17874# 0.04426f
C6367 sg13cmos5l_a21oi_1_4.A1 sg13cmos5l_nand2b_1_1.A_N 0.29993f
C6368 sg13cmos5l_dfrbpq_1_11.D sg13cmos5l_dfrbpq_1_9.D 0.05073f
C6369 a_9646_6351# a_9761_6352# 0.3854f
C6370 a_18682_16714# sg13cmos5l_dfrbpq_1_30.Q 0.28741f
C6371 sg13cmos5l_nand4_1_6.B sg13cmos5l_a21oi_1_4.A1 2.12003f
C6372 sg13cmos5l_a21oi_1_27.B1 sg13cmos5l_dfrbpq_1_24.Q 0.02783f
C6373 sg13cmos5l_nand3b_1_3.C valid 0.01783f
C6374 sg13cmos5l_nor4_1_1.D a_10428_14484# 0.01095f
C6375 sg13cmos5l_nand3_1_0.C a_17015_9577# 0.03695f
C6376 sg13cmos5l_dfrbpq_1_11.D sg13cmos5l_a21oi_1_3.Y 0.54693f
C6377 a_15488_12342# VDD 0.08214f
C6378 sg13cmos5l_buf_1_45.X a_15023_17869# 0.11974f
C6379 sg13cmos5l_mux2_1_0.A1 a_6394_13690# 0.01246f
C6380 sg13cmos5l_dfrbpq_1_30.D a_21084_16710# 0.01548f
C6381 a_21215_15967# a_22005_16043# 0.02241f
C6382 a_21063_16083# a_21911_16043# 0.07916f
C6383 sg13cmos5l_inv_1_3.Y a_17098_6130# 0.04157f
C6384 sg13cmos5l_dfrbpq_1_19.CLK sg13cmos5l_o21ai_1_21.Y 0.44105f
C6385 sg13cmos5l_nand3b_1_3.C a_6785_18448# 0.03193f
C6386 sg13cmos5l_a21oi_1_27.B1 sg13cmos5l_inv_1_25.Y 0.03317f
C6387 sg13cmos5l_and2_1_3.X sg13cmos5l_a21oi_1_15.A2 0.07248f
C6388 sg13cmos5l_buf_1_2.A a_20207_5773# 0.02314f
C6389 sg13cmos5l_a21oi_1_4.A1 a_13384_14484# 0.02103f
C6390 sg13cmos5l_o21ai_1_21.Y sg13cmos5l_nor2_1_7.Y 0.01862f
C6391 sg13cmos5l_nand2_1_11.B sg13cmos5l_nand4_1_3.B 0.46201f
C6392 sg13cmos5l_buf_1_66.X a_12232_14484# 0.04914f
C6393 a_13727_13992# a_13486_13722# 0.01058f
C6394 sg13cmos5l_dfrbpq_1_15.CLK a_5554_13718# 0.01146f
C6395 a_12631_5376# a_13191_5499# 0.17382f
C6396 a_22506_14484# bn8 0.01182f
C6397 a_13727_13992# a_14423_14113# 0.02431f
C6398 sg13cmos5l_a22oi_1_0.A2 VDD 0.29961f
C6399 sg13cmos5l_dlygate4sd3_1_81.X a_17038_14751# 0.10673f
C6400 sg13cmos5l_o21ai_1_26.B1 a_12118_17886# 0.02434f
C6401 a_14744_19061# bn2 0.07488f
C6402 a_4906_18988# a_4932_19024# 0.24169f
C6403 sg13cmos5l_nand4_1_7.B sg13cmos5l_buf_1_20.A 0.70868f
C6404 sg13cmos5l_o21ai_1_15.Y a_10118_18262# 0.01358f
C6405 a_12545_9376# VDD 0.21443f
C6406 sg13cmos5l_o21ai_1_26.B1 sg13cmos5l_dlygate4sd3_1_69.A 0.11901f
C6407 a_10316_12936# VDD 0.17654f
C6408 a_20294_11898# a_21099_11471# 0.07916f
C6409 a_13434_6887# sg13cmos5l_o21ai_1_0.B1 0.16576f
C6410 sg13cmos5l_a21oi_1_27.B1 sg13cmos5l_o21ai_1_21.A2 0.38155f
C6411 sg13cmos5l_nor4_1_1.D sg13cmos5l_and4_1_1.A 0.17279f
C6412 sg13cmos5l_dfrbpq_1_28.RESET_B sg13cmos5l_nand4_1_6.B 0.02591f
C6413 a_20580_8440# bp2 0.01282f
C6414 sg13cmos5l_dfrbpq_1_13.CLK sg13cmos5l_nand3_1_1.Y 0.08087f
C6415 a_12232_14484# VDD 0.18452f
C6416 sg13cmos5l_nand4_1_12.Y sg13cmos5l_a21oi_1_26.A2 0.03927f
C6417 sg13cmos5l_buf_1_20.A sg13cmos5l_nand4_1_3.B 0.13767f
C6418 sg13cmos5l_inv_1_20.Y sg13cmos5l_buf_1_10.A 0.22594f
C6419 a_7912_12972# VDD 0.18142f
C6420 a_10906_18984# a_10625_19286# 0.18796f
C6421 sg13cmos5l_inv_1_18.A sg13cmos5l_nand3_1_0.A 0.12275f
C6422 sg13cmos5l_dfrbpq_1_28.RESET_B sg13cmos5l_nand4_1_17.Y 0.04607f
C6423 sg13cmos5l_o21ai_1_25.B1 sg13cmos5l_dfrbpq_1_38.Q 0.31146f
C6424 sg13cmos5l_nand3b_1_3.C sg13cmos5l_nand4_1_15.B 0.0328f
C6425 sg13cmos5l_inv_1_4.Y a_21099_8447# 0.04025f
C6426 sg13cmos5l_a21oi_1_9.A1 a_13434_6887# 0.0706f
C6427 sg13cmos5l_inv_1_17.Y sg13cmos5l_buf_1_4.A 0.01396f
C6428 sg13cmos5l_dfrbpq_1_41.CLK bn0 0.42944f
C6429 sg13cmos5l_nor3_1_4.A a_11072_13058# 0.02106f
C6430 sg13cmos5l_dlygate4sd3_1_4.A bp7 0.02575f
C6431 a_9867_19892# sg13cmos5l_dfrbpq_1_19.CLK 0.01779f
C6432 VDD bp8 0.21945f
C6433 sg13cmos5l_nand2_1_3.Y VDD 0.66462f
C6434 sg13cmos5l_a21oi_1_7.A2 a_19048_12248# 0.04853f
C6435 sg13cmos5l_buf_1_26.A a_18104_18262# 0.08592f
C6436 sg13cmos5l_buf_1_45.X bn6 0.01532f
C6437 sg13cmos5l_nor2b_1_1.A sg13cmos5l_buf_1_57.A 0.02019f
C6438 sg13cmos5l_nand4_1_8.B sg13cmos5l_nand2_1_15.B 0.02155f
C6439 sg13cmos5l_nand4_1_1.C sg13cmos5l_a21oi_1_0.A2 0.10252f
C6440 a_13958_19770# a_14532_19783# 0.18486f
C6441 a_14763_19892# a_15760_19990# 0.03412f
C6442 sg13cmos5l_buf_8_2.A sg13cmos5l_o21ai_1_23.B1 0.07174f
C6443 a_15280_17750# code0 0.02385f
C6444 a_9350_12210# a_10155_12332# 0.07916f
C6445 a_9636_12528# a_10053_12189# 0.28324f
C6446 sg13cmos5l_a21oi_1_7.A2 sg13cmos5l_inv_1_2.A 0.01426f
C6447 sg13cmos5l_nand4_1_7.B a_17434_14448# 0.02128f
C6448 sg13cmos5l_a21o_1_0.A2 sg13cmos5l_o21ai_1_0.A2 0.03339f
C6449 sg13cmos5l_nand4_1_1.A a_18689_14750# 0.0354f
C6450 sg13cmos5l_buf_1_63.A sg13cmos5l_inv_1_25.Y 0.02428f
C6451 sg13cmos5l_buf_1_53.A bn5 0.02006f
C6452 sg13cmos5l_nand4_1_3.B sg13cmos5l_inv_1_13.Y 0.02038f
C6453 sg13cmos5l_nand2_1_6.A sg13cmos5l_nand3_1_3.Y 0.08469f
C6454 a_15023_16357# a_15690_15996# 0.09257f
C6455 sg13cmos5l_inv_1_16.Y sg13cmos5l_nor3_1_7.Y 0.01206f
C6456 sg13cmos5l_a21oi_1_2.A2 sg13cmos5l_inv_1_6.Y 0.11352f
C6457 sg13cmos5l_a21oi_1_9.B1 sg13cmos5l_nand2b_1_3.B 0.01401f
C6458 sg13cmos5l_dfrbpq_1_13.RESET_B a_6756_11464# 0.27119f
C6459 a_3500_19734# VDD 0.23324f
C6460 sg13cmos5l_buf_8_2.A a_13738_17476# 0.01514f
C6461 sg13cmos5l_a21oi_1_3.A2 sg13cmos5l_dlygate4sd3_1_13.X 0.28516f
C6462 sg13cmos5l_buf_1_20.A sg13cmos5l_buf_1_21.A 0.14664f
C6463 sg13cmos5l_dfrbpq_1_13.RESET_B sg13cmos5l_dlygate4sd3_1_42.A 0.03844f
C6464 sg13cmos5l_dlygate4sd3_1_45.X a_8118_13790# 0.11774f
C6465 sg13cmos5l_a21oi_1_9.Y a_10042_6130# 0.02005f
C6466 sg13cmos5l_nor3_1_6.Y sg13cmos5l_inv_1_9.Y 0.02154f
C6467 sg13cmos5l_nand3_1_0.B sg13cmos5l_inv_1_20.Y 0.12804f
C6468 a_17126_7362# a_17386_6892# 0.45119f
C6469 sg13cmos5l_dfrbpq_1_5.CLK sg13cmos5l_dfrbpq_1_28.Q 0.03355f
C6470 sg13cmos5l_a21oi_1_6.A2 a_19738_9912# 0.06287f
C6471 bp6 bp8 0.13904f
C6472 sg13cmos5l_dfrbpq_1_3.D a_17109_9344# 0.02228f
C6473 sg13cmos5l_nor3_1_2.A sg13cmos5l_nand4_1_0.C 0.35668f
C6474 sg13cmos5l_nand4_1_18.D sg13cmos5l_inv_1_12.A 0.01825f
C6475 sg13cmos5l_o21ai_1_14.Y a_8444_17064# 0.01087f
C6476 a_13042_4646# VDD 0.01926f
C6477 sg13cmos5l_buf_1_9.A sg13cmos5l_nand3_1_0.A 0.01832f
C6478 sg13cmos5l_buf_8_2.A sg13cmos5l_a21oi_1_19.A2 0.0118f
C6479 sg13cmos5l_o21ai_1_1.B1 a_14534_10702# 0.01907f
C6480 sg13cmos5l_nand2_1_1.A sg13cmos5l_dlygate4sd3_1_18.A 0.32472f
C6481 sg13cmos5l_nand4_1_7.B a_15280_16238# 0.01081f
C6482 a_16673_11726# sg13cmos5l_nand3_1_1.Y 0.01091f
C6483 sg13cmos5l_buf_1_13.A sg13cmos5l_dlygate4sd3_1_7.X 0.08261f
C6484 a_19048_3900# bp9 0.15674f
C6485 a_4932_19024# a_6191_19381# 0.01412f
C6486 sg13cmos5l_inv_1_17.A a_22096_12430# 0.0224f
C6487 a_12814_13239# VDD 0.16303f
C6488 sg13cmos5l_and2_1_3.X a_16085_12508# 0.06588f
C6489 a_22096_7166# bp1 0.0258f
C6490 sg13cmos5l_o21ai_1_8.B1 sg13cmos5l_a21oi_1_12.Y 0.25732f
C6491 a_12040_15272# bn4 0.06211f
C6492 sg13cmos5l_dlygate4sd3_1_43.X a_6766_7191# 0.12581f
C6493 a_20868_11885# a_21099_11471# 0.07823f
C6494 a_20554_12433# a_20294_12210# 0.45119f
C6495 a_20580_11464# a_21745_11821# 0.25046f
C6496 sg13cmos5l_a21oi_1_18.B1 sg13cmos5l_nand4_1_18.C 0.03969f
C6497 a_5643_9308# sg13cmos5l_nor3_1_2.Y 0.04089f
C6498 a_6383_9263# a_6640_9406# 0.23043f
C6499 sg13cmos5l_buf_8_2.A a_7334_14484# 0.01013f
C6500 a_19169_18448# VDD 0.20108f
C6501 sg13cmos5l_nand2_1_0.A sg13cmos5l_dlygate4sd3_1_15.X 0.34151f
C6502 a_9185_18448# a_9466_18226# 0.18796f
C6503 sg13cmos5l_a21oi_1_1.A2 sg13cmos5l_a21oi_1_2.Y 0.02687f
C6504 sg13cmos5l_o21ai_1_10.A2 sg13cmos5l_o21ai_1_10.B1 0.21067f
C6505 sg13cmos5l_nand4_1_18.B sg13cmos5l_inv_1_12.A 0.23251f
C6506 sg13cmos5l_a21o_1_2.B1 a_7334_14484# 0.01438f
C6507 sg13cmos5l_buf_1_42.A bn6 0.03106f
C6508 sg13cmos5l_inv_1_1.Y a_20716_16434# 0.01277f
C6509 sg13cmos5l_buf_1_14.A sg13cmos5l_a22oi_1_0.B2 0.0137f
C6510 sg13cmos5l_nor4_1_0.Y VDD 0.76053f
C6511 sg13cmos5l_nand3_1_6.C bn4 0.08345f
C6512 a_15041_16936# bn2 0.01467f
C6513 sg13cmos5l_buf_1_8.A sg13cmos5l_inv_1_0.A 0.02028f
C6514 sg13cmos5l_buf_1_2.A a_20398_4167# 0.03773f
C6515 sg13cmos5l_nand2b_1_1.A_N sg13cmos5l_a22oi_1_1.B2 0.01412f
C6516 sg13cmos5l_buf_1_1.A sg13cmos5l_dfrbpq_1_28.Q 0.04926f
C6517 sg13cmos5l_dlygate4sd3_1_50.X a_5782_15230# 0.02441f
C6518 sg13cmos5l_dfrbpq_1_13.CLK a_10508_10662# 0.04788f
C6519 a_21473_5678# bp2 0.0445f
C6520 sg13cmos5l_buf_1_10.A sg13cmos5l_nand2_1_0.B 0.02113f
C6521 sg13cmos5l_inv_1_17.Y sg13cmos5l_inv_1_2.A 0.15539f
C6522 sg13cmos5l_a21oi_1_24.A2 sg13cmos5l_nand4_1_5.D 0.03566f
C6523 sg13cmos5l_o21ai_1_21.B1 sg13cmos5l_o21ai_1_20.A1 0.02483f
C6524 a_12040_15272# VDD 0.1796f
C6525 sg13cmos5l_buf_1_5.A bp9 0.3079f
C6526 sg13cmos5l_mux2_1_1.A1 a_8848_12214# 0.01726f
C6527 sg13cmos5l_o21ai_1_5.A1 sg13cmos5l_and4_1_1.A 0.03376f
C6528 sg13cmos5l_inv_1_32.Y sg13cmos5l_buf_8_2.A 0.02809f
C6529 sg13cmos5l_dfrbpq_1_24.Q a_12128_14570# 0.01818f
C6530 sg13cmos5l_mux2_1_0.S a_8337_13362# 0.05029f
C6531 sg13cmos5l_dfrbpq_1_37.D a_21462_17532# 0.01103f
C6532 sg13cmos5l_a21oi_1_10.A2 sg13cmos5l_nand2b_1_3.B 0.01087f
C6533 sg13cmos5l_buf_1_65.A sg13cmos5l_nand4_1_15.B 1.20731f
C6534 a_4838_15238# a_4950_15302# 0.3854f
C6535 sg13cmos5l_a21oi_1_1.A2 sg13cmos5l_inv_1_6.Y 0.2117f
C6536 sg13cmos5l_a21oi_1_2.A2 sg13cmos5l_inv_1_11.Y 0.01716f
C6537 sg13cmos5l_buf_1_66.X sg13cmos5l_a21oi_1_4.A1 0.95231f
C6538 sg13cmos5l_nand4_1_3.D bn5 0.04911f
C6539 sg13cmos5l_nand4_1_18.B sg13cmos5l_nand2_1_13.A 0.05588f
C6540 sg13cmos5l_a21oi_1_27.B1 sg13cmos5l_nand3b_1_3.C 0.1543f
C6541 sg13cmos5l_nand4_1_1.A a_16190_13730# 0.01832f
C6542 a_5541_9165# VDD 0.24537f
C6543 sg13cmos5l_buf_1_43.X sg13cmos5l_buf_1_53.A 0.01806f
C6544 a_20580_11464# VDD 0.0721f
C6545 a_17355_19892# VDD 0.20448f
C6546 a_21646_15423# a_21761_15424# 0.3854f
C6547 sg13cmos5l_nand3_1_6.C VDD 0.28562f
C6548 sg13cmos5l_buf_1_7.X sg13cmos5l_dfrbpq_1_1.D 0.34081f
C6549 sg13cmos5l_dfrbpq_1_13.RESET_B a_8015_11821# 0.11137f
C6550 sg13cmos5l_nor2_1_2.Y a_8296_4782# 0.0336f
C6551 sg13cmos5l_nor3_1_2.B a_10917_9959# 0.01762f
C6552 sg13cmos5l_buf_8_2.A a_15280_17750# 0.0105f
C6553 sg13cmos5l_a21oi_1_6.A2 sg13cmos5l_inv_1_11.Y 0.12009f
C6554 sg13cmos5l_inv_1_15.Y sg13cmos5l_dfrbpq_1_11.D 0.011f
C6555 sg13cmos5l_nor2b_1_1.A sg13cmos5l_or4_1_1.X 0.11265f
C6556 sg13cmos5l_mux2_1_0.A1 a_9446_13726# 0.01105f
C6557 sg13cmos5l_nand3_1_2.A sg13cmos5l_o21ai_1_1.B1 0.37714f
C6558 a_1294_15423# sg13cmos5l_buf_1_29.A 0.10701f
C6559 sg13cmos5l_dfrbpq_1_5.CLK sg13cmos5l_inv_1_17.A 1.32135f
C6560 sg13cmos5l_a21oi_1_1.A2 a_18662_5850# 0.01427f
C6561 sg13cmos5l_dfrbpq_1_24.RESET_B a_4740_14488# 0.30208f
C6562 sg13cmos5l_buf_1_1.A sg13cmos5l_buf_1_0.A 0.12946f
C6563 sg13cmos5l_a21oi_1_18.B1 sg13cmos5l_inv_1_17.A 0.02655f
C6564 a_16469_14484# VDD 0.16091f
C6565 sg13cmos5l_o21ai_1_20.B1 sg13cmos5l_o21ai_1_19.Y 0.01225f
C6566 sg13cmos5l_a21oi_1_4.A1 VDD 1.79984f
C6567 sg13cmos5l_dfrbpq_1_37.D a_21911_18649# 0.01427f
C6568 sg13cmos5l_nor4_1_2.Y sg13cmos5l_inv_1_24.A 0.04349f
C6569 sg13cmos5l_dfrbpq_1_13.RESET_B sg13cmos5l_dfrbpq_1_15.Q 0.09058f
C6570 sg13cmos5l_dfrbpq_1_28.RESET_B bn4 2.06367f
C6571 a_1690_15202# VDD 0.3038f
C6572 sg13cmos5l_dfrbpq_1_28.Q bn9 0.03202f
C6573 sg13cmos5l_buf_1_16.A sg13cmos5l_o21ai_1_23.B1 0.01929f
C6574 sg13cmos5l_a21oi_1_19.Y sg13cmos5l_nor4_1_2.Y 0.07994f
C6575 a_6191_19381# a_6858_19020# 0.09257f
C6576 a_21911_16043# VDD 0.52273f
C6577 a_10694_18258# a_11397_18237# 0.02453f
C6578 sg13cmos5l_buf_1_16.A a_17733_8447# 0.03171f
C6579 sg13cmos5l_o21ai_1_7.A2 a_7498_18226# 0.02907f
C6580 a_21839_11821# a_21745_11821# 0.16704f
C6581 sg13cmos5l_inv_1_8.A a_14698_6385# 0.0232f
C6582 a_10268_17064# VDD 0.01828f
C6583 sg13cmos5l_inv_1_31.A sg13cmos5l_inv_1_25.Y 0.0566f
C6584 sg13cmos5l_o21ai_1_18.B1 VDD 0.38508f
C6585 sg13cmos5l_dfrbpq_1_15.CLK a_7162_6888# 0.02146f
C6586 sg13cmos5l_dfrbpq_1_19.CLK a_7498_18988# 0.01027f
C6587 a_21084_16357# a_21063_16083# 0.20773f
C6588 a_13015_13686# a_13228_13722# 0.23043f
C6589 sg13cmos5l_buf_1_63.A a_12902_17508# 0.02279f
C6590 a_12134_19458# a_12837_19031# 0.02431f
C6591 a_5998_17775# a_6113_17774# 0.3854f
C6592 sg13cmos5l_a21oi_1_18.B1 sg13cmos5l_a21oi_1_20.Y 0.2186f
C6593 sg13cmos5l_buf_1_15.A sg13cmos5l_nand2b_1_1.A_N 0.01061f
C6594 sg13cmos5l_buf_1_63.A sg13cmos5l_nand3b_1_3.C 0.01382f
C6595 sg13cmos5l_dfrbpq_1_28.RESET_B VDD 8.2534f
C6596 a_17002_15457# a_17028_15552# 0.24169f
C6597 valid bn2 0.19565f
C6598 sg13cmos5l_nor3_1_6.Y sg13cmos5l_dfrbpq_1_24.Q 0.22339f
C6599 sg13cmos5l_inv_1_1.A sg13cmos5l_nand4_1_18.C 0.02112f
C6600 sg13cmos5l_a21oi_1_4.A2 sg13cmos5l_nand3_1_0.B 0.12278f
C6601 bn4 bn1 0.01313f
C6602 sg13cmos5l_dlygate4sd3_1_81.X a_16742_15234# 0.16859f
C6603 bn3 bn0 0.02088f
C6604 sg13cmos5l_buf_1_15.A sg13cmos5l_nand4_1_6.B 0.44608f
C6605 sg13cmos5l_a21oi_1_24.A1 code1 0.01983f
C6606 sg13cmos5l_buf_1_15.A a_21063_16083# 0.28507f
C6607 sg13cmos5l_buf_1_15.A a_13676_12936# 0.18467f
C6608 sg13cmos5l_buf_1_0.A bn9 0.03459f
C6609 sg13cmos5l_mux2_1_1.A1 VDD 1.00809f
C6610 sg13cmos5l_a21oi_1_7.A2 a_19830_12278# 0.01199f
C6611 sg13cmos5l_nand2_1_18.A sg13cmos5l_nor2_1_3.Y 0.05906f
C6612 sg13cmos5l_buf_1_16.A sg13cmos5l_a21oi_1_19.A2 0.01273f
C6613 sg13cmos5l_a21oi_1_5.A2 a_19733_6924# 0.06387f
C6614 sg13cmos5l_buf_1_66.X a_7432_15366# 0.0408f
C6615 sg13cmos5l_inv_1_17.A sg13cmos5l_buf_1_1.A 2.01045f
C6616 sg13cmos5l_buf_8_2.A a_22049_10888# 0.02952f
C6617 sg13cmos5l_buf_1_66.X bn1 0.20449f
C6618 sg13cmos5l_nand3_1_2.Y sg13cmos5l_o21ai_1_1.B1 0.13763f
C6619 sg13cmos5l_dfrbpq_1_13.Q a_11393_6352# 0.05114f
C6620 sg13cmos5l_a21oi_1_5.A2 sg13cmos5l_dlygate4sd3_1_29.A 0.12588f
C6621 sg13cmos5l_buf_1_15.A sg13cmos5l_nand4_1_17.Y 0.01897f
C6622 sg13cmos5l_buf_1_26.A a_18374_18262# 0.03529f
C6623 sg13cmos5l_inv_1_1.A sg13cmos5l_buf_1_0.A 0.04125f
C6624 a_10895_12287# a_11152_12430# 0.23043f
C6625 sg13cmos5l_buf_1_1.A a_21745_7285# 0.01248f
C6626 sg13cmos5l_a21oi_1_1.A2 sg13cmos5l_inv_1_11.Y 0.07125f
C6627 sg13cmos5l_nand4_1_16.D sg13cmos5l_a21oi_1_20.A2 0.2166f
C6628 sg13cmos5l_inv_1_1.Y bp5 0.02525f
C6629 sg13cmos5l_a21o_1_0.A1 a_11840_9389# 0.07497f
C6630 sg13cmos5l_dfrbpq_1_13.Q a_11278_6351# 0.01464f
C6631 sg13cmos5l_and4_1_0.D sg13cmos5l_nand2b_1_3.Y 0.05666f
C6632 sg13cmos5l_mux2_1_0.S a_11670_14484# 0.01582f
C6633 a_9558_13790# sg13cmos5l_nand2_1_13.A 0.10659f
C6634 a_12131_5412# VDD 0.01438f
C6635 sg13cmos5l_a21oi_1_2.A2 a_18123_11471# 0.0545f
C6636 sg13cmos5l_o21ai_1_5.A1 clk 0.09444f
C6637 sg13cmos5l_nor4_1_2.Y bn0 0.01827f
C6638 sg13cmos5l_a21oi_1_5.A2 sg13cmos5l_buf_1_13.X 0.02982f
C6639 sg13cmos5l_buf_8_2.A sg13cmos5l_inv_1_12.A 0.50426f
C6640 sg13cmos5l_a21oi_1_2.A2 sg13cmos5l_buf_1_4.A 0.02877f
C6641 sg13cmos5l_inv_1_4.Y a_16631_8065# 0.01291f
C6642 a_21839_11821# VDD 0.17125f
C6643 a_7507_9380# VDD 0.25648f
C6644 sg13cmos5l_dlygate4sd3_1_18.A a_17604_11464# 0.04083f
C6645 a_10872_11016# sg13cmos5l_a21o_1_0.A2 0.01087f
C6646 sg13cmos5l_a21oi_1_26.A2 sg13cmos5l_buf_1_42.A 0.15043f
C6647 a_5345_19960# a_5349_19031# 0.01248f
C6648 sg13cmos5l_o21ai_1_11.A2 a_6524_15552# 0.01294f
C6649 a_7432_15366# VDD 0.12551f
C6650 a_21089_19960# a_21370_19738# 0.18796f
C6651 sg13cmos5l_buf_1_43.X sg13cmos5l_nand4_1_3.D 0.37725f
C6652 VDD bn1 1.04099f
C6653 sg13cmos5l_nor4_1_2.Y a_18689_14750# 0.05064f
C6654 sg13cmos5l_nand3_1_0.B a_16586_7832# 0.01556f
C6655 sg13cmos5l_a21oi_1_13.Y sg13cmos5l_nand3_1_8.Y 0.01942f
C6656 sg13cmos5l_nand4_1_1.B sg13cmos5l_a21oi_1_0.A2 0.01503f
C6657 sg13cmos5l_o21ai_1_28.Y a_13400_15238# 0.27688f
C6658 sg13cmos5l_dfrbpq_1_13.CLK a_9867_5423# 0.0199f
C6659 a_17829_6935# a_18577_7285# 0.01058f
C6660 sg13cmos5l_nand2_1_12.A a_13409_16936# 0.01213f
C6661 sg13cmos5l_inv_1_1.Y a_20554_14452# 0.01794f
C6662 sg13cmos5l_a21oi_1_1.A2 a_19236_5837# 0.01086f
C6663 a_20384_16921# a_20716_16746# 0.07015f
C6664 sg13cmos5l_nand4_1_7.B a_17028_15552# 0.04123f
C6665 sg13cmos5l_nand2_1_2.Y a_16342_10694# 0.07922f
C6666 a_8122_10666# sg13cmos5l_dlygate4sd3_1_37.A 0.33695f
C6667 sg13cmos5l_o21ai_1_7.Y sg13cmos5l_o21ai_1_7.A2 0.62506f
C6668 sg13cmos5l_a21oi_1_27.B1 sg13cmos5l_buf_1_65.A 1.23436f
C6669 sg13cmos5l_dfrbpq_1_5.CLK bp0 0.03945f
C6670 a_14133_5459# a_14039_5459# 0.45119f
C6671 sg13cmos5l_o21ai_1_21.A2 sg13cmos5l_nand4_1_8.B 0.10696f
C6672 sg13cmos5l_buf_1_0.A sg13cmos5l_buf_1_2.A 0.28372f
C6673 sg13cmos5l_inv_1_15.A a_21084_18222# 0.0153f
C6674 sg13cmos5l_inv_1_17.A bn9 0.07398f
C6675 a_18286_16935# a_18401_16936# 0.3854f
C6676 sg13cmos5l_dlygate4sd3_1_50.X sg13cmos5l_nand3b_1_3.C 0.03408f
C6677 sg13cmos5l_buf_1_63.A a_14661_19749# 0.01726f
C6678 sg13cmos5l_o21ai_1_5.A2 sg13cmos5l_and2_1_6.A 0.02595f
C6679 sg13cmos5l_buf_8_2.A sg13cmos5l_nand2_1_13.A 0.05077f
C6680 a_11499_18380# a_12239_18335# 0.17382f
C6681 sg13cmos5l_buf_1_16.A a_19242_8436# 0.02073f
C6682 a_11180_15198# sg13cmos5l_dfrbpq_1_18.Q 0.18691f
C6683 sg13cmos5l_a21oi_1_2.Y bp8 0.04781f
C6684 a_20580_12528# a_21745_12287# 0.25046f
C6685 a_21099_12332# a_20868_12223# 0.07823f
C6686 a_21839_12287# a_22096_12430# 0.23043f
C6687 sg13cmos5l_dfrbpq_1_15.Q a_8520_8436# 0.2177f
C6688 sg13cmos5l_o21ai_1_5.A2 a_13768_14484# 0.01119f
C6689 a_13096_15996# sg13cmos5l_buf_1_20.A 0.1844f
C6690 sg13cmos5l_o21ai_1_1.B1 sg13cmos5l_nand3_1_1.Y 0.13269f
C6691 sg13cmos5l_o21ai_1_7.B1 sg13cmos5l_dfrbpq_1_19.D 0.10163f
C6692 sg13cmos5l_dfrbpq_1_19.CLK a_9040_19262# 0.01123f
C6693 sg13cmos5l_nor2_1_0.Y a_14668_8436# 0.01408f
C6694 sg13cmos5l_nor3_1_6.Y sg13cmos5l_and2_1_3.X 0.02421f
C6695 sg13cmos5l_nor2b_1_1.A bn3 0.11f
C6696 a_12837_19031# a_12708_19445# 0.01562f
C6697 sg13cmos5l_inv_1_36.A a_6113_13912# 0.01037f
C6698 a_12420_19024# a_12939_19031# 0.20754f
C6699 sg13cmos5l_nand2b_1_0.B a_14446_9375# 0.01678f
C6700 sg13cmos5l_o21ai_1_14.Y sg13cmos5l_nand3b_1_1.Y 0.3727f
C6701 sg13cmos5l_inv_1_17.Y a_19830_12278# 0.01024f
C6702 sg13cmos5l_nor2b_1_2.Y sg13cmos5l_o21ai_1_0.B1 0.02654f
C6703 sg13cmos5l_buf_1_2.A a_20104_3176# 0.19068f
C6704 sg13cmos5l_buf_1_10.A sg13cmos5l_dfrbpq_1_11.Q 0.01821f
C6705 a_4740_14488# a_5999_14845# 0.01412f
C6706 sg13cmos5l_dlygate4sd3_1_74.A a_20494_15423# 0.01804f
C6707 a_18670_16263# a_18785_16262# 0.3854f
C6708 sg13cmos5l_dfrbpq_1_47.D a_14438_6162# 0.04015f
C6709 sg13cmos5l_nand2b_1_1.A_N sg13cmos5l_a21oi_1_9.A2 0.81417f
C6710 sg13cmos5l_nand3_1_0.A a_15480_8752# 0.01832f
C6711 sg13cmos5l_dfrbpq_1_13.Q sg13cmos5l_o21ai_1_4.Y 0.05401f
C6712 sg13cmos5l_nand4_1_8.B sg13cmos5l_and2_1_3.X 0.29779f
C6713 sg13cmos5l_o21ai_1_5.A1 a_10304_10830# 0.01467f
C6714 sg13cmos5l_buf_1_17.X a_1409_9376# 0.05006f
C6715 sg13cmos5l_buf_1_47.X a_10230_18326# 0.0248f
C6716 sg13cmos5l_dfrbpq_1_34.Q bn3 0.0892f
C6717 a_16070_5850# VDD 0.52448f
C6718 sg13cmos5l_o21ai_1_10.Y sg13cmos5l_o21ai_1_10.B1 0.21685f
C6719 sg13cmos5l_inv_1_6.Y bp8 0.03738f
C6720 sg13cmos5l_buf_1_1.A bp0 0.03191f
C6721 sg13cmos5l_nand2b_1_0.B sg13cmos5l_o21ai_1_0.A2 0.0708f
C6722 sg13cmos5l_inv_1_1.A sg13cmos5l_a21oi_1_20.Y 0.56414f
C6723 sg13cmos5l_buf_1_7.X a_19995_9190# 0.07543f
C6724 sg13cmos5l_nor3_1_4.A VDD 0.99598f
C6725 sg13cmos5l_nor2b_1_2.Y sg13cmos5l_a21oi_1_9.A1 0.1222f
C6726 sg13cmos5l_buf_1_5.A a_19336_3176# 0.19269f
C6727 sg13cmos5l_a21oi_1_1.A2 sg13cmos5l_buf_1_4.A 0.014f
C6728 sg13cmos5l_o21ai_1_5.A2 clk 0.08741f
C6729 sg13cmos5l_inv_1_1.A sg13cmos5l_dlygate4sd3_1_25.A 0.027f
C6730 sg13cmos5l_buf_1_7.X a_19649_4840# 0.01602f
C6731 sg13cmos5l_a22oi_1_1.B2 VDD 0.4072f
C6732 sg13cmos5l_o21ai_1_0.A1 sg13cmos5l_o21ai_1_4.Y 0.02046f
C6733 sg13cmos5l_a21oi_1_7.A2 sg13cmos5l_nor3_1_7.Y 0.03782f
C6734 sg13cmos5l_o21ai_1_19.Y sg13cmos5l_dfrbpq_1_24.RESET_B 0.08109f
C6735 sg13cmos5l_a21oi_1_7.A2 a_21366_10766# 0.02264f
C6736 sg13cmos5l_buf_1_47.X a_10066_19398# 0.05708f
C6737 sg13cmos5l_nand2b_1_1.A_N sg13cmos5l_nor2_1_2.A 0.73583f
C6738 sg13cmos5l_nand3_1_0.A sg13cmos5l_o21ai_1_0.A1 0.30965f
C6739 sg13cmos5l_inv_1_13.Y sg13cmos5l_a21oi_1_5.A2 0.12972f
C6740 sg13cmos5l_o21ai_1_14.A1 sg13cmos5l_nand4_1_15.B 0.01501f
C6741 sg13cmos5l_a21oi_1_4.A2 a_14920_14484# 0.01139f
C6742 sg13cmos5l_a21oi_1_7.A2 a_20984_10702# 0.02783f
C6743 sg13cmos5l_a21oi_1_18.B1 sg13cmos5l_nand4_1_16.D 0.39043f
C6744 sg13cmos5l_a21oi_1_5.A2 sg13cmos5l_dlygate4sd3_1_18.X 0.02803f
C6745 a_21838_19959# a_21953_19960# 0.3854f
C6746 sg13cmos5l_dfrbpq_1_24.RESET_B a_3628_16746# 0.09643f
C6747 sg13cmos5l_a21oi_1_3.A2 sg13cmos5l_nor3_1_7.Y 0.01323f
C6748 a_16070_5850# a_16330_5380# 0.45119f
C6749 sg13cmos5l_dlygate4sd3_1_58.X sg13cmos5l_buf_1_24.A 0.02265f
C6750 sg13cmos5l_o21ai_1_28.B1 a_12886_15230# 0.0634f
C6751 sg13cmos5l_or2_1_1.X sg13cmos5l_and4_1_0.D 0.07278f
C6752 sg13cmos5l_dfrbpq_1_13.RESET_B sg13cmos5l_nand3_1_3.Y 0.02032f
C6753 sg13cmos5l_a21o_1_0.X a_10330_9154# 0.08184f
C6754 sg13cmos5l_nand4_1_0.C sg13cmos5l_nor4_1_0.C 0.10564f
C6755 a_20974_6351# sg13cmos5l_buf_1_8.A 0.10701f
C6756 sg13cmos5l_dlygate4sd3_1_4.A a_20580_4968# 0.0137f
C6757 sg13cmos5l_buf_1_13.X a_17015_9577# 0.01976f
C6758 sg13cmos5l_nor3_1_2.B a_8955_9228# 0.12253f
C6759 sg13cmos5l_a21oi_1_3.A2 sg13cmos5l_a21oi_1_16.A2 0.0237f
C6760 sg13cmos5l_nand2_1_3.Y sg13cmos5l_nand2_1_6.A 0.18213f
C6761 sg13cmos5l_o21ai_1_23.A2 sg13cmos5l_o21ai_1_28.Y 0.08558f
C6762 sg13cmos5l_o21ai_1_28.B1 a_12984_15552# 0.01214f
C6763 a_6524_15552# VDD 0.01784f
C6764 sg13cmos5l_inv_1_17.A a_22005_16904# 0.03276f
C6765 a_20494_15423# sg13cmos5l_dfrbpq_1_29.D 0.10673f
C6766 sg13cmos5l_buf_1_54.A sg13cmos5l_nand4_1_6.B 0.03504f
C6767 sg13cmos5l_dfrbpq_1_41.CLK a_17051_15996# 0.01007f
C6768 a_7498_18988# a_7524_19024# 0.24169f
C6769 sg13cmos5l_nand4_1_0.C sg13cmos5l_nor2_1_2.B 0.11214f
C6770 sg13cmos5l_nand4_1_18.D sg13cmos5l_nand4_1_18.C 0.47156f
C6771 sg13cmos5l_nand2_1_1.Y sg13cmos5l_inv_1_20.Y 0.12775f
C6772 bp0 bn9 0.12294f
C6773 a_9934_9375# clk 0.05646f
C6774 sg13cmos5l_nand4_1_17.Y a_18470_17946# 0.01915f
C6775 sg13cmos5l_buf_1_5.A a_16342_10694# 0.03253f
C6776 sg13cmos5l_inv_1_9.Y sg13cmos5l_inv_1_5.A 0.06585f
C6777 sg13cmos5l_nand3_1_0.B a_16568_9989# 0.06717f
C6778 sg13cmos5l_buf_1_16.A sg13cmos5l_inv_1_12.A 0.06642f
C6779 sg13cmos5l_nand2_1_1.A sg13cmos5l_inv_1_16.A 0.12706f
C6780 a_10592_4782# VDD 0.09916f
C6781 sg13cmos5l_inv_1_1.A bp0 0.02092f
C6782 sg13cmos5l_inv_1_9.Y a_16184_8477# 0.01001f
C6783 sg13cmos5l_buf_1_14.A sg13cmos5l_nand2_1_0.A 0.7264f
C6784 sg13cmos5l_dfrbpq_1_15.CLK sg13cmos5l_nand2_1_3.Y 0.74689f
C6785 sg13cmos5l_dfrbpq_1_19.CLK a_4476_18222# 0.06947f
C6786 sg13cmos5l_nor3_1_2.A sg13cmos5l_dfrbpq_1_17.Q 0.34446f
C6787 sg13cmos5l_buf_1_15.A sg13cmos5l_buf_1_66.X 0.02992f
C6788 a_12939_19031# a_13679_19381# 0.17382f
C6789 a_21084_16357# VDD 0.0721f
C6790 a_5230_19959# a_5345_19960# 0.3854f
C6791 sg13cmos5l_nand4_1_18.B sg13cmos5l_nand4_1_18.C 0.19048f
C6792 a_17445_15213# a_17547_15356# 0.36168f
C6793 a_8540_17488# VDD 0.01784f
C6794 sg13cmos5l_nor2_1_12.Y sg13cmos5l_o21ai_1_5.A1 0.07339f
C6795 sg13cmos5l_buf_1_6.A bp9 0.07387f
C6796 sg13cmos5l_a21o_1_2.A1 a_8192_15366# 0.02185f
C6797 a_11756_19734# sg13cmos5l_o21ai_1_13.B1 0.19692f
C6798 sg13cmos5l_nand3b_1_3.C sg13cmos5l_nand4_1_8.B 0.07956f
C6799 sg13cmos5l_a21oi_1_7.A2 a_21099_12332# 0.01851f
C6800 sg13cmos5l_nor3_1_0.Y sg13cmos5l_inv_1_18.A 0.0794f
C6801 sg13cmos5l_nand3b_1_3.C a_15358_14850# 0.04952f
C6802 sg13cmos5l_o21ai_1_7.Y sg13cmos5l_nand3_1_5.Y 0.02913f
C6803 a_11374_17775# VDD 0.15979f
C6804 sg13cmos5l_buf_1_10.A sg13cmos5l_dfrbpq_1_3.D 0.02536f
C6805 sg13cmos5l_buf_1_45.X a_14181_16007# 0.04153f
C6806 a_15784_15272# VDD 0.18067f
C6807 sg13cmos5l_nand4_1_18.A a_18206_12218# 0.01831f
C6808 a_16875_5423# VDD 0.20472f
C6809 sg13cmos5l_o21ai_1_21.A2 sg13cmos5l_inv_1_25.Y 0.03152f
C6810 a_12987_12214# sg13cmos5l_nand2_1_19.Y 0.02233f
C6811 sg13cmos5l_nor2_1_10.Y sg13cmos5l_dlygate4sd3_1_56.X 0.06543f
C6812 sg13cmos5l_buf_1_25.A sg13cmos5l_nand4_1_1.B 0.01728f
C6813 sg13cmos5l_nand3_1_8.Y a_21099_13844# 0.01656f
C6814 sg13cmos5l_buf_1_1.A a_21839_12287# 0.01839f
C6815 sg13cmos5l_nand4_1_15.B sg13cmos5l_o21ai_1_10.A2 0.10026f
C6816 sg13cmos5l_buf_1_15.A VDD 4.1797f
C6817 a_20384_16283# a_20503_15960# 0.09257f
C6818 sg13cmos5l_buf_1_26.A sg13cmos5l_nand4_1_17.Y 0.20221f
C6819 sg13cmos5l_a21oi_1_5.A2 sg13cmos5l_buf_1_9.A 0.02027f
C6820 sg13cmos5l_dfrbpq_1_28.RESET_B a_19930_15960# 0.02945f
C6821 sg13cmos5l_buf_1_15.A a_10864_19990# 0.09962f
C6822 sg13cmos5l_a21oi_1_1.A2 sg13cmos5l_inv_1_2.A 0.36081f
C6823 sg13cmos5l_inv_1_2.A a_20997_4629# 0.23195f
C6824 a_22234_19738# sg13cmos5l_dfrbpq_1_5.CLK 0.01797f
C6825 a_16356_5416# a_16644_5837# 0.24435f
C6826 sg13cmos5l_nor3_1_6.Y a_4454_14922# 0.0415f
C6827 sg13cmos5l_a21oi_1_5.A2 a_17412_6928# 0.01123f
C6828 sg13cmos5l_nor4_1_0.Y sg13cmos5l_nand2_1_6.A 0.1606f
C6829 sg13cmos5l_dfrbpq_1_13.CLK clk 0.09343f
C6830 sg13cmos5l_dlygate4sd3_1_4.A sg13cmos5l_inv_1_7.A 0.01144f
C6831 sg13cmos5l_a21oi_1_0.A2 sg13cmos5l_buf_1_13.A 0.04237f
C6832 sg13cmos5l_dfrbpq_1_39.Q sg13cmos5l_buf_1_25.A 0.07137f
C6833 sg13cmos5l_nand4_1_1.A sg13cmos5l_inv_1_16.A 0.39971f
C6834 sg13cmos5l_a21oi_1_4.A2 sg13cmos5l_inv_1_36.Y 0.06006f
C6835 sg13cmos5l_o21ai_1_0.A2 sg13cmos5l_nand2b_1_3.B 0.01531f
C6836 sg13cmos5l_buf_1_25.A sg13cmos5l_o21ai_1_28.Y 0.01065f
C6837 sg13cmos5l_inv_1_1.Y bn6 0.02102f
C6838 sg13cmos5l_nand4_1_1.A a_18970_14448# 0.012f
C6839 sg13cmos5l_buf_1_63.A bn2 0.37563f
C6840 sg13cmos5l_inv_1_1.A sg13cmos5l_nand4_1_16.D 0.01719f
C6841 sg13cmos5l_o21ai_1_5.A1 a_6760_15366# 0.03755f
C6842 sg13cmos5l_buf_1_57.A sg13cmos5l_nor4_1_1.D 0.04417f
C6843 sg13cmos5l_inv_1_15.Y sg13cmos5l_nand2_1_13.Y 0.02514f
C6844 sg13cmos5l_a21oi_1_27.B1 sg13cmos5l_o21ai_1_14.A1 0.24835f
C6845 a_17338_18984# sg13cmos5l_dlygate4sd3_1_82.A 0.28704f
C6846 sg13cmos5l_buf_1_13.A sg13cmos5l_inv_1_14.Y 0.01339f
C6847 a_7941_19031# a_8043_19031# 0.3643f
C6848 sg13cmos5l_dfrbpq_1_18.Q sg13cmos5l_mux2_1_0.S 0.0805f
C6849 a_20554_8404# VDD 0.09599f
C6850 a_13304_18262# sg13cmos5l_dfrbpq_1_48.Q 0.31953f
C6851 a_12616_14484# bn2 0.06235f
C6852 sg13cmos5l_nand3_1_0.B sg13cmos5l_and2_1_5.X 0.14182f
C6853 sg13cmos5l_inv_1_32.Y sg13cmos5l_buf_1_53.A 0.08604f
C6854 sg13cmos5l_buf_1_3.A VDD 0.73027f
C6855 sg13cmos5l_a21oi_1_2.B1 a_17733_8447# 0.02957f
C6856 a_19630_15423# a_19745_15424# 0.3854f
C6857 a_13764_16000# code0 0.01275f
C6858 sg13cmos5l_buf_1_30.A a_1192_19020# 0.19688f
C6859 a_16319_9456# VDD 0.24555f
C6860 sg13cmos5l_dfrbpq_1_28.RESET_B a_18730_17476# 0.1719f
C6861 sg13cmos5l_o21ai_1_7.B1 a_6209_16936# 0.01468f
C6862 sg13cmos5l_and4_1_1.A sg13cmos5l_mux2_1_0.A1 0.76357f
C6863 sg13cmos5l_inv_1_7.A bp9 0.02961f
C6864 sg13cmos5l_buf_1_24.A sg13cmos5l_o21ai_1_17.Y 0.01623f
C6865 a_20398_13239# bn8 0.0338f
C6866 sg13cmos5l_dfrbpq_1_5.CLK a_21646_15423# 0.04043f
C6867 sg13cmos5l_inv_1_1.Y sg13cmos5l_dlygate4sd3_1_2.A 0.0218f
C6868 sg13cmos5l_nand4_1_17.Y a_19829_18556# 0.05797f
C6869 sg13cmos5l_nor2_1_15.Y a_12458_15996# 0.01382f
C6870 a_17547_15356# a_18287_15311# 0.17382f
C6871 sg13cmos5l_nand2_1_12.Y sg13cmos5l_o21ai_1_5.A1 0.02955f
C6872 a_20580_6928# bp2 0.01341f
C6873 sg13cmos5l_dlygate4sd3_1_50.X a_3296_16921# 0.0457f
C6874 sg13cmos5l_buf_1_4.A bp8 1.28877f
C6875 sg13cmos5l_a21oi_1_7.A2 a_20868_12223# 0.0165f
C6876 a_14724_6480# a_15243_6284# 0.20773f
C6877 sg13cmos5l_o21ai_1_20.B1 a_4114_17886# 0.04425f
C6878 sg13cmos5l_dlygate4sd3_1_1.A VDD 0.38103f
C6879 sg13cmos5l_buf_1_65.A sg13cmos5l_nor3_1_6.Y 0.20345f
C6880 sg13cmos5l_dfrbpq_1_15.CLK a_5541_9165# 0.22858f
C6881 sg13cmos5l_o21ai_1_10.A2 sg13cmos5l_o21ai_1_9.A2 0.14702f
C6882 a_1192_19020# VDD 0.18156f
C6883 a_3800_19061# a_4070_19020# 0.18796f
C6884 sg13cmos5l_a22oi_1_0.B2 sg13cmos5l_a21oi_1_4.B1 0.05534f
C6885 sg13cmos5l_a21oi_1_12.A2 a_9716_15202# 0.15152f
C6886 sg13cmos5l_buf_1_47.X a_11499_18380# 0.02748f
C6887 a_19066_15960# VDD 0.26196f
C6888 a_18470_19458# a_19275_19031# 0.07916f
C6889 sg13cmos5l_inv_1_12.Y a_17621_12972# 0.03272f
C6890 sg13cmos5l_buf_8_2.A sg13cmos5l_dfrbpq_1_28.Q 0.02123f
C6891 sg13cmos5l_a21oi_1_4.A2 sg13cmos5l_nand2_1_1.Y 0.05963f
C6892 code2 busy 0.08277f
C6893 a_19173_17519# bn5 0.01186f
C6894 sg13cmos5l_nand4_1_1.B a_17820_16754# 0.0114f
C6895 sg13cmos5l_nand4_1_18.B sg13cmos5l_inv_1_8.A 0.13965f
C6896 sg13cmos5l_nand2_1_13.A sg13cmos5l_buf_1_22.A 0.02025f
C6897 sg13cmos5l_dfrbpq_1_47.Q a_12430_6980# 0.02636f
C6898 sg13cmos5l_o21ai_1_7.B1 sg13cmos5l_o21ai_1_21.Y 0.01556f
C6899 sg13cmos5l_buf_1_2.A sg13cmos5l_inv_1_0.A 0.04132f
C6900 sg13cmos5l_a21oi_1_9.A2 VDD 0.95095f
C6901 sg13cmos5l_o21ai_1_6.Y VDD 0.30275f
C6902 sg13cmos5l_a21oi_1_6.Y sg13cmos5l_dlygate4sd3_1_16.A 0.07769f
C6903 sg13cmos5l_o21ai_1_18.B1 a_9734_17508# 0.01169f
C6904 a_11770_17472# a_11489_17774# 0.18796f
C6905 sg13cmos5l_buf_1_25.A a_18756_19024# 0.01965f
C6906 sg13cmos5l_buf_1_65.A sg13cmos5l_nand4_1_8.B 0.37609f
C6907 sg13cmos5l_dfrbpq_1_47.Q a_12344_6166# 0.32528f
C6908 sg13cmos5l_a21oi_1_4.A1 sg13cmos5l_dfrbpq_1_15.CLK 0.02212f
C6909 sg13cmos5l_o21ai_1_5.A1 sg13cmos5l_a21oi_1_4.A2 0.15271f
C6910 sg13cmos5l_dfrbpq_1_25.Q a_6858_19020# 0.07846f
C6911 a_16875_5423# a_17615_5773# 0.17382f
C6912 a_14218_19993# busy 0.03216f
C6913 sg13cmos5l_a21oi_1_5.A2 a_18671_7285# 0.01459f
C6914 sg13cmos5l_nand4_1_18.A sg13cmos5l_inv_1_13.Y 0.26865f
C6915 sg13cmos5l_a21oi_1_0.A2 sg13cmos5l_a21oi_1_0.Y 0.15337f
C6916 sg13cmos5l_nand4_1_18.D bp0 0.01442f
C6917 sg13cmos5l_nor2_1_2.A VDD 0.99688f
C6918 sg13cmos5l_dfrbpq_1_5.CLK a_21084_16710# 0.05213f
C6919 sg13cmos5l_a21oi_1_27.B1 sg13cmos5l_o21ai_1_10.A2 0.22038f
C6920 sg13cmos5l_o21ai_1_20.A1 sg13cmos5l_buf_1_66.X 2.28594f
C6921 a_20294_8874# a_20554_8404# 0.45119f
C6922 sg13cmos5l_nand4_1_12.Y sg13cmos5l_a21oi_1_18.B1 0.02122f
C6923 sg13cmos5l_a21oi_1_0.A2 a_18497_6352# 0.0452f
C6924 sg13cmos5l_a21o_1_0.A2 a_10500_9952# 0.01806f
C6925 sg13cmos5l_a21oi_1_2.B1 sg13cmos5l_dfrbpq_1_8.D 0.48975f
C6926 a_21466_7642# VDD 0.26724f
C6927 sg13cmos5l_dlygate4sd3_1_1.A bp6 0.0182f
C6928 a_20580_14488# VDD 0.07291f
C6929 sg13cmos5l_a21oi_1_0.A2 sg13cmos5l_buf_1_5.A 0.36063f
C6930 a_21646_15423# sg13cmos5l_buf_1_1.A 0.11201f
C6931 sg13cmos5l_o21ai_1_17.B1 sg13cmos5l_o21ai_1_17.Y 0.21157f
C6932 sg13cmos5l_dlygate4sd3_1_82.A sg13cmos5l_nand4_1_12.Y 0.09715f
C6933 sg13cmos5l_buf_8_2.A sg13cmos5l_buf_1_0.A 0.02227f
C6934 a_21215_17016# a_21063_16964# 0.3643f
C6935 sg13cmos5l_inv_1_14.Y sg13cmos5l_a21oi_1_0.Y 0.39976f
C6936 a_9040_19262# a_8783_19381# 0.23043f
C6937 sg13cmos5l_or4_1_0.C a_10771_9380# 0.01613f
C6938 sg13cmos5l_nand3b_1_3.C sg13cmos5l_inv_1_25.Y 0.04129f
C6939 sg13cmos5l_nand4_1_1.B sg13cmos5l_dfrbpq_1_28.D 0.04998f
C6940 a_22096_8678# VDD 0.13569f
C6941 sg13cmos5l_buf_1_10.A bp9 0.01869f
C6942 a_16078_19287# a_16193_19286# 0.3854f
C6943 sg13cmos5l_buf_1_20.A sg13cmos5l_a21oi_1_27.A1 0.15076f
C6944 sg13cmos5l_a21oi_1_27.B1 a_9610_12433# 0.03065f
C6945 sg13cmos5l_buf_1_25.A sg13cmos5l_dfrbpq_1_44.Q 0.02114f
C6946 a_3776_18433# a_3895_18222# 0.09257f
C6947 a_6730_11428# a_7173_11471# 0.02241f
C6948 a_18470_17946# VDD 0.52387f
C6949 a_16078_19287# sg13cmos5l_a21oi_1_26.Y 0.02892f
C6950 sg13cmos5l_inv_1_24.Y bn5 0.01289f
C6951 sg13cmos5l_buf_1_5.A sg13cmos5l_inv_1_14.Y 0.02019f
C6952 sg13cmos5l_o21ai_1_20.A1 VDD 0.88841f
C6953 a_18634_7897# VDD 0.09605f
C6954 sg13cmos5l_a21oi_1_18.B1 sg13cmos5l_dlygate4sd3_1_76.X 0.06526f
C6955 a_14244_20088# VDD 0.07265f
C6956 sg13cmos5l_buf_1_54.A VDD 0.38932f
C6957 a_15023_16357# code0 0.03978f
C6958 sg13cmos5l_inv_1_15.Y sg13cmos5l_nand4_1_6.B 0.08119f
C6959 a_15405_11808# a_15208_11546# 0.01796f
C6960 sg13cmos5l_nand2_1_9.Y sg13cmos5l_a21oi_1_12.Y 0.27552f
C6961 sg13cmos5l_nand4_1_18.B bp0 0.07986f
C6962 sg13cmos5l_buf_1_26.A bn4 0.4625f
C6963 a_19246_19959# sg13cmos5l_dfrbpq_1_35.D 0.10701f
C6964 sg13cmos5l_dlygate4sd3_1_80.X sg13cmos5l_o21ai_1_23.A2 0.02248f
C6965 sg13cmos5l_buf_1_24.A busy 0.02489f
C6966 a_15494_18258# code1 0.03616f
C6967 sg13cmos5l_a21oi_1_24.A1 a_15494_18258# 0.01456f
C6968 sg13cmos5l_nand4_1_15.B sg13cmos5l_nand3_1_8.Y 0.03453f
C6969 sg13cmos5l_buf_1_24.A sg13cmos5l_nand4_1_7.B 0.04694f
C6970 sg13cmos5l_nor3_1_2.C a_6286_8703# 0.02086f
C6971 sg13cmos5l_dfrbpq_1_13.RESET_B a_9765_5423# 0.03634f
C6972 sg13cmos5l_nand3b_1_3.C sg13cmos5l_o21ai_1_21.A2 0.05473f
C6973 a_18874_9912# VDD 0.25982f
C6974 sg13cmos5l_dfrbpq_1_9.D VDD 0.3258f
C6975 sg13cmos5l_inv_1_9.Y a_16091_9948# 0.03316f
C6976 sg13cmos5l_nand2_1_1.A sg13cmos5l_nand2_1_1.Y 0.12199f
C6977 a_20580_12528# bn8 0.01348f
C6978 sg13cmos5l_dfrbpq_1_33.D code2 0.01549f
C6979 sg13cmos5l_buf_1_13.A a_15243_6284# 0.34023f
C6980 sg13cmos5l_nand2_1_15.B bn2 0.10042f
C6981 sg13cmos5l_nand2_1_18.A sg13cmos5l_nand2_1_19.A 0.0857f
C6982 sg13cmos5l_o21ai_1_5.A1 sg13cmos5l_buf_1_57.A 0.03619f
C6983 a_14181_17519# VDD 0.24133f
C6984 a_18287_15311# a_18544_15454# 0.23043f
C6985 sg13cmos5l_a21oi_1_3.Y VDD 0.21346f
C6986 sg13cmos5l_nand4_1_15.B sg13cmos5l_nand4_1_1.C 0.45346f
C6987 a_21099_6935# bp2 0.05442f
C6988 sg13cmos5l_dfrbpq_1_13.CLK sg13cmos5l_inv_1_20.Y 0.16981f
C6989 a_22522_6130# bp5 0.06072f
C6990 sg13cmos5l_a21oi_1_2.B1 a_18948_5416# 0.02489f
C6991 sg13cmos5l_a21oi_1_12.A2 a_8411_15532# 0.05834f
C6992 a_19044_19445# a_19275_19031# 0.07823f
C6993 a_18756_19024# a_19921_19381# 0.25046f
C6994 sg13cmos5l_nand4_1_18.A a_19240_13058# 0.01937f
C6995 sg13cmos5l_dlygate4sd3_1_97.X a_13478_17946# 0.17935f
C6996 sg13cmos5l_buf_1_66.X sg13cmos5l_o21ai_1_9.B1 0.07717f
C6997 sg13cmos5l_inv_1_2.A bp8 0.13807f
C6998 sg13cmos5l_dfrbpq_1_28.RESET_B sg13cmos5l_dlygate4sd3_1_98.A 0.18411f
C6999 sg13cmos5l_buf_8_2.A sg13cmos5l_inv_1_17.A 0.30941f
C7000 sg13cmos5l_o21ai_1_20.Y a_3592_19106# 0.04642f
C7001 sg13cmos5l_nand2b_1_1.A_N sg13cmos5l_and4_1_0.D 0.04948f
C7002 sg13cmos5l_buf_1_26.A VDD 0.7883f
C7003 sg13cmos5l_o21ai_1_7.B1 a_5998_17775# 0.05861f
C7004 sg13cmos5l_buf_1_47.X a_14038_16742# 0.06394f
C7005 sg13cmos5l_nor2_1_15.Y busy 0.01449f
C7006 sg13cmos5l_inv_1_12.Y sg13cmos5l_a21oi_1_0.A2 0.05125f
C7007 a_9928_10034# VDD 0.13427f
C7008 sg13cmos5l_o21ai_1_21.B1 sg13cmos5l_dfrbpq_1_23.Q 0.01457f
C7009 sg13cmos5l_nor2_1_10.Y a_10172_19000# 0.01141f
C7010 sg13cmos5l_o21ai_1_5.A2 sg13cmos5l_a21oi_1_4.A2 0.03767f
C7011 sg13cmos5l_nor2_1_15.Y sg13cmos5l_nand4_1_7.B 0.11021f
C7012 sg13cmos5l_o21ai_1_0.Y a_12040_6294# 0.01716f
C7013 sg13cmos5l_inv_1_17.Y sg13cmos5l_dfrbpq_1_9.Q 0.19402f
C7014 sg13cmos5l_buf_8_2.A sg13cmos5l_o21ai_1_21.Y 0.02145f
C7015 sg13cmos5l_buf_1_21.A a_13208_11501# 0.01236f
C7016 sg13cmos5l_a21o_1_0.X VDD 0.43244f
C7017 sg13cmos5l_buf_1_45.X a_18095_19847# 0.10868f
C7018 a_9846_17532# VDD 0.16053f
C7019 a_8122_10666# VDD 0.25813f
C7020 sg13cmos5l_nand2b_1_4.Y VDD 0.31839f
C7021 sg13cmos5l_o21ai_1_9.B1 VDD 0.59231f
C7022 sg13cmos5l_o21ai_1_0.A1 sg13cmos5l_o21ai_1_4.A1 0.02335f
C7023 sg13cmos5l_a21oi_1_2.A2 sg13cmos5l_nor3_1_7.Y 0.0155f
C7024 sg13cmos5l_buf_1_1.A sg13cmos5l_dfrbpq_1_6.D 0.32972f
C7025 sg13cmos5l_o21ai_1_17.B1 a_10954_18481# 0.0264f
C7026 sg13cmos5l_o21ai_1_20.B1 a_6448_19262# 0.01277f
C7027 sg13cmos5l_dfrbpq_1_38.Q bn5 0.11215f
C7028 sg13cmos5l_dfrbpq_1_5.CLK a_21911_17137# 0.01377f
C7029 sg13cmos5l_nand2_1_13.A a_9636_12528# 0.01072f
C7030 a_20554_8404# a_20997_8447# 0.02241f
C7031 a_7594_9916# VDD 0.09681f
C7032 sg13cmos5l_a21o_1_0.A2 a_11019_9959# 0.05498f
C7033 sg13cmos5l_nand2_1_15.B a_12381_13912# 0.20602f
C7034 sg13cmos5l_nand4_1_1.C sg13cmos5l_a21oi_1_15.A2 0.21176f
C7035 a_22506_14484# VDD 0.27461f
C7036 sg13cmos5l_o21ai_1_17.B1 a_12134_19458# 0.04419f
C7037 sg13cmos5l_nand4_1_18.C sg13cmos5l_a21oi_1_15.Y 0.02021f
C7038 sg13cmos5l_a21oi_1_6.A2 sg13cmos5l_nor3_1_7.Y 1.60063f
C7039 sg13cmos5l_buf_8_2.A sg13cmos5l_inv_1_8.A 0.01536f
C7040 a_3208_10034# VDD 0.14731f
C7041 sg13cmos5l_buf_8_2.A sg13cmos5l_a21oi_1_20.Y 0.02085f
C7042 sg13cmos5l_o21ai_1_7.B1 a_6191_19381# 0.01029f
C7043 a_9450_19020# sg13cmos5l_dlygate4sd3_1_65.A 0.09558f
C7044 sg13cmos5l_nand4_1_18.B sg13cmos5l_nand4_1_16.D 0.02469f
C7045 a_20974_19959# sg13cmos5l_dfrbpq_1_39.Q 0.05081f
C7046 sg13cmos5l_nor4_1_2.Y sg13cmos5l_inv_1_16.A 0.02086f
C7047 sg13cmos5l_buf_8_2.A sg13cmos5l_dlygate4sd3_1_25.A 0.07607f
C7048 sg13cmos5l_inv_1_15.A sg13cmos5l_nor3_1_7.Y 0.01281f
C7049 sg13cmos5l_nand4_1_8.B bn2 0.02706f
C7050 sg13cmos5l_buf_1_10.A a_21640_3900# 0.18289f
C7051 sg13cmos5l_dlygate4sd3_1_18.A a_18634_10921# 0.03056f
C7052 a_3895_18222# a_4476_18222# 0.01412f
C7053 a_4607_18528# a_4455_18476# 0.3643f
C7054 sg13cmos5l_inv_1_16.Y sg13cmos5l_a21oi_1_2.A2 0.13532f
C7055 sg13cmos5l_nand4_1_1.B a_15041_16936# 0.01156f
C7056 a_6756_11464# a_8015_11821# 0.01412f
C7057 sg13cmos5l_a21oi_1_10.A1 sg13cmos5l_a21oi_1_9.Y 0.06906f
C7058 a_17243_17508# VDD 0.16149f
C7059 sg13cmos5l_inv_1_24.Y sg13cmos5l_dfrbpq_1_18.Q 0.01888f
C7060 sg13cmos5l_nor4_1_2.Y a_18970_14448# 0.02007f
C7061 sg13cmos5l_dfrbpq_1_13.RESET_B sg13cmos5l_nand2_1_3.Y 0.20666f
C7062 sg13cmos5l_a21o_1_2.X VDD 0.40909f
C7063 sg13cmos5l_a22oi_1_1.B2 sg13cmos5l_nand2_1_6.A 0.16404f
C7064 sg13cmos5l_nand4_1_3.B a_13596_13686# 0.01615f
C7065 sg13cmos5l_buf_1_65.A sg13cmos5l_dfrbpq_1_24.Q 0.47749f
C7066 sg13cmos5l_nand4_1_16.D code0 0.08859f
C7067 sg13cmos5l_o21ai_1_13.B1 code5 0.13469f
C7068 sg13cmos5l_inv_1_16.Y sg13cmos5l_a21oi_1_6.A2 0.01492f
C7069 a_12406_15230# valid 0.03467f
C7070 sg13cmos5l_inv_1_12.A sg13cmos5l_a21oi_1_2.B1 0.03546f
C7071 sg13cmos5l_nor2_1_2.B sg13cmos5l_dlygate4sd3_1_43.A 0.30472f
C7072 a_17318_11898# VDD 0.52387f
C7073 sg13cmos5l_inv_1_20.Y a_16673_11726# 0.0244f
C7074 sg13cmos5l_buf_1_43.X sg13cmos5l_inv_1_24.Y 0.30092f
C7075 sg13cmos5l_a21oi_1_24.A1 a_17296_18478# 0.03358f
C7076 sg13cmos5l_buf_1_16.A sg13cmos5l_nand4_1_18.C 0.03442f
C7077 sg13cmos5l_buf_1_65.A sg13cmos5l_inv_1_25.Y 0.1703f
C7078 a_18286_16935# sg13cmos5l_inv_1_1.A 0.10671f
C7079 sg13cmos5l_inv_1_15.A sg13cmos5l_inv_1_16.Y 0.01785f
C7080 sg13cmos5l_dfrbpq_1_19.CLK a_7498_18226# 0.67478f
C7081 sg13cmos5l_or4_1_0.C clk 0.12813f
C7082 a_5312_13854# sg13cmos5l_o21ai_1_9.Y 0.01139f
C7083 sg13cmos5l_nand3_1_5.Y a_8338_16742# 0.06988f
C7084 sg13cmos5l_dfrbpq_1_44.Q a_14744_19061# 0.31667f
C7085 sg13cmos5l_buf_8_2.A a_7354_16714# 0.01126f
C7086 sg13cmos5l_inv_1_5.A a_16184_8477# 0.06479f
C7087 sg13cmos5l_o21ai_1_25.Y sg13cmos5l_nand4_1_1.B 0.04109f
C7088 sg13cmos5l_o21ai_1_25.B1 a_14038_16742# 0.02919f
C7089 sg13cmos5l_dlygate4sd3_1_50.A a_4568_15238# 0.29231f
C7090 sg13cmos5l_o21ai_1_5.A2 sg13cmos5l_buf_1_57.A 0.09378f
C7091 sg13cmos5l_buf_1_16.A a_18374_10698# 0.02232f
C7092 a_15935_7944# VDD 0.24699f
C7093 sg13cmos5l_dlygate4sd3_1_42.A sg13cmos5l_dfrbpq_1_15.Q 0.04248f
C7094 sg13cmos5l_a21oi_1_4.A1 sg13cmos5l_dlygate4sd3_1_14.A 0.07629f
C7095 a_15690_17508# VDD 0.27503f
C7096 sg13cmos5l_dfrbpq_1_0.D VDD 0.27393f
C7097 sg13cmos5l_dfrbpq_1_17.Q sg13cmos5l_nor2_1_2.B 0.38917f
C7098 sg13cmos5l_buf_1_42.A sg13cmos5l_dlygate4sd3_1_74.A 0.27717f
C7099 sg13cmos5l_nand4_1_3.B a_8898_14020# 0.01276f
C7100 a_19829_18556# VDD 0.17005f
C7101 sg13cmos5l_buf_1_16.A sg13cmos5l_buf_1_0.A 0.01806f
C7102 a_16838_9948# VDD 0.20192f
C7103 sg13cmos5l_a21oi_1_17.Y sg13cmos5l_a21oi_1_16.A2 0.32794f
C7104 sg13cmos5l_a21oi_1_2.B1 a_20207_5773# 0.02225f
C7105 a_20015_19381# a_19921_19381# 0.16704f
C7106 a_15329_10214# VDD 0.20829f
C7107 sg13cmos5l_a21oi_1_8.Y a_8021_5412# 0.10092f
C7108 sg13cmos5l_dfrbpq_1_28.RESET_B a_21084_18222# 0.27749f
C7109 sg13cmos5l_o21ai_1_21.A2 sg13cmos5l_buf_1_65.A 0.12994f
C7110 a_12597_11722# a_12656_11826# 0.01251f
C7111 a_12420_19024# bn0 0.04477f
C7112 sg13cmos5l_buf_1_45.X sg13cmos5l_a21oi_1_18.B1 0.03913f
C7113 sg13cmos5l_a21oi_1_17.Y sg13cmos5l_inv_1_16.Y 0.32465f
C7114 sg13cmos5l_dfrbpq_1_5.CLK a_22426_18984# 0.06449f
C7115 sg13cmos5l_buf_8_2.A bp0 0.04406f
C7116 a_10245_14020# VDD 0.0138f
C7117 sg13cmos5l_dfrbpq_1_13.CLK sg13cmos5l_nand2_1_0.B 0.04094f
C7118 a_12426_9948# VDD 0.27855f
C7119 sg13cmos5l_inv_1_20.Y a_11759_10309# 0.01f
C7120 a_18670_16263# sg13cmos5l_buf_1_57.A 0.10678f
C7121 sg13cmos5l_inv_1_8.A sg13cmos5l_nor3_1_2.B 0.69487f
C7122 sg13cmos5l_buf_1_21.A a_13596_13686# 0.05194f
C7123 sg13cmos5l_or4_1_1.X sg13cmos5l_o21ai_1_5.A1 0.04544f
C7124 a_5626_19738# code6 0.01272f
C7125 sg13cmos5l_inv_1_17.Y sg13cmos5l_a21oi_1_7.A2 0.02978f
C7126 a_15760_19990# code1 0.02839f
C7127 sg13cmos5l_o21ai_1_10.Y sg13cmos5l_o21ai_1_9.A2 0.01017f
C7128 a_8671_7996# VDD 0.20251f
C7129 sg13cmos5l_nand2b_1_1.A_N sg13cmos5l_inv_1_19.Y 0.04217f
C7130 sg13cmos5l_dlygate4sd3_1_24.A a_22522_6130# 0.29529f
C7131 sg13cmos5l_buf_1_9.A sg13cmos5l_dlygate4sd3_1_22.A 0.01751f
C7132 sg13cmos5l_nor3_1_2.B sg13cmos5l_a22oi_1_2.Y 0.0159f
C7133 sg13cmos5l_nand2_1_13.A a_10895_12287# 0.01396f
C7134 a_20580_8440# a_21839_8797# 0.01412f
C7135 sg13cmos5l_buf_1_59.A busy 0.03211f
C7136 sg13cmos5l_buf_1_26.A sg13cmos5l_dlygate4sd3_1_69.A 0.3561f
C7137 a_9136_10190# VDD 0.1414f
C7138 sg13cmos5l_nand3_1_0.A sg13cmos5l_or2_1_1.X 0.39146f
C7139 a_19077_7653# a_19179_7796# 0.36168f
C7140 sg13cmos5l_buf_1_59.A sg13cmos5l_nand4_1_7.B 0.0208f
C7141 sg13cmos5l_a21oi_1_4.A2 sg13cmos5l_dfrbpq_1_13.CLK 0.03158f
C7142 sg13cmos5l_o21ai_1_17.B1 a_12708_19445# 0.01726f
C7143 a_22241_17774# VDD 0.20201f
C7144 a_17608_13760# a_17984_13854# 0.01689f
C7145 sg13cmos5l_or4_1_1.X a_10774_17886# 0.04953f
C7146 sg13cmos5l_buf_1_42.A sg13cmos5l_dfrbpq_1_29.D 0.08947f
C7147 a_21215_17016# a_20974_16746# 0.01058f
C7148 sg13cmos5l_nand2_1_9.Y sg13cmos5l_o21ai_1_28.A1 0.26422f
C7149 a_21063_16964# a_21866_16904# 0.07823f
C7150 a_21084_16710# a_22005_16904# 0.24169f
C7151 sg13cmos5l_buf_1_20.A a_11278_13239# 0.0763f
C7152 a_18634_7897# a_18374_7674# 0.45119f
C7153 a_5829_7653# VDD 0.27119f
C7154 a_21063_18476# bn4 0.01159f
C7155 sg13cmos5l_a21oi_1_21.A1 code1 0.01858f
C7156 a_4476_18222# a_5303_18649# 0.26205f
C7157 a_17710_17775# a_17825_17774# 0.3854f
C7158 a_19242_8436# a_19624_8522# 0.01648f
C7159 sg13cmos5l_o21ai_1_7.Y sg13cmos5l_dfrbpq_1_19.CLK 0.03534f
C7160 a_8272_11702# a_8682_11460# 0.07015f
C7161 sg13cmos5l_nand4_1_1.B valid 0.0231f
C7162 sg13cmos5l_nand3_1_0.Y a_16668_7290# 0.01437f
C7163 sg13cmos5l_a21oi_1_6.Y VDD 0.30629f
C7164 sg13cmos5l_o21ai_1_7.Y sg13cmos5l_nor2_1_7.Y 0.11806f
C7165 sg13cmos5l_inv_1_5.A sg13cmos5l_dlygate4sd3_1_29.X 0.32881f
C7166 a_18106_17472# sg13cmos5l_o21ai_1_23.B1 0.29573f
C7167 sg13cmos5l_buf_1_20.A a_11372_10662# 0.19269f
C7168 sg13cmos5l_o21ai_1_12.Y sg13cmos5l_nor2_1_6.Y 0.01632f
C7169 sg13cmos5l_a21oi_1_2.Y sg13cmos5l_dlygate4sd3_1_1.A 0.33237f
C7170 sg13cmos5l_dfrbpq_1_24.D a_5554_13718# 0.03365f
C7171 sg13cmos5l_dfrbpq_1_24.RESET_B a_5222_17508# 0.06849f
C7172 sg13cmos5l_inv_1_6.Y sg13cmos5l_buf_1_3.A 0.06492f
C7173 sg13cmos5l_dfrbpq_1_40.Q sg13cmos5l_buf_1_24.A 0.11255f
C7174 a_21370_6130# VDD 0.26044f
C7175 sg13cmos5l_buf_1_13.A a_15820_9186# 0.09623f
C7176 sg13cmos5l_o21ai_1_9.Y a_6394_13690# 0.28367f
C7177 sg13cmos5l_nand2_1_1.Y sg13cmos5l_and2_1_5.X 0.1187f
C7178 a_17030_8874# a_17604_8861# 0.18486f
C7179 sg13cmos5l_inv_1_36.A sg13cmos5l_nand3b_1_0.C 0.02765f
C7180 a_17316_8440# a_17733_8447# 0.28418f
C7181 a_19361_6352# a_19642_6130# 0.18796f
C7182 sg13cmos5l_dfrbpq_1_40.Q a_19361_19960# 0.01275f
C7183 sg13cmos5l_buf_1_15.A sg13cmos5l_dlygate4sd3_1_33.X 0.04783f
C7184 sg13cmos5l_a21oi_1_3.Y a_17621_7972# 0.10322f
C7185 a_16725_7832# VDD 0.09577f
C7186 sg13cmos5l_buf_1_15.A sg13cmos5l_dfrbpq_1_15.CLK 0.20129f
C7187 a_19457_10214# VDD 0.20809f
C7188 sg13cmos5l_dfrbpq_1_13.RESET_B a_5541_9165# 0.04992f
C7189 sg13cmos5l_inv_1_15.Y VDD 0.51199f
C7190 sg13cmos5l_nand3b_1_1.Y sg13cmos5l_nor2b_1_1.A 0.06252f
C7191 sg13cmos5l_a21oi_1_18.B1 sg13cmos5l_buf_1_42.A 0.22331f
C7192 sg13cmos5l_buf_8_2.A sg13cmos5l_nand4_1_16.D 0.02003f
C7193 sg13cmos5l_dfrbpq_1_14.D a_7334_10386# 0.17282f
C7194 a_21063_18476# VDD 0.20567f
C7195 sg13cmos5l_o21ai_1_23.A2 bn0 0.01822f
C7196 a_16566_8460# sg13cmos5l_dfrbpq_1_9.D 0.10642f
C7197 a_18382_6351# a_18497_6352# 0.3854f
C7198 a_13304_18262# bn0 0.05791f
C7199 a_14842_11424# a_14561_11726# 0.18796f
C7200 sg13cmos5l_nor2b_1_0.B_N a_15488_9361# 0.09336f
C7201 sg13cmos5l_dlygate4sd3_1_16.A bp4 0.02542f
C7202 sg13cmos5l_buf_1_15.A sg13cmos5l_inv_1_11.Y 0.02737f
C7203 sg13cmos5l_dfrbpq_1_24.RESET_B a_6448_19262# 0.10764f
C7204 a_14534_10702# a_14646_10766# 0.3854f
C7205 sg13cmos5l_inv_1_25.Y bn2 0.03323f
C7206 a_20554_13945# a_20294_13722# 0.45119f
C7207 a_13478_17946# a_13764_17512# 0.26205f
C7208 sg13cmos5l_a21oi_1_27.B1 sg13cmos5l_o21ai_1_15.B1 0.01676f
C7209 sg13cmos5l_a21o_1_2.A1 sg13cmos5l_dlygate4sd3_1_45.X 0.01815f
C7210 sg13cmos5l_dlygate4sd3_1_1.A sg13cmos5l_inv_1_6.Y 0.01599f
C7211 a_1409_9376# rst_n 0.01501f
C7212 a_21466_7642# sg13cmos5l_a21oi_1_2.Y 0.27488f
C7213 sg13cmos5l_buf_8_2.A a_21839_12287# 0.02408f
C7214 sg13cmos5l_a21oi_1_26.A1 sg13cmos5l_a21oi_1_19.Y 0.1224f
C7215 sg13cmos5l_nand4_1_5.D code1 0.14841f
C7216 sg13cmos5l_nand4_1_15.B sg13cmos5l_nand4_1_1.B 0.02307f
C7217 sg13cmos5l_o21ai_1_10.A2 sg13cmos5l_nand4_1_8.B 0.01841f
C7218 sg13cmos5l_o21ai_1_7.B1 a_5626_19738# 0.06334f
C7219 a_15214_10215# VDD 0.16005f
C7220 sg13cmos5l_dlygate4sd3_1_76.A a_21160_12972# 0.0185f
C7221 sg13cmos5l_nand2_1_1.A sg13cmos5l_dfrbpq_1_13.CLK 0.05115f
C7222 sg13cmos5l_buf_1_25.A sg13cmos5l_a21oi_1_19.Y 0.53257f
C7223 sg13cmos5l_inv_1_17.A a_21839_10309# 0.01287f
C7224 sg13cmos5l_a21oi_1_15.Y bp0 0.28485f
C7225 sg13cmos5l_and4_1_0.D VDD 0.68517f
C7226 sg13cmos5l_buf_1_45.X sg13cmos5l_inv_1_1.A 0.02527f
C7227 sg13cmos5l_dlygate4sd3_1_1.A a_18662_5850# 0.04407f
C7228 a_22096_8678# a_22506_8436# 0.07015f
C7229 sg13cmos5l_a21oi_1_0.A2 sg13cmos5l_dlygate4sd3_1_18.A 0.68226f
C7230 sg13cmos5l_nand2_1_13.A a_12987_12214# 0.02136f
C7231 sg13cmos5l_buf_1_15.A sg13cmos5l_o21ai_1_3.Y 0.04181f
C7232 sg13cmos5l_dfrbpq_1_13.CLK a_10474_9916# 0.01995f
C7233 a_19179_7796# a_20176_7894# 0.03412f
C7234 a_3996_16710# VDD 0.07225f
C7235 sg13cmos5l_a21oi_1_2.B1 a_20398_4167# 0.01798f
C7236 sg13cmos5l_a21oi_1_6.Y a_20294_8874# 0.04262f
C7237 a_21911_17137# a_22005_16904# 0.45119f
C7238 sg13cmos5l_nand4_1_5.D a_19336_15366# 0.02144f
C7239 a_18470_17946# a_18730_17476# 0.45119f
C7240 a_7736_7678# VDD 0.26054f
C7241 sg13cmos5l_nand2_1_12.A bn1 0.01982f
C7242 sg13cmos5l_a21oi_1_14.Y bn4 0.03256f
C7243 sg13cmos5l_buf_1_5.A sg13cmos5l_inv_1_7.Y 0.01552f
C7244 sg13cmos5l_nand3b_1_3.C sg13cmos5l_buf_1_65.A 0.10893f
C7245 sg13cmos5l_o21ai_1_26.B1 sg13cmos5l_a21oi_1_24.A1 0.01493f
C7246 sg13cmos5l_dfrbpq_1_24.RESET_B a_11499_18380# 0.27963f
C7247 sg13cmos5l_mux2_1_1.A1 sg13cmos5l_dfrbpq_1_13.RESET_B 0.0235f
C7248 sg13cmos5l_buf_1_16.A bp0 0.12931f
C7249 sg13cmos5l_inv_1_9.Y a_17523_12236# 0.01158f
C7250 a_14244_20088# a_14763_19892# 0.20773f
C7251 a_8734_12214# a_8637_12214# 0.01637f
C7252 sg13cmos5l_nand2_1_6.A sg13cmos5l_a21oi_1_9.A2 0.0162f
C7253 a_10500_9952# a_10917_9959# 0.28418f
C7254 sg13cmos5l_o21ai_1_5.A1 bn3 0.10783f
C7255 sg13cmos5l_inv_1_36.A a_13676_12936# 0.01266f
C7256 sg13cmos5l_a21oi_1_24.A2 sg13cmos5l_buf_1_54.A 0.30113f
C7257 sg13cmos5l_a21oi_1_18.B1 a_22506_14020# 0.03087f
C7258 sg13cmos5l_buf_1_7.X VDD 8.42718f
C7259 sg13cmos5l_a21oi_1_2.B1 a_20294_7362# 0.02048f
C7260 sg13cmos5l_dfrbpq_1_28.RESET_B a_22522_17472# 0.01919f
C7261 a_15690_17508# a_16064_17594# 0.01702f
C7262 sg13cmos5l_nand4_1_15.B a_9832_16082# 0.01121f
C7263 sg13cmos5l_dfrbpq_1_41.CLK a_13764_17512# 0.05796f
C7264 sg13cmos5l_dlygate4sd3_1_0.A a_22522_3106# 0.30345f
C7265 sg13cmos5l_nand4_1_0.C sg13cmos5l_dfrbpq_1_17.Q 0.42061f
C7266 sg13cmos5l_buf_1_25.A bn0 0.02111f
C7267 a_15126_19044# sg13cmos5l_o21ai_1_25.B1 0.10797f
C7268 sg13cmos5l_inv_1_20.Y sg13cmos5l_o21ai_1_1.B1 0.90959f
C7269 sg13cmos5l_inv_1_1.Y a_19919_10775# 0.01374f
C7270 sg13cmos5l_a21oi_1_14.Y VDD 0.3073f
C7271 sg13cmos5l_a21oi_1_3.Y a_17835_8447# 0.02483f
C7272 sg13cmos5l_dfrbpq_1_24.RESET_B sg13cmos5l_nor2_1_6.Y 0.02202f
C7273 sg13cmos5l_o21ai_1_5.A1 sg13cmos5l_nor4_1_2.Y 0.51493f
C7274 sg13cmos5l_inv_1_1.Y sg13cmos5l_buf_1_8.A 0.02335f
C7275 a_16558_11727# VDD 0.15946f
C7276 sg13cmos5l_buf_1_42.A a_17142_16754# 0.01811f
C7277 sg13cmos5l_buf_1_16.A a_17829_6935# 0.01169f
C7278 sg13cmos5l_a21oi_1_27.B1 sg13cmos5l_o21ai_1_15.Y 0.02632f
C7279 sg13cmos5l_dfrbpq_1_35.Q a_22426_18984# 0.28352f
C7280 sg13cmos5l_buf_1_26.A a_18730_17476# 0.01188f
C7281 sg13cmos5l_buf_1_7.X a_16330_5380# 0.20587f
C7282 sg13cmos5l_buf_1_5.A a_19246_6351# 0.04455f
C7283 sg13cmos5l_o21ai_1_3.Y a_16319_9456# 0.01634f
C7284 sg13cmos5l_dfrbpq_1_48.Q valid 0.01454f
C7285 sg13cmos5l_a21oi_1_4.A2 bn6 0.01507f
C7286 a_12812_15960# sg13cmos5l_nand3_1_2.Y 0.1874f
C7287 sg13cmos5l_a21oi_1_1.A2 bp1 0.01875f
C7288 sg13cmos5l_inv_1_7.A a_17704_3986# 0.01931f
C7289 a_13764_17512# a_14052_17933# 0.24435f
C7290 sg13cmos5l_a21oi_1_9.Y a_9867_5423# 0.04031f
C7291 a_14542_7191# VDD 0.16128f
C7292 sg13cmos5l_o21ai_1_21.A2 sg13cmos5l_o21ai_1_14.A1 0.71622f
C7293 sg13cmos5l_o21ai_1_23.B1 sg13cmos5l_inv_1_24.Y 0.02541f
C7294 sg13cmos5l_nand2_1_19.A sg13cmos5l_inv_1_18.A 0.36971f
C7295 sg13cmos5l_buf_1_42.A sg13cmos5l_inv_1_1.A 0.21519f
C7296 sg13cmos5l_o21ai_1_25.B1 code2 0.13027f
C7297 sg13cmos5l_buf_1_24.A sg13cmos5l_buf_1_47.X 0.04561f
C7298 a_21099_14495# a_22096_14726# 0.03546f
C7299 sg13cmos5l_buf_1_26.A sg13cmos5l_a21oi_1_24.A2 0.02663f
C7300 a_20997_14495# a_21745_14845# 0.01058f
C7301 sg13cmos5l_a21oi_1_27.B1 a_9096_15996# 0.24166f
C7302 sg13cmos5l_dfrbpq_1_15.CLK sg13cmos5l_nor2_1_2.A 0.11261f
C7303 sg13cmos5l_buf_1_7.X bp6 0.0393f
C7304 sg13cmos5l_inv_1_17.A a_20294_11898# 0.01532f
C7305 sg13cmos5l_o21ai_1_21.A2 a_4823_17137# 0.02869f
C7306 sg13cmos5l_buf_1_45.X a_15754_18481# 0.17765f
C7307 sg13cmos5l_inv_1_18.A sg13cmos5l_nor2_1_0.Y 0.0124f
C7308 sg13cmos5l_a21oi_1_27.B1 a_4568_15238# 0.01557f
C7309 sg13cmos5l_nand2_1_18.A sg13cmos5l_nand2_1_19.Y 0.04209f
C7310 sg13cmos5l_dfrbpq_1_25.Q code6 0.01863f
C7311 sg13cmos5l_buf_1_63.A a_12406_15230# 0.01366f
C7312 sg13cmos5l_o21ai_1_21.B1 a_5230_19959# 0.10705f
C7313 sg13cmos5l_inv_1_4.Y a_21269_9484# 0.02731f
C7314 sg13cmos5l_dfrbpq_1_13.Q sg13cmos5l_o21ai_1_0.Y 0.06972f
C7315 sg13cmos5l_inv_1_14.Y sg13cmos5l_inv_1_7.A 0.03779f
C7316 a_4454_14922# a_5028_14909# 0.18486f
C7317 a_4740_14488# a_5157_14495# 0.28418f
C7318 sg13cmos5l_nand2b_1_1.A_N a_8872_6294# 0.02025f
C7319 sg13cmos5l_inv_1_15.A sg13cmos5l_o21ai_1_28.B1 0.01531f
C7320 sg13cmos5l_dlygate4sd3_1_62.A a_7858_16742# 0.06016f
C7321 sg13cmos5l_buf_1_16.A sg13cmos5l_nand4_1_16.D 0.03788f
C7322 sg13cmos5l_o21ai_1_0.A2 sg13cmos5l_a22oi_1_2.Y 0.02032f
C7323 a_20176_7894# a_20586_7972# 0.07015f
C7324 sg13cmos5l_dfrbpq_1_30.Q a_19649_16262# 0.01433f
C7325 sg13cmos5l_a21oi_1_1.A2 sg13cmos5l_dfrbpq_1_9.Q 0.32763f
C7326 sg13cmos5l_inv_1_12.Y sg13cmos5l_dfrbpq_1_28.D 0.08892f
C7327 a_18470_17946# a_19044_17933# 0.18486f
C7328 a_8411_12252# VDD 0.56553f
C7329 sg13cmos5l_inv_1_19.Y VDD 0.26045f
C7330 sg13cmos5l_o21ai_1_26.B1 a_13936_19262# 0.01488f
C7331 sg13cmos5l_o21ai_1_7.B1 a_4476_18222# 0.02795f
C7332 sg13cmos5l_mux2_1_0.S a_11286_14020# 0.01426f
C7333 sg13cmos5l_o21ai_1_0.A1 sg13cmos5l_dlygate4sd3_1_8.X 0.34935f
C7334 sg13cmos5l_buf_1_1.A sg13cmos5l_inv_1_4.Y 0.01503f
C7335 sg13cmos5l_o21ai_1_0.A1 sg13cmos5l_o21ai_1_0.Y 0.03718f
C7336 sg13cmos5l_inv_1_17.A a_21866_16276# 0.01153f
C7337 sg13cmos5l_inv_1_24.Y sg13cmos5l_a21oi_1_19.A2 0.12893f
C7338 sg13cmos5l_buf_1_7.X a_20294_8874# 0.09928f
C7339 sg13cmos5l_buf_1_47.X sg13cmos5l_nor2_1_15.Y 0.23925f
C7340 sg13cmos5l_nand4_1_17.Y a_18682_16714# 0.01453f
C7341 sg13cmos5l_mux2_1_0.S sg13cmos5l_nand2_1_13.A 0.03047f
C7342 a_1409_15424# start 0.01561f
C7343 a_4476_18222# a_4366_18258# 0.25046f
C7344 sg13cmos5l_o21ai_1_5.A2 bn3 0.03628f
C7345 sg13cmos5l_a21oi_1_24.A2 a_17243_17508# 0.06218f
C7346 sg13cmos5l_inv_1_1.Y a_20513_13238# 0.03192f
C7347 sg13cmos5l_nor3_1_2.B sg13cmos5l_a21o_1_0.A1 0.03859f
C7348 a_10917_9959# a_11019_9959# 0.3643f
C7349 sg13cmos5l_a21oi_1_3.A2 sg13cmos5l_a21oi_1_2.A2 0.12701f
C7350 sg13cmos5l_buf_1_4.A sg13cmos5l_buf_1_3.A 0.09015f
C7351 sg13cmos5l_nor3_1_6.Y sg13cmos5l_nand3_1_8.Y 0.02454f
C7352 sg13cmos5l_inv_1_1.Y a_20294_12210# 0.01491f
C7353 sg13cmos5l_o21ai_1_10.A2 sg13cmos5l_inv_1_25.Y 0.03289f
C7354 a_9846_17532# a_9734_17508# 0.3854f
C7355 sg13cmos5l_a21oi_1_2.B1 a_20192_7010# 0.02763f
C7356 a_18575_8797# a_19242_8436# 0.09257f
C7357 a_16167_9404# a_17015_9577# 0.07916f
C7358 a_16631_8065# a_16586_7832# 0.18486f
C7359 a_15804_7638# a_15694_7674# 0.25046f
C7360 sg13cmos5l_o21ai_1_17.B1 sg13cmos5l_buf_1_47.X 0.30054f
C7361 sg13cmos5l_nor3_1_6.Y sg13cmos5l_nand4_1_1.C 0.31041f
C7362 sg13cmos5l_nor3_1_2.B a_8602_9154# 0.0161f
C7363 a_20554_6892# VDD 0.09567f
C7364 sg13cmos5l_a21oi_1_6.A2 sg13cmos5l_a21oi_1_3.A2 0.0204f
C7365 sg13cmos5l_nand2b_1_4.Y sg13cmos5l_nand2_1_6.A 0.10186f
C7366 sg13cmos5l_nand2_1_1.A bn6 0.01866f
C7367 sg13cmos5l_a21oi_1_2.A2 a_17098_6130# 0.02813f
C7368 sg13cmos5l_dfrbpq_1_9.D sg13cmos5l_inv_1_11.Y 0.01798f
C7369 sg13cmos5l_inv_1_15.A a_20890_15202# 0.01572f
C7370 a_8122_10666# sg13cmos5l_dlygate4sd3_1_38.X 0.05318f
C7371 sg13cmos5l_dlygate4sd3_1_13.A sg13cmos5l_buf_1_5.A 0.10645f
C7372 sg13cmos5l_nand3b_1_3.C bn2 0.22716f
C7373 sg13cmos5l_nor4_1_2.Y sg13cmos5l_o21ai_1_5.A2 0.02329f
C7374 sg13cmos5l_a21oi_1_9.A1 a_12512_5699# 0.02539f
C7375 sg13cmos5l_a21o_1_1.A2 a_8139_9959# 0.03296f
C7376 sg13cmos5l_nand4_1_3.D sg13cmos5l_nand4_1_18.C 0.15824f
C7377 sg13cmos5l_dfrbpq_1_13.CLK a_17604_11464# 0.04933f
C7378 sg13cmos5l_a21oi_1_0.A2 sg13cmos5l_buf_1_10.A 0.01891f
C7379 a_14218_18226# code0 0.0389f
C7380 sg13cmos5l_inv_1_9.Y a_17510_10702# 0.06036f
C7381 a_8122_10666# a_8037_9959# 0.0121f
C7382 sg13cmos5l_dlygate4sd3_1_38.X a_7594_9916# 0.02272f
C7383 sg13cmos5l_o21ai_1_21.A2 sg13cmos5l_o21ai_1_10.A2 0.0101f
C7384 sg13cmos5l_buf_1_7.X a_17615_5773# 0.118f
C7385 sg13cmos5l_dfrbpq_1_34.Q sg13cmos5l_buf_1_25.A 0.01373f
C7386 sg13cmos5l_nand4_1_8.B sg13cmos5l_nand4_1_1.C 0.19594f
C7387 a_13574_18262# bn0 0.04953f
C7388 sg13cmos5l_dfrbpq_1_0.D sg13cmos5l_inv_1_6.Y 0.01538f
C7389 sg13cmos5l_nand4_1_12.Y sg13cmos5l_buf_8_2.A 0.04978f
C7390 sg13cmos5l_a21oi_1_2.B1 sg13cmos5l_buf_1_0.A 0.53233f
C7391 sg13cmos5l_dfrbpq_1_24.RESET_B a_8043_19031# 0.30302f
C7392 a_14283_17519# a_15280_17750# 0.03546f
C7393 sg13cmos5l_inv_1_4.Y bn9 0.01958f
C7394 sg13cmos5l_inv_1_31.A a_19035_16750# 0.67317f
C7395 a_6958_19959# sg13cmos5l_o21ai_1_20.B1 0.1068f
C7396 a_7594_9916# a_8037_9959# 0.02241f
C7397 sg13cmos5l_o21ai_1_5.A2 a_13015_13686# 0.05007f
C7398 a_16172_14448# sg13cmos5l_nand4_1_18.D 0.15424f
C7399 sg13cmos5l_o21ai_1_20.Y a_4108_18258# 0.02835f
C7400 sg13cmos5l_dfrbpq_1_15.CLK a_8122_10666# 0.01356f
C7401 sg13cmos5l_o21ai_1_1.B1 sg13cmos5l_nand2_1_0.B 0.35201f
C7402 a_20294_13722# bn8 0.04503f
C7403 sg13cmos5l_dfrbpq_1_15.CLK sg13cmos5l_o21ai_1_9.B1 0.02255f
C7404 a_17518_10215# sg13cmos5l_nand3_1_0.C 0.10798f
C7405 a_20580_14040# a_21099_13844# 0.20773f
C7406 a_22126_17775# sg13cmos5l_inv_1_25.Y 0.04453f
C7407 sg13cmos5l_a21oi_1_17.Y sg13cmos5l_a21oi_1_3.A2 0.01243f
C7408 sg13cmos5l_nand2b_1_1.A_N sg13cmos5l_o21ai_1_4.Y 0.17668f
C7409 sg13cmos5l_buf_1_63.A sg13cmos5l_nand4_1_1.B 0.01463f
C7410 sg13cmos5l_o21ai_1_25.B1 a_15322_16714# 0.04029f
C7411 sg13cmos5l_inv_1_32.Y sg13cmos5l_inv_1_24.Y 0.01399f
C7412 sg13cmos5l_inv_1_1.A sg13cmos5l_inv_1_4.Y 0.04904f
C7413 sg13cmos5l_dfrbpq_1_13.CLK sg13cmos5l_and2_1_5.X 0.11124f
C7414 sg13cmos5l_nand2b_1_1.A_N sg13cmos5l_nand3_1_0.A 0.02159f
C7415 a_16950_9972# a_17518_10215# 0.01641f
C7416 a_11678_7972# VDD 0.0181f
C7417 sg13cmos5l_nor4_1_2.Y a_18670_16263# 0.05605f
C7418 sg13cmos5l_o21ai_1_25.B1 sg13cmos5l_nor2_1_15.Y 0.17296f
C7419 sg13cmos5l_dlygate4sd3_1_43.X a_5412_7992# 0.05325f
C7420 sg13cmos5l_o21ai_1_21.B1 sg13cmos5l_dfrbpq_1_20.Q 0.03628f
C7421 sg13cmos5l_nand4_1_18.B sg13cmos5l_nand3_1_2.A 0.10385f
C7422 sg13cmos5l_dlygate4sd3_1_28.A sg13cmos5l_dfrbpq_1_8.D 0.18996f
C7423 sg13cmos5l_nand4_1_18.B sg13cmos5l_buf_1_45.X 0.04819f
C7424 sg13cmos5l_a21oi_1_2.A2 a_19432_3900# 0.01734f
C7425 sg13cmos5l_dlygate4sd3_1_58.X VDD 0.29238f
C7426 sg13cmos5l_nor2b_1_0.B_N sg13cmos5l_a22oi_1_0.B2 0.36725f
C7427 sg13cmos5l_a21oi_1_19.Y a_15780_18576# 0.02224f
C7428 a_18922_5380# a_18948_5416# 0.24169f
C7429 a_20586_7972# sg13cmos5l_dlygate4sd3_1_28.A 0.0776f
C7430 sg13cmos5l_a21o_1_2.X sg13cmos5l_dfrbpq_1_15.CLK 0.05007f
C7431 sg13cmos5l_buf_8_2.A sg13cmos5l_dfrbpq_1_6.D 0.03789f
C7432 sg13cmos5l_a21oi_1_6.Y a_22506_8436# 0.04719f
C7433 sg13cmos5l_buf_1_15.A a_15404_6888# 0.18268f
C7434 sg13cmos5l_a21oi_1_1.A2 sg13cmos5l_a21oi_1_7.A2 0.02004f
C7435 sg13cmos5l_dlygate4sd3_1_54.A sg13cmos5l_buf_1_24.A 0.01217f
C7436 sg13cmos5l_mux2_1_1.X VDD 0.32165f
C7437 a_14926_16935# a_15041_16936# 0.3854f
C7438 VDD bp4 0.53015f
C7439 a_22522_3864# VDD 0.25492f
C7440 sg13cmos5l_buf_1_21.A sg13cmos5l_nand3b_1_0.C 0.3352f
C7441 sg13cmos5l_nand4_1_1.A bn6 0.89782f
C7442 sg13cmos5l_buf_1_45.X code0 0.09447f
C7443 sg13cmos5l_buf_1_7.X a_20997_8447# 0.03814f
C7444 a_14661_19749# bn2 0.01968f
C7445 sg13cmos5l_buf_1_66.X sg13cmos5l_dfrbpq_1_23.Q 0.09116f
C7446 sg13cmos5l_inv_1_1.Y sg13cmos5l_dlygate4sd3_1_74.A 0.16514f
C7447 a_10461_11730# a_10543_11830# 0.01126f
C7448 sg13cmos5l_a21oi_1_6.A2 sg13cmos5l_inv_1_17.Y 0.32285f
C7449 sg13cmos5l_buf_1_7.X a_18374_7674# 0.10382f
C7450 sg13cmos5l_buf_1_66.X sg13cmos5l_inv_1_36.A 0.03316f
C7451 sg13cmos5l_buf_1_63.A a_12496_18478# 0.03278f
C7452 a_7726_8703# VDD 0.15982f
C7453 sg13cmos5l_dfrbpq_1_20.D a_6670_18447# 0.10672f
C7454 sg13cmos5l_nand3b_1_3.C sg13cmos5l_o21ai_1_14.A1 0.49129f
C7455 a_11019_9959# a_12016_10190# 0.03546f
C7456 sg13cmos5l_inv_1_17.A sg13cmos5l_a21oi_1_2.B1 0.03939f
C7457 sg13cmos5l_a21oi_1_4.A1 sg13cmos5l_nor3_1_7.Y 0.0324f
C7458 sg13cmos5l_nand4_1_6.B busy 0.1779f
C7459 a_15780_18576# a_17039_18335# 0.01412f
C7460 sg13cmos5l_buf_1_1.A sg13cmos5l_nand3_1_0.Y 0.05831f
C7461 a_15976_12972# sg13cmos5l_dlygate4sd3_1_13.A 0.02487f
C7462 sg13cmos5l_buf_1_63.A a_18762_20068# 0.01206f
C7463 sg13cmos5l_a21oi_1_23.A2 sg13cmos5l_inv_1_13.Y 0.12278f
C7464 sg13cmos5l_inv_1_2.A a_20554_8404# 0.01915f
C7465 sg13cmos5l_nand4_1_6.B sg13cmos5l_nand4_1_7.B 0.04701f
C7466 sg13cmos5l_a21oi_1_2.B1 a_21745_7285# 0.01378f
C7467 a_9885_7194# a_9640_7010# 0.01713f
C7468 sg13cmos5l_buf_1_15.A sg13cmos5l_dfrbpq_1_13.RESET_B 0.12778f
C7469 a_17318_11898# a_17578_11428# 0.45119f
C7470 sg13cmos5l_a21oi_1_2.Y a_20113_5773# 0.01368f
C7471 sg13cmos5l_nand2_1_15.B a_12406_15230# 0.07183f
C7472 sg13cmos5l_o21ai_1_18.B1 sg13cmos5l_o21ai_1_22.Y 0.01692f
C7473 a_17015_9577# sg13cmos5l_dfrbpq_1_11.D 0.02407f
C7474 sg13cmos5l_buf_1_47.X sg13cmos5l_buf_1_59.A 0.11614f
C7475 sg13cmos5l_buf_1_42.A sg13cmos5l_nand4_1_18.D 0.49355f
C7476 sg13cmos5l_a21oi_1_25.Y a_16197_18237# 0.03099f
C7477 sg13cmos5l_buf_1_20.A a_11152_12430# 0.03073f
C7478 a_10365_7194# sg13cmos5l_nand2b_1_3.B 0.18244f
C7479 sg13cmos5l_dfrbpq_1_23.Q VDD 0.62523f
C7480 sg13cmos5l_nand2_1_11.B a_8411_15532# 0.0152f
C7481 sg13cmos5l_nand4_1_6.B sg13cmos5l_nand4_1_3.B 0.04388f
C7482 sg13cmos5l_a21oi_1_25.Y sg13cmos5l_buf_1_24.A 0.02802f
C7483 sg13cmos5l_inv_1_16.Y a_16469_14484# 0.05809f
C7484 sg13cmos5l_a21o_1_1.A2 sg13cmos5l_nand2b_1_5.Y 0.18328f
C7485 a_9546_9948# a_9928_10034# 0.01648f
C7486 sg13cmos5l_a21oi_1_24.Y a_18756_17512# 0.02488f
C7487 sg13cmos5l_dfrbpq_1_24.D a_5216_13058# 0.0375f
C7488 sg13cmos5l_inv_1_36.A VDD 1.47871f
C7489 a_9885_7194# sg13cmos5l_a21oi_1_9.B1 0.18814f
C7490 sg13cmos5l_a21o_1_1.A2 sg13cmos5l_or4_1_0.C 0.20871f
C7491 bp1 bp8 0.03577f
C7492 bp2 bp7 0.02203f
C7493 comp_clk sample 0.24291f
C7494 bp9 bp5 0.15652f
C7495 bp6 bp4 0.0225f
C7496 a_22042_15202# VDD 0.25608f
C7497 a_19738_9912# a_19457_10214# 0.18796f
C7498 sg13cmos5l_nand4_1_18.B sg13cmos5l_nand3_1_2.Y 0.0846f
C7499 a_15935_7944# a_15783_7892# 0.3643f
C7500 sg13cmos5l_buf_1_45.X a_14423_14113# 0.12454f
C7501 sg13cmos5l_nand2_1_1.A a_19912_11460# 0.07081f
C7502 sg13cmos5l_a21oi_1_3.Y sg13cmos5l_inv_1_3.Y 0.08614f
C7503 a_19077_10677# VDD 0.24992f
C7504 sg13cmos5l_dfrbpq_1_24.RESET_B sg13cmos5l_dlygate4sd3_1_65.A 0.02783f
C7505 a_17153_14750# VDD 0.20597f
C7506 sg13cmos5l_dfrbpq_1_25.Q sg13cmos5l_dfrbpq_1_21.D 0.11584f
C7507 sg13cmos5l_buf_1_20.A sg13cmos5l_dfrbpq_1_18.Q 0.12066f
C7508 a_7620_9952# a_8879_10309# 0.01412f
C7509 sg13cmos5l_a21oi_1_9.Y clk 0.09259f
C7510 sg13cmos5l_inv_1_1.Y sg13cmos5l_dfrbpq_1_29.D 0.253f
C7511 sg13cmos5l_a21oi_1_2.B1 sg13cmos5l_dlygate4sd3_1_25.A 0.10253f
C7512 sg13cmos5l_inv_1_9.Y sg13cmos5l_a21oi_1_4.B1 0.11096f
C7513 sg13cmos5l_buf_1_66.X sg13cmos5l_dlygate4sd3_1_62.A 0.01363f
C7514 a_20580_14040# a_21839_13799# 0.01412f
C7515 sg13cmos5l_a21oi_1_24.Y sg13cmos5l_dlygate4sd3_1_72.A 0.08509f
C7516 a_19829_18556# sg13cmos5l_dlygate4sd3_1_98.A 0.10035f
C7517 sg13cmos5l_inv_1_2.A sg13cmos5l_dlygate4sd3_1_1.A 0.68484f
C7518 sg13cmos5l_dlygate4sd3_1_42.X sg13cmos5l_nor3_1_2.C 0.06602f
C7519 sg13cmos5l_nand4_1_18.B sg13cmos5l_buf_1_42.A 0.17213f
C7520 a_16186_6888# VDD 0.26155f
C7521 a_15358_14850# a_15968_14570# 0.01631f
C7522 sg13cmos5l_buf_8_2.A a_14218_18226# 0.34177f
C7523 sg13cmos5l_dfrbpq_1_15.Q a_7162_6888# 0.05987f
C7524 a_20997_12189# a_20997_11471# 0.05604f
C7525 sg13cmos5l_nand3b_1_1.Y a_10389_16258# 0.13452f
C7526 sg13cmos5l_inv_1_1.A sg13cmos5l_nand3_1_0.Y 0.02897f
C7527 a_20294_8874# bp4 0.0148f
C7528 a_11288_19061# sg13cmos5l_inv_1_25.Y 0.0111f
C7529 sg13cmos5l_dfrbpq_1_15.CLK a_5829_7653# 0.24029f
C7530 sg13cmos5l_a21oi_1_1.A2 sg13cmos5l_inv_1_17.Y 0.03886f
C7531 a_11552_11546# VDD 0.08859f
C7532 a_19365_5423# a_19467_5423# 0.3643f
C7533 a_15804_7638# sg13cmos5l_nand2b_1_3.B 0.02352f
C7534 sg13cmos5l_nand4_1_8.B a_12406_15230# 0.01185f
C7535 a_11014_9508# VDD 0.22111f
C7536 sg13cmos5l_dlygate4sd3_1_62.A VDD 0.29845f
C7537 sg13cmos5l_buf_1_6.A sg13cmos5l_inv_1_7.Y 0.32506f
C7538 sg13cmos5l_buf_1_7.X sg13cmos5l_a21oi_1_2.Y 0.03903f
C7539 a_11393_6352# VDD 0.21054f
C7540 a_4360_19808# sg13cmos5l_o21ai_1_7.B1 0.01925f
C7541 a_3500_19734# a_3296_19902# 0.01689f
C7542 sg13cmos5l_nand4_1_16.D sg13cmos5l_buf_1_53.A 0.01579f
C7543 sg13cmos5l_inv_1_25.Y sg13cmos5l_nand3_1_8.Y 0.12651f
C7544 sg13cmos5l_a21oi_1_4.A1 a_7310_12400# 0.08037f
C7545 sg13cmos5l_a21oi_1_6.Y a_22696_10830# 0.04144f
C7546 sg13cmos5l_o21ai_1_25.B1 sg13cmos5l_buf_1_59.A 0.29474f
C7547 a_20272_17750# a_20015_17869# 0.23043f
C7548 a_6958_16935# VDD 0.16189f
C7549 a_11278_6351# VDD 0.15958f
C7550 sg13cmos5l_dfrbpq_1_5.CLK sg13cmos5l_inv_1_1.Y 0.019f
C7551 a_20872_3176# VDD 0.17955f
C7552 sg13cmos5l_nand3b_1_3.C sg13cmos5l_o21ai_1_10.A2 0.5377f
C7553 a_13690_16714# bn0 0.05114f
C7554 sg13cmos5l_a21oi_1_9.A2 a_15404_6888# 0.072f
C7555 sg13cmos5l_inv_1_12.A bn7 0.01029f
C7556 a_15409_19847# code2 0.01721f
C7557 sg13cmos5l_dlygate4sd3_1_64.X a_5334_17532# 0.12233f
C7558 sg13cmos5l_a21oi_1_18.B1 sg13cmos5l_inv_1_1.Y 0.01914f
C7559 sg13cmos5l_nand4_1_12.Y sg13cmos5l_buf_1_16.A 0.04049f
C7560 sg13cmos5l_buf_1_1.A a_21745_4727# 0.0134f
C7561 a_8872_6294# VDD 0.14049f
C7562 sg13cmos5l_inv_1_2.A a_21466_7642# 0.05365f
C7563 a_10896_8052# sg13cmos5l_nand2b_1_3.Y 0.01521f
C7564 a_18682_16714# VDD 0.25866f
C7565 sg13cmos5l_a21oi_1_6.Y sg13cmos5l_inv_1_11.Y 0.06332f
C7566 a_17039_18335# a_17706_18556# 0.09257f
C7567 sg13cmos5l_a21o_1_0.A2 a_11360_9318# 0.0229f
C7568 a_9646_6351# VDD 0.15852f
C7569 a_15780_18576# a_16945_18335# 0.25046f
C7570 a_16299_18380# a_16068_18271# 0.07823f
C7571 sg13cmos5l_nand3_1_3.Y a_10784_7806# 0.06001f
C7572 sg13cmos5l_a21oi_1_10.A1 a_9640_7010# 0.0299f
C7573 sg13cmos5l_o21ai_1_11.Y sg13cmos5l_o21ai_1_11.A2 0.02166f
C7574 sg13cmos5l_a21oi_1_27.A1 a_9651_11808# 0.01282f
C7575 sg13cmos5l_o21ai_1_25.Y bn0 0.09643f
C7576 sg13cmos5l_nand3_1_3.Y sg13cmos5l_dfrbpq_1_47.Q 0.04374f
C7577 sg13cmos5l_buf_1_43.X a_17434_14448# 0.02515f
C7578 sg13cmos5l_o21ai_1_0.A2 sg13cmos5l_a21o_1_0.A1 0.60256f
C7579 a_7047_6380# VDD 0.20956f
C7580 a_17318_11898# a_18123_11471# 0.07916f
C7581 sg13cmos5l_buf_1_45.X sg13cmos5l_buf_8_2.A 0.0923f
C7582 sg13cmos5l_o21ai_1_18.B1 a_10980_18576# 0.03435f
C7583 sg13cmos5l_buf_1_59.A sg13cmos5l_inv_1_35.Y 0.09265f
C7584 sg13cmos5l_buf_1_1.A a_22096_10190# 0.01484f
C7585 a_20398_13239# VDD 0.1614f
C7586 sg13cmos5l_dlygate4sd3_1_98.A a_19921_17869# 0.01606f
C7587 sg13cmos5l_nand2_1_6.A sg13cmos5l_and4_1_0.D 0.21117f
C7588 sg13cmos5l_a21oi_1_9.B1 sg13cmos5l_a21oi_1_10.A1 0.03692f
C7589 sg13cmos5l_a21oi_1_19.Y valid 0.21901f
C7590 sg13cmos5l_buf_1_7.X sg13cmos5l_inv_1_6.Y 0.47592f
C7591 sg13cmos5l_nor3_1_6.Y a_4568_15238# 0.01088f
C7592 sg13cmos5l_a21oi_1_24.Y a_19275_17519# 0.0145f
C7593 sg13cmos5l_buf_1_65.A sg13cmos5l_o21ai_1_14.A1 0.02426f
C7594 a_15208_12972# sg13cmos5l_inv_1_12.A 0.18788f
C7595 sg13cmos5l_o21ai_1_17.Y VDD 0.3466f
C7596 sg13cmos5l_o21ai_1_18.B1 sg13cmos5l_a21oi_1_24.A1 0.06182f
C7597 sg13cmos5l_buf_1_16.A sg13cmos5l_dfrbpq_1_6.D 0.04937f
C7598 sg13cmos5l_dfrbpq_1_28.RESET_B a_21099_12332# 0.28334f
C7599 sg13cmos5l_nand3b_1_1.C sg13cmos5l_or4_1_1.X 0.01514f
C7600 sg13cmos5l_nand2b_1_0.B a_15691_12256# 0.0103f
C7601 sg13cmos5l_nand2_1_15.B sg13cmos5l_o21ai_1_28.Y 0.02759f
C7602 sg13cmos5l_dfrbpq_1_11.Q a_20104_10034# 0.04208f
C7603 sg13cmos5l_nand4_1_0.C a_8122_8400# 0.01111f
C7604 a_12886_15230# bn1 0.0106f
C7605 sg13cmos5l_o21ai_1_13.B1 a_10066_19398# 0.08296f
C7606 VDD code9 0.1713f
C7607 a_20176_10918# VDD 0.13648f
C7608 a_11756_19734# code4 0.16394f
C7609 sg13cmos5l_dfrbpq_1_13.RESET_B sg13cmos5l_nor2_1_2.A 0.58859f
C7610 sg13cmos5l_buf_1_7.X a_18662_5850# 0.10121f
C7611 sg13cmos5l_dfrbpq_1_17.Q sg13cmos5l_dlygate4sd3_1_43.A 0.06237f
C7612 sg13cmos5l_nand2_1_11.B sg13cmos5l_a21o_1_2.A1 0.15185f
C7613 sg13cmos5l_inv_1_31.A sg13cmos5l_dfrbpq_1_39.Q 0.04577f
C7614 sg13cmos5l_nand4_1_15.B sg13cmos5l_inv_1_12.Y 0.27729f
C7615 a_17039_18335# valid 0.03993f
C7616 a_9136_10190# a_9546_9948# 0.07015f
C7617 sg13cmos5l_a21oi_1_2.B1 a_17829_6935# 0.01989f
C7618 sg13cmos5l_inv_1_1.Y sg13cmos5l_buf_1_1.A 0.03117f
C7619 a_20997_13701# a_21745_13799# 0.01058f
C7620 a_13596_13686# a_14517_13880# 0.24169f
C7621 sg13cmos5l_dfrbpq_1_34.Q a_20974_19959# 0.01379f
C7622 sg13cmos5l_and2_1_3.X sg13cmos5l_nand3_1_8.Y 0.01994f
C7623 a_5349_19031# VDD 0.24519f
C7624 sg13cmos5l_nand3_1_0.C sg13cmos5l_dfrbpq_1_2.D 0.01478f
C7625 sg13cmos5l_inv_1_7.A sg13cmos5l_inv_1_7.Y 0.31974f
C7626 a_13749_9386# a_13910_9194# 0.01261f
C7627 sg13cmos5l_nor3_1_2.A a_6401_8702# 0.01921f
C7628 a_20384_18433# a_20503_18222# 0.09257f
C7629 sg13cmos5l_nand4_1_8.B sg13cmos5l_nand4_1_1.B 0.41545f
C7630 a_16836_20088# a_17124_19783# 0.24435f
C7631 sg13cmos5l_nand4_1_15.B sg13cmos5l_inv_1_24.A 0.01873f
C7632 sg13cmos5l_and2_1_3.X sg13cmos5l_nand4_1_1.C 0.16529f
C7633 sg13cmos5l_inv_1_12.Y bp2 0.01837f
C7634 a_20464_5654# a_20207_5773# 0.23043f
C7635 sg13cmos5l_o21ai_1_4.Y VDD 0.47567f
C7636 a_17002_15457# VDD 0.09557f
C7637 sg13cmos5l_buf_8_2.A sg13cmos5l_nand3_1_2.Y 0.32943f
C7638 sg13cmos5l_nand3_1_0.A VDD 0.74514f
C7639 sg13cmos5l_o21ai_1_20.B1 a_7066_18226# 0.02186f
C7640 sg13cmos5l_o21ai_1_7.Y code6 0.05915f
C7641 sg13cmos5l_buf_1_3.A a_18952_3176# 0.01047f
C7642 a_12726_6230# VDD 0.17096f
C7643 sg13cmos5l_dfrbpq_1_5.CLK a_21215_15967# 0.22789f
C7644 code1 bn1 0.02613f
C7645 sg13cmos5l_a21oi_1_24.A1 bn1 0.02047f
C7646 valid bn0 0.40928f
C7647 bn4 busy 0.12131f
C7648 sg13cmos5l_o21ai_1_15.B1 sg13cmos5l_inv_1_25.Y 0.01141f
C7649 sg13cmos5l_nor4_1_4.C sg13cmos5l_nand3_1_6.C 0.20259f
C7650 sg13cmos5l_buf_1_17.A a_1192_8436# 0.19688f
C7651 sg13cmos5l_nand4_1_7.B bn4 0.02977f
C7652 sg13cmos5l_dlygate4sd3_1_76.A sg13cmos5l_inv_1_17.Y 0.03292f
C7653 a_3200_16283# a_2920_16082# 0.01648f
C7654 sg13cmos5l_nand2_1_19.Y sg13cmos5l_inv_1_18.A 0.02873f
C7655 a_16172_15960# VDD 0.18211f
C7656 sg13cmos5l_buf_8_2.A sg13cmos5l_buf_1_42.A 0.09044f
C7657 sg13cmos5l_buf_1_66.X sg13cmos5l_nand4_1_7.B 0.02428f
C7658 sg13cmos5l_o21ai_1_0.A2 sg13cmos5l_nor2b_1_2.Y 0.11157f
C7659 sg13cmos5l_o21ai_1_21.A2 sg13cmos5l_dfrbpq_1_23.D 0.02716f
C7660 sg13cmos5l_buf_1_66.X sg13cmos5l_o21ai_1_11.Y 0.0443f
C7661 sg13cmos5l_nor2_1_0.Y sg13cmos5l_o21ai_1_0.A1 0.05947f
C7662 sg13cmos5l_a21oi_1_15.A2 sg13cmos5l_inv_1_12.Y 0.12658f
C7663 sg13cmos5l_nor4_1_2.Y sg13cmos5l_mux2_1_0.A1 0.03929f
C7664 sg13cmos5l_nand4_1_8.B sg13cmos5l_o21ai_1_28.Y 0.43809f
C7665 a_12987_10318# a_14350_10215# 0.01845f
C7666 sg13cmos5l_inv_1_1.Y bn9 0.0323f
C7667 a_15503_19847# a_16170_20068# 0.09257f
C7668 sg13cmos5l_a21oi_1_10.A2 sg13cmos5l_a21oi_1_10.A1 0.46438f
C7669 sg13cmos5l_mux2_1_1.A0 VDD 0.16088f
C7670 sg13cmos5l_buf_1_24.A sg13cmos5l_dfrbpq_1_24.RESET_B 0.02423f
C7671 sg13cmos5l_a21oi_1_4.A1 sg13cmos5l_nor4_1_4.C 0.04562f
C7672 sg13cmos5l_nor4_1_2.Y bn6 0.01787f
C7673 sg13cmos5l_a21oi_1_2.B1 sg13cmos5l_inv_1_0.A 0.05604f
C7674 sg13cmos5l_buf_1_7.X sg13cmos5l_inv_1_11.Y 0.82376f
C7675 sg13cmos5l_o21ai_1_15.B1 sg13cmos5l_o21ai_1_21.A2 0.16091f
C7676 sg13cmos5l_buf_1_65.A sg13cmos5l_o21ai_1_10.A2 0.21722f
C7677 sg13cmos5l_inv_1_1.Y sg13cmos5l_inv_1_1.A 0.1444f
C7678 a_9446_13726# a_9558_13790# 0.3854f
C7679 sg13cmos5l_buf_1_0.A a_21832_7806# 0.02661f
C7680 sg13cmos5l_inv_1_12.A sg13cmos5l_dfrbpq_1_7.D 0.17752f
C7681 sg13cmos5l_buf_1_66.X sg13cmos5l_nand4_1_3.B 0.15495f
C7682 a_21531_13342# VDD 0.87866f
C7683 sg13cmos5l_buf_1_15.A a_9062_19770# 0.07721f
C7684 a_9322_19993# a_9348_20088# 0.24169f
C7685 sg13cmos5l_dfrbpq_1_47.D a_14039_5459# 0.17749f
C7686 a_10954_18481# VDD 0.09442f
C7687 a_20580_12528# VDD 0.0721f
C7688 sg13cmos5l_a21oi_1_6.A2 a_19430_9190# 0.01467f
C7689 sg13cmos5l_or2_1_1.X a_10896_8052# 0.0947f
C7690 VDD busy 0.34699f
C7691 a_9848_18262# VDD 0.26164f
C7692 sg13cmos5l_o21ai_1_18.B1 sg13cmos5l_o21ai_1_19.B1 0.14787f
C7693 sg13cmos5l_a21oi_1_6.A2 sg13cmos5l_a21oi_1_2.A2 0.01756f
C7694 a_12134_19458# VDD 0.52731f
C7695 sg13cmos5l_o21ai_1_11.Y VDD 0.45593f
C7696 sg13cmos5l_nand4_1_7.B VDD 0.79542f
C7697 sg13cmos5l_buf_1_59.A sg13cmos5l_o21ai_1_24.Y 0.17887f
C7698 sg13cmos5l_dlygate4sd3_1_13.X a_17318_11898# 0.17219f
C7699 sg13cmos5l_inv_1_31.A a_18756_19024# 0.04188f
C7700 sg13cmos5l_inv_1_12.A a_20580_9952# 0.04924f
C7701 sg13cmos5l_dfrbpq_1_13.RESET_B sg13cmos5l_a21o_1_0.X 0.08976f
C7702 sg13cmos5l_buf_1_25.A a_11656_15272# 0.01693f
C7703 sg13cmos5l_buf_1_0.A a_19077_7653# 0.01089f
C7704 sg13cmos5l_inv_1_19.Y sg13cmos5l_nand2_1_6.A 0.02736f
C7705 sg13cmos5l_buf_1_13.A a_17804_4614# 0.18259f
C7706 sg13cmos5l_dfrbpq_1_5.Q VDD 0.28178f
C7707 sg13cmos5l_o21ai_1_6.Y a_8520_8436# 0.03038f
C7708 sg13cmos5l_nand4_1_3.B VDD 1.03589f
C7709 sg13cmos5l_buf_1_13.X a_17733_8447# 0.03905f
C7710 sg13cmos5l_inv_1_2.A sg13cmos5l_dfrbpq_1_0.D 0.0164f
C7711 sg13cmos5l_inv_1_15.A sg13cmos5l_a21oi_1_6.A2 0.01682f
C7712 a_16945_18335# valid 0.01005f
C7713 sg13cmos5l_buf_8_2.A sg13cmos5l_nand3_1_1.Y 0.01931f
C7714 sg13cmos5l_nand3_1_2.Y sg13cmos5l_nor3_1_2.B 0.0287f
C7715 sg13cmos5l_nand2_1_15.Y a_15392_13854# 0.03662f
C7716 sg13cmos5l_o21ai_1_0.A1 a_12844_5850# 0.01012f
C7717 a_9274_6888# a_8993_7190# 0.18796f
C7718 a_13676_19734# sg13cmos5l_o21ai_1_25.Y 0.02706f
C7719 sg13cmos5l_dfrbpq_1_13.RESET_B a_7594_9916# 0.20105f
C7720 sg13cmos5l_a21oi_1_4.A2 a_14181_16007# 0.0102f
C7721 sg13cmos5l_buf_1_13.X a_17633_10214# 0.07514f
C7722 a_21215_18528# a_21911_18649# 0.02431f
C7723 a_21063_18476# a_21084_18222# 0.20754f
C7724 sg13cmos5l_dfrbpq_1_24.RESET_B a_5258_18416# 0.02721f
C7725 a_3628_16746# a_3975_16964# 0.03546f
C7726 a_3415_16710# a_3996_16710# 0.01412f
C7727 sg13cmos5l_nor3_1_0.Y sg13cmos5l_nand2_1_13.Y 0.11196f
C7728 sg13cmos5l_nor4_1_4.C sg13cmos5l_mux2_1_1.A1 0.01162f
C7729 sg13cmos5l_inv_1_31.A a_21215_17016# 0.23297f
C7730 sg13cmos5l_a21oi_1_2.Y bp4 0.04537f
C7731 sg13cmos5l_dfrbpq_1_15.Q sg13cmos5l_nand2_1_3.Y 0.04485f
C7732 sg13cmos5l_inv_1_1.Y sg13cmos5l_buf_1_2.A 0.25344f
C7733 sg13cmos5l_and4_1_1.A sg13cmos5l_o21ai_1_9.Y 0.01019f
C7734 sg13cmos5l_nor3_1_2.A sg13cmos5l_or4_1_0.D 0.15951f
C7735 a_21839_7285# bp5 0.01012f
C7736 sg13cmos5l_dfrbpq_1_2.D a_15804_7638# 0.01054f
C7737 a_6671_7751# a_6928_7894# 0.23043f
C7738 a_5829_7653# a_5700_7687# 0.01562f
C7739 sg13cmos5l_nor2b_1_0.B_N sg13cmos5l_nand2_1_0.A 0.8051f
C7740 sg13cmos5l_o21ai_1_15.Y sg13cmos5l_inv_1_25.Y 0.0134f
C7741 sg13cmos5l_o21ai_1_9.A2 a_4727_16043# 0.01405f
C7742 sg13cmos5l_o21ai_1_7.B1 sg13cmos5l_o21ai_1_7.Y 0.17422f
C7743 sg13cmos5l_o21ai_1_17.B1 sg13cmos5l_dfrbpq_1_24.RESET_B 0.23954f
C7744 a_20874_5412# sg13cmos5l_dlygate4sd3_1_4.A 0.0762f
C7745 sg13cmos5l_a21oi_1_17.Y sg13cmos5l_a21oi_1_6.A2 0.1986f
C7746 sg13cmos5l_nand2b_1_1.A_N sg13cmos5l_o21ai_1_4.A1 0.42758f
C7747 sg13cmos5l_dfrbpq_1_28.RESET_B a_22145_19286# 0.01437f
C7748 sg13cmos5l_nand3b_1_1.C bn3 0.03437f
C7749 sg13cmos5l_buf_1_3.A a_21640_3176# 0.01321f
C7750 sg13cmos5l_inv_1_15.A sg13cmos5l_a21oi_1_17.Y 0.01783f
C7751 sg13cmos5l_o21ai_1_21.B1 sg13cmos5l_o21ai_1_20.B1 0.02507f
C7752 a_21462_17532# a_21350_17508# 0.3854f
C7753 a_10389_16258# a_10550_16362# 0.01261f
C7754 a_3900_16357# a_4031_15967# 0.28324f
C7755 sg13cmos5l_dlygate4sd3_1_50.A a_3879_16083# 0.0276f
C7756 sg13cmos5l_buf_1_15.A sg13cmos5l_nand2_1_9.Y 0.01592f
C7757 sg13cmos5l_nand3b_1_3.C a_4070_19020# 0.01656f
C7758 sg13cmos5l_a21oi_1_1.A2 a_19430_9190# 0.03146f
C7759 sg13cmos5l_dfrbpq_1_34.Q valid 0.03523f
C7760 sg13cmos5l_buf_1_21.A VDD 1.7156f
C7761 sg13cmos5l_nand2_1_13.A sg13cmos5l_nand2_1_18.A 0.02118f
C7762 sg13cmos5l_a21oi_1_7.A2 a_20580_11464# 0.02866f
C7763 a_21838_19959# VDD 0.15937f
C7764 sg13cmos5l_inv_1_6.Y bp4 0.01871f
C7765 sg13cmos5l_o21ai_1_11.Y a_6418_15230# 0.06016f
C7766 sg13cmos5l_o21ai_1_15.Y sg13cmos5l_o21ai_1_21.A2 0.02798f
C7767 sg13cmos5l_buf_8_2.A sg13cmos5l_inv_1_4.Y 0.04055f
C7768 sg13cmos5l_dfrbpq_1_28.RESET_B a_19173_19031# 0.03886f
C7769 a_16170_20068# sg13cmos5l_dfrbpq_1_34.Q 0.08038f
C7770 sg13cmos5l_dfrbpq_1_33.D VDD 0.31689f
C7771 sg13cmos5l_and2_1_3.X sg13cmos5l_dlygate4sd3_1_81.X 0.04108f
C7772 a_7498_18226# sg13cmos5l_buf_8_2.A 0.40382f
C7773 sg13cmos5l_dlygate4sd3_1_22.A a_19995_9190# 0.02281f
C7774 a_12504_15552# VDD 0.01784f
C7775 sg13cmos5l_buf_1_63.A a_20225_19960# 0.01033f
C7776 a_14761_15238# a_14855_15532# 0.02103f
C7777 a_18863_11821# a_19530_11460# 0.09257f
C7778 a_12239_18335# VDD 0.1706f
C7779 sg13cmos5l_nor3_1_2.B sg13cmos5l_nand3_1_1.Y 0.05077f
C7780 sg13cmos5l_buf_1_10.A sg13cmos5l_a22oi_1_0.B2 0.09772f
C7781 sg13cmos5l_nand3b_1_3.C sg13cmos5l_o21ai_1_10.Y 0.02418f
C7782 sg13cmos5l_buf_1_6.A a_19328_4782# 0.01246f
C7783 sg13cmos5l_a21oi_1_6.Y sg13cmos5l_inv_1_2.A 0.10549f
C7784 sg13cmos5l_a21oi_1_6.A2 sg13cmos5l_a21oi_1_1.A2 0.43734f
C7785 sg13cmos5l_buf_1_7.X sg13cmos5l_buf_1_4.A 0.05144f
C7786 sg13cmos5l_inv_1_15.A sg13cmos5l_nand4_1_5.D 0.02764f
C7787 a_22506_12508# VDD 0.27611f
C7788 a_18352_19990# VDD 0.13551f
C7789 sg13cmos5l_nand4_1_1.B sg13cmos5l_inv_1_25.Y 0.69106f
C7790 sg13cmos5l_inv_1_1.A a_13768_14484# 0.01669f
C7791 sg13cmos5l_dfrbpq_1_7.D a_20997_9959# 0.02001f
C7792 sg13cmos5l_buf_1_7.X sg13cmos5l_inv_1_3.Y 0.06416f
C7793 sg13cmos5l_dfrbpq_1_28.RESET_B a_20716_16746# 0.09624f
C7794 a_6968_17549# VDD 0.26486f
C7795 sg13cmos5l_a21oi_1_13.Y sg13cmos5l_inv_1_16.A 0.60335f
C7796 sg13cmos5l_nor2b_1_1.A sg13cmos5l_nand4_1_15.B 0.55157f
C7797 sg13cmos5l_inv_1_2.A a_21370_6130# 0.02076f
C7798 a_5230_19959# VDD 0.15801f
C7799 sg13cmos5l_buf_1_2.A sg13cmos5l_inv_1_0.Y 0.31855f
C7800 sg13cmos5l_buf_1_0.A a_20176_7894# 0.05606f
C7801 sg13cmos5l_buf_1_43.X a_17028_15552# 0.01152f
C7802 a_20294_10386# a_20868_10373# 0.18486f
C7803 a_20580_9952# a_20997_9959# 0.28418f
C7804 sg13cmos5l_buf_1_16.A sg13cmos5l_buf_1_42.A 1.41405f
C7805 sg13cmos5l_o21ai_1_17.Y a_10872_17488# 0.01087f
C7806 sg13cmos5l_o21ai_1_0.A1 a_13191_5499# 0.03414f
C7807 a_14446_12508# a_14548_12508# 0.12518f
C7808 sg13cmos5l_dfrbpq_1_13.RESET_B a_9136_10190# 0.12193f
C7809 a_21911_18649# a_22005_18416# 0.45119f
C7810 sg13cmos5l_dfrbpq_1_39.Q sg13cmos5l_inv_1_25.Y 0.03115f
C7811 a_3996_16710# a_4917_16904# 0.24169f
C7812 sg13cmos5l_nor2_1_2.B sg13cmos5l_nand2b_1_4.B 0.49768f
C7813 sg13cmos5l_o21ai_1_7.Y sg13cmos5l_dfrbpq_1_21.D 0.07835f
C7814 a_15784_15272# code1 0.06602f
C7815 sg13cmos5l_dfrbpq_1_13.RESET_B a_5829_7653# 0.03779f
C7816 sg13cmos5l_and4_1_1.A a_6835_13916# 0.04988f
C7817 a_7941_19031# VDD 0.24537f
C7818 sg13cmos5l_buf_1_13.X a_17518_10215# 0.03758f
C7819 sg13cmos5l_inv_1_9.Y sg13cmos5l_buf_1_13.A 0.02768f
C7820 sg13cmos5l_buf_1_15.A code1 0.02688f
C7821 sg13cmos5l_buf_1_15.A sg13cmos5l_a21oi_1_24.A1 0.02083f
C7822 sg13cmos5l_a21oi_1_21.A1 sg13cmos5l_o21ai_1_26.B1 0.01722f
C7823 sg13cmos5l_nor2_1_2.A sg13cmos5l_a21oi_1_8.Y 0.2443f
C7824 a_7507_9380# sg13cmos5l_dlygate4sd3_1_42.A 0.1229f
C7825 sg13cmos5l_nand3_1_0.C sg13cmos5l_buf_1_0.A 0.02496f
C7826 sg13cmos5l_nor4_1_4.C sg13cmos5l_nor3_1_4.A 0.05119f
C7827 sg13cmos5l_o21ai_1_28.B1 bn1 0.11714f
C7828 sg13cmos5l_nor2_1_2.A a_7068_6126# 0.02022f
C7829 a_12939_19031# sg13cmos5l_inv_1_25.Y 0.01174f
C7830 a_22522_17472# a_22241_17774# 0.18796f
C7831 sg13cmos5l_nor3_1_0.Y sg13cmos5l_nand2b_1_1.A_N 0.10819f
C7832 sg13cmos5l_inv_1_17.A a_21099_14495# 0.01114f
C7833 sg13cmos5l_dfrbpq_1_29.Q bn6 0.03133f
C7834 a_20580_4968# bp2 0.01545f
C7835 sg13cmos5l_o21ai_1_7.Y sg13cmos5l_buf_8_2.A 0.03412f
C7836 a_14438_6162# VDD 0.52297f
C7837 sg13cmos5l_nor2b_1_0.B_N a_12826_9154# 0.01281f
C7838 a_18730_18988# VDD 0.09498f
C7839 sg13cmos5l_nand3_1_0.A a_16566_8460# 0.01935f
C7840 sg13cmos5l_dfrbpq_1_41.CLK a_14181_16007# 0.2553f
C7841 sg13cmos5l_nand2b_1_0.B sg13cmos5l_inv_1_18.A 0.28491f
C7842 sg13cmos5l_inv_1_32.Y a_13738_15964# 0.02101f
C7843 sg13cmos5l_nand3_1_5.Y sg13cmos5l_o21ai_1_18.A2 0.19639f
C7844 a_20580_4968# a_21099_4772# 0.20773f
C7845 sg13cmos5l_inv_1_36.A sg13cmos5l_dfrbpq_1_15.CLK 0.02209f
C7846 a_13505_7864# sg13cmos5l_nand2b_1_3.B 0.01017f
C7847 sg13cmos5l_buf_1_13.A a_13343_5383# 0.03752f
C7848 sg13cmos5l_o21ai_1_5.A1 sg13cmos5l_o21ai_1_23.A2 0.1464f
C7849 a_8637_5682# a_8480_5498# 0.01774f
C7850 sg13cmos5l_o21ai_1_14.Y sg13cmos5l_o21ai_1_21.A2 0.02625f
C7851 sg13cmos5l_buf_1_9.A a_20868_8861# 0.0106f
C7852 sg13cmos5l_buf_8_2.A sg13cmos5l_nand3_1_0.Y 0.06289f
C7853 sg13cmos5l_inv_1_12.A a_19930_12936# 0.01358f
C7854 sg13cmos5l_inv_1_16.A sg13cmos5l_dfrbpq_1_28.D 0.0193f
C7855 sg13cmos5l_nand3_1_2.Y a_12929_13238# 0.01009f
C7856 code4 code5 0.45153f
C7857 a_5660_14040# VDD 0.01784f
C7858 sg13cmos5l_dfrbpq_1_40.Q VDD 0.29503f
C7859 sg13cmos5l_dlygate4sd3_1_4.A a_20794_3864# 0.27487f
C7860 sg13cmos5l_dfrbpq_1_24.RESET_B a_5318_13410# 0.08307f
C7861 sg13cmos5l_buf_1_7.X sg13cmos5l_inv_1_2.A 0.87592f
C7862 sg13cmos5l_buf_1_45.X a_16550_19770# 0.07692f
C7863 sg13cmos5l_nand3_1_2.Y a_12428_12936# 0.18636f
C7864 sg13cmos5l_nand3_1_0.B sg13cmos5l_dlygate4sd3_1_13.A 0.21995f
C7865 sg13cmos5l_dfrbpq_1_20.Q VDD 0.39314f
C7866 sg13cmos5l_buf_1_0.A sg13cmos5l_dlygate4sd3_1_28.A 0.07121f
C7867 sg13cmos5l_inv_1_15.A sg13cmos5l_dlygate4sd3_1_76.A 0.01852f
C7868 sg13cmos5l_buf_1_9.A a_17733_8447# 0.01273f
C7869 sg13cmos5l_dfrbpq_1_35.D sg13cmos5l_dfrbpq_1_28.RESET_B 0.07629f
C7870 sg13cmos5l_buf_1_63.A bn0 0.04636f
C7871 a_22126_9375# VDD 0.16001f
C7872 sg13cmos5l_dlygate4sd3_1_50.X a_4727_16043# 0.01242f
C7873 sg13cmos5l_o21ai_1_19.B1 a_8540_17488# 0.01087f
C7874 sg13cmos5l_inv_1_12.A sg13cmos5l_buf_1_13.X 0.0131f
C7875 sg13cmos5l_buf_1_16.A sg13cmos5l_inv_1_4.Y 0.01986f
C7876 a_5318_13410# a_5604_12976# 0.26205f
C7877 a_6094_16935# sg13cmos5l_dfrbpq_1_19.D 0.1069f
C7878 sg13cmos5l_buf_1_63.A a_15503_19847# 0.01795f
C7879 sg13cmos5l_o21ai_1_21.B1 sg13cmos5l_dfrbpq_1_24.RESET_B 0.09198f
C7880 sg13cmos5l_a21oi_1_27.B1 sg13cmos5l_nor2b_1_1.A 0.45052f
C7881 VDD comp 0.23378f
C7882 sg13cmos5l_and4_1_1.A a_8006_13726# 0.01763f
C7883 sg13cmos5l_dlygate4sd3_1_50.X a_3532_16434# 0.04939f
C7884 a_9450_19020# VDD 0.27627f
C7885 sg13cmos5l_nand4_1_18.B sg13cmos5l_and4_1_1.A 0.06612f
C7886 a_3584_18390# VDD 0.10368f
C7887 sg13cmos5l_buf_1_45.X sg13cmos5l_buf_1_53.A 0.01374f
C7888 sg13cmos5l_nand3b_1_3.C a_9096_15996# 0.01054f
C7889 a_9867_19892# code5 0.02742f
C7890 sg13cmos5l_o21ai_1_22.Y a_9846_17532# 0.03746f
C7891 sg13cmos5l_dlygate4sd3_1_25.A sg13cmos5l_nand3_1_0.C 0.03726f
C7892 a_16836_20088# sg13cmos5l_buf_1_24.A 0.02159f
C7893 sg13cmos5l_dfrbpq_1_44.Q sg13cmos5l_inv_1_25.Y 0.01528f
C7894 sg13cmos5l_inv_1_7.A bp2 0.03307f
C7895 sg13cmos5l_inv_1_9.Y sg13cmos5l_buf_1_5.A 0.07134f
C7896 a_15208_9318# VDD 0.13755f
C7897 sg13cmos5l_nand2b_1_1.A_N a_14842_11424# 0.06035f
C7898 sg13cmos5l_dlygate4sd3_1_25.A a_16950_9972# 0.0111f
C7899 sg13cmos5l_inv_1_17.A bn7 0.02713f
C7900 a_18954_15532# VDD 0.27478f
C7901 sg13cmos5l_buf_1_0.A a_20464_5654# 0.01322f
C7902 a_16240_6382# VDD 0.13513f
C7903 a_20272_19262# VDD 0.13589f
C7904 sg13cmos5l_o21ai_1_15.B1 sg13cmos5l_buf_1_65.A 0.01292f
C7905 sg13cmos5l_dfrbpq_1_30.D sg13cmos5l_dfrbpq_1_29.Q 0.0791f
C7906 sg13cmos5l_inv_1_15.A a_12232_14484# 0.0183f
C7907 sg13cmos5l_a21oi_1_2.A2 bp8 0.21415f
C7908 sg13cmos5l_dfrbpq_1_15.CLK a_7047_6380# 0.03743f
C7909 sg13cmos5l_buf_1_4.A bp4 0.02141f
C7910 sg13cmos5l_inv_1_17.A sg13cmos5l_dlygate4sd3_1_28.A 0.01823f
C7911 sg13cmos5l_buf_1_26.A sg13cmos5l_nand2_1_9.Y 0.60978f
C7912 sg13cmos5l_o21ai_1_4.A1 VDD 0.34253f
C7913 sg13cmos5l_nand3b_1_3.C sg13cmos5l_nand4_1_1.B 0.01879f
C7914 sg13cmos5l_inv_1_16.A a_21099_13844# 0.03845f
C7915 a_20580_4968# a_20868_4663# 0.24435f
C7916 sg13cmos5l_buf_1_25.A sg13cmos5l_o21ai_1_5.A1 0.01992f
C7917 sg13cmos5l_dlygate4sd3_1_76.A sg13cmos5l_a21oi_1_1.A2 0.02495f
C7918 sg13cmos5l_dfrbpq_1_34.Q a_16810_19993# 0.01753f
C7919 sg13cmos5l_buf_1_9.A sg13cmos5l_dfrbpq_1_8.D 0.01108f
C7920 sg13cmos5l_nand4_1_18.B sg13cmos5l_and2_1_6.A 0.0387f
C7921 sg13cmos5l_and4_1_0.D a_13390_7863# 0.12493f
C7922 a_7275_11471# VDD 0.20488f
C7923 sg13cmos5l_nand2_1_15.B sg13cmos5l_inv_1_24.A 0.22276f
C7924 sg13cmos5l_buf_1_7.X a_20997_6935# 0.04015f
C7925 sg13cmos5l_buf_1_47.X bn4 0.72209f
C7926 sg13cmos5l_nor4_1_0.Y a_12632_8477# 0.26706f
C7927 sg13cmos5l_a21oi_1_14.Y a_22522_17472# 0.05123f
C7928 sg13cmos5l_nand2_1_15.B a_13228_13722# 0.0183f
C7929 sg13cmos5l_buf_8_2.A a_22096_10190# 0.01329f
C7930 sg13cmos5l_a21oi_1_25.Y sg13cmos5l_nand4_1_17.Y 0.02328f
C7931 sg13cmos5l_nor4_1_0.Y sg13cmos5l_nand3_1_3.Y 0.15869f
C7932 sg13cmos5l_dlygate4sd3_1_74.A sg13cmos5l_nand2_1_1.A 0.10882f
C7933 a_13096_15996# VDD 0.19764f
C7934 sg13cmos5l_nor3_1_6.Y sg13cmos5l_inv_1_12.Y 0.02169f
C7935 a_16949_12508# sg13cmos5l_a21oi_1_15.Y 0.10499f
C7936 a_5600_8522# VDD 0.08648f
C7937 sg13cmos5l_inv_1_31.A sg13cmos5l_a21oi_1_19.Y 0.04571f
C7938 sg13cmos5l_inv_1_13.Y sg13cmos5l_inv_1_12.A 0.01815f
C7939 a_5604_12976# a_5892_13397# 0.24435f
C7940 sg13cmos5l_a21oi_1_5.A2 VDD 0.63913f
C7941 sg13cmos5l_buf_1_42.A sg13cmos5l_buf_1_53.A 0.03537f
C7942 sg13cmos5l_buf_1_20.A sg13cmos5l_nand2_1_13.A 0.0284f
C7943 sg13cmos5l_buf_1_10.A bp2 0.06793f
C7944 sg13cmos5l_buf_1_15.A sg13cmos5l_dfrbpq_1_24.D 0.20394f
C7945 sg13cmos5l_buf_1_63.A sg13cmos5l_dfrbpq_1_34.Q 0.37991f
C7946 sg13cmos5l_buf_1_13.X a_20997_9959# 0.03706f
C7947 a_9640_7010# clk 0.01843f
C7948 sg13cmos5l_dfrbpq_1_28.RESET_B a_20997_13701# 0.04383f
C7949 sg13cmos5l_a21oi_1_12.Y sg13cmos5l_a21oi_1_4.A1 0.25208f
C7950 sg13cmos5l_and4_1_1.A a_9558_13790# 0.05051f
C7951 sg13cmos5l_buf_8_2.A sg13cmos5l_inv_1_1.Y 0.04528f
C7952 a_3996_16710# a_3886_16746# 0.25046f
C7953 sg13cmos5l_inv_1_16.Y a_17318_11898# 0.04034f
C7954 sg13cmos5l_buf_1_47.X VDD 0.96201f
C7955 sg13cmos5l_nor3_1_6.Y sg13cmos5l_inv_1_24.A 0.01259f
C7956 sg13cmos5l_buf_1_16.A sg13cmos5l_nand3_1_0.Y 0.03841f
C7957 sg13cmos5l_dlygate4sd3_1_18.X a_18272_10034# 0.01243f
C7958 sg13cmos5l_inv_1_31.A a_17039_18335# 0.01048f
C7959 a_5397_18416# VDD 0.09522f
C7960 sg13cmos5l_nand3b_1_3.C sg13cmos5l_o21ai_1_14.Y 0.04628f
C7961 sg13cmos5l_buf_1_26.A code1 0.02278f
C7962 sg13cmos5l_buf_1_26.A sg13cmos5l_a21oi_1_24.A1 0.0183f
C7963 sg13cmos5l_nand4_1_8.B a_10880_16878# 0.02125f
C7964 sg13cmos5l_a21oi_1_9.B1 clk 0.01291f
C7965 sg13cmos5l_buf_1_13.X sg13cmos5l_dfrbpq_1_2.D 0.09444f
C7966 a_20024_6166# VDD 0.26272f
C7967 sg13cmos5l_o21ai_1_15.Y sg13cmos5l_buf_1_65.A 0.10215f
C7968 sg13cmos5l_dfrbpq_1_15.Q sg13cmos5l_a22oi_1_1.B2 0.0797f
C7969 sg13cmos5l_nor3_1_2.B sg13cmos5l_dlygate4sd3_1_42.X 0.02502f
C7970 sg13cmos5l_nand4_1_15.B sg13cmos5l_nand3_1_0.B 0.01473f
C7971 sg13cmos5l_nand3_1_0.A sg13cmos5l_inv_1_11.Y 0.02737f
C7972 sg13cmos5l_nor3_1_2.Y sg13cmos5l_or4_1_0.D 0.02715f
C7973 sg13cmos5l_nand4_1_8.B sg13cmos5l_inv_1_24.A 0.04404f
C7974 sg13cmos5l_nand3_1_5.Y a_8444_17064# 0.0104f
C7975 sg13cmos5l_inv_1_5.A a_14724_6480# 0.10521f
C7976 sg13cmos5l_inv_1_9.Y sg13cmos5l_nor2b_1_0.B_N 0.03226f
C7977 sg13cmos5l_nand4_1_3.D a_16172_14448# 0.18478f
C7978 a_15592_10736# VDD 0.2124f
C7979 sg13cmos5l_o21ai_1_25.B1 bn4 0.02294f
C7980 sg13cmos5l_nand3_1_0.A a_15783_7892# 0.04863f
C7981 sg13cmos5l_nand2b_1_1.A_N sg13cmos5l_dlygate4sd3_1_8.X 0.16647f
C7982 sg13cmos5l_nand2b_1_1.A_N sg13cmos5l_o21ai_1_0.Y 0.15417f
C7983 a_22096_8678# bp1 0.03091f
C7984 sg13cmos5l_nor3_1_0.Y VDD 0.59542f
C7985 sg13cmos5l_inv_1_8.A a_12987_10318# 0.05022f
C7986 sg13cmos5l_buf_1_57.A a_17547_15356# 0.02299f
C7987 sg13cmos5l_inv_1_32.Y a_13670_15238# 0.02472f
C7988 sg13cmos5l_inv_1_2.A bp4 0.35915f
C7989 sg13cmos5l_buf_1_25.A sg13cmos5l_o21ai_1_5.A2 0.0748f
C7990 sg13cmos5l_buf_8_2.A sg13cmos5l_and4_1_1.A 0.03816f
C7991 a_21839_4727# a_21745_4727# 0.16704f
C7992 sg13cmos5l_inv_1_17.A sg13cmos5l_dfrbpq_1_7.D 0.01233f
C7993 sg13cmos5l_nand2_1_0.A sg13cmos5l_buf_1_10.A 0.02543f
C7994 a_17253_19749# valid 0.01345f
C7995 sg13cmos5l_o21ai_1_3.Y sg13cmos5l_nand3_1_0.A 0.30728f
C7996 sg13cmos5l_dlygate4sd3_1_71.X a_19912_11460# 0.01938f
C7997 sg13cmos5l_a21o_1_2.B1 sg13cmos5l_and4_1_1.A 0.37122f
C7998 a_18486_18326# a_19054_18447# 0.01641f
C7999 a_9260_11424# VDD 0.18307f
C8000 sg13cmos5l_buf_1_7.X a_22096_7166# 0.09622f
C8001 sg13cmos5l_a21oi_1_24.A1 a_17243_17508# 0.02731f
C8002 sg13cmos5l_a21oi_1_18.B1 sg13cmos5l_buf_1_57.A 0.02541f
C8003 sg13cmos5l_buf_1_43.X a_16840_12972# 0.17632f
C8004 sg13cmos5l_inv_1_12.A a_19240_13058# 0.02716f
C8005 a_15208_12972# bp0 0.1569f
C8006 sg13cmos5l_buf_1_65.A sg13cmos5l_nand4_1_1.B 0.25245f
C8007 sg13cmos5l_and4_1_0.D a_12430_6980# 0.20469f
C8008 a_7736_13726# VDD 0.26911f
C8009 a_20554_6892# a_20997_6935# 0.02241f
C8010 sg13cmos5l_nor3_1_2.B a_13749_9386# 0.03292f
C8011 sg13cmos5l_dfrbpq_1_5.CLK sg13cmos5l_nand2_1_1.A 0.1356f
C8012 sg13cmos5l_o21ai_1_25.B1 VDD 0.45712f
C8013 sg13cmos5l_a21oi_1_18.B1 sg13cmos5l_nand2_1_1.A 0.08937f
C8014 sg13cmos5l_nand4_1_16.D sg13cmos5l_inv_1_24.Y 0.01535f
C8015 sg13cmos5l_inv_1_12.A sg13cmos5l_buf_1_9.A 0.15814f
C8016 a_22042_15202# sg13cmos5l_dfrbpq_1_27.Q 0.275f
C8017 a_20294_13722# VDD 0.5236f
C8018 sg13cmos5l_dfrbpq_1_37.D bn4 0.02044f
C8019 a_6123_12983# a_7120_13214# 0.03546f
C8020 a_6021_12983# a_6769_13333# 0.01058f
C8021 sg13cmos5l_inv_1_15.Y sg13cmos5l_nor3_1_7.Y 0.01781f
C8022 sg13cmos5l_nor3_1_2.B a_10771_9380# 0.06176f
C8023 sg13cmos5l_nand4_1_8.B bn0 0.02244f
C8024 sg13cmos5l_buf_8_2.A sg13cmos5l_and2_1_6.A 0.02484f
C8025 a_12929_19960# code3 0.0253f
C8026 sg13cmos5l_dfrbpq_1_19.CLK a_4127_17016# 0.21954f
C8027 sg13cmos5l_mux2_1_1.X sg13cmos5l_dfrbpq_1_13.RESET_B 0.15061f
C8028 sg13cmos5l_buf_1_42.A sg13cmos5l_nand4_1_3.D 0.02977f
C8029 sg13cmos5l_a21oi_1_10.A2 clk 0.01871f
C8030 a_6094_16935# a_6209_16936# 0.3854f
C8031 sg13cmos5l_dfrbpq_1_19.D a_5800_16878# 0.02381f
C8032 sg13cmos5l_nand4_1_6.B a_16088_13730# 0.01149f
C8033 sg13cmos5l_inv_1_35.Y VDD 0.12151f
C8034 sg13cmos5l_inv_1_15.A sg13cmos5l_a21oi_1_4.A1 0.25472f
C8035 sg13cmos5l_a21o_1_1.A2 sg13cmos5l_nor3_1_2.C 0.72281f
C8036 a_21640_3900# a_22126_4167# 0.01642f
C8037 sg13cmos5l_buf_1_24.A sg13cmos5l_dfrbpq_1_18.Q 0.02469f
C8038 sg13cmos5l_o21ai_1_12.Y sg13cmos5l_o21ai_1_11.A2 0.17704f
C8039 sg13cmos5l_inv_1_15.A a_21911_16043# 0.04264f
C8040 sg13cmos5l_inv_1_15.Y sg13cmos5l_inv_1_16.Y 0.02547f
C8041 a_17015_9577# VDD 0.52297f
C8042 sg13cmos5l_buf_1_8.A sg13cmos5l_dlygate4sd3_1_4.A 0.29402f
C8043 sg13cmos5l_buf_1_13.A sg13cmos5l_inv_1_5.A 0.27344f
C8044 sg13cmos5l_buf_1_26.A sg13cmos5l_nor4_1_4.C 0.44704f
C8045 sg13cmos5l_dfrbpq_1_41.CLK a_17547_15356# 0.02557f
C8046 sg13cmos5l_inv_1_14.Y a_19365_5423# 0.02373f
C8047 sg13cmos5l_inv_1_1.A sg13cmos5l_a21oi_1_4.A2 0.102f
C8048 sg13cmos5l_nand4_1_15.B sg13cmos5l_inv_1_16.A 0.01566f
C8049 sg13cmos5l_buf_1_13.A a_17030_8874# 0.01184f
C8050 sg13cmos5l_buf_1_47.X a_12118_17886# 0.08212f
C8051 sg13cmos5l_a21oi_1_25.A2 sg13cmos5l_nand4_1_1.B 0.16867f
C8052 sg13cmos5l_dfrbpq_1_28.RESET_B a_20012_14448# 0.01089f
C8053 sg13cmos5l_inv_1_5.A a_16650_6460# 0.01583f
C8054 sg13cmos5l_dfrbpq_1_37.D VDD 0.36761f
C8055 sg13cmos5l_buf_1_47.X sg13cmos5l_dlygate4sd3_1_69.A 0.14371f
C8056 sg13cmos5l_dfrbpq_1_23.D a_4823_17137# 0.16508f
C8057 sg13cmos5l_dlygate4sd3_1_54.A VDD 0.27248f
C8058 sg13cmos5l_o21ai_1_28.A1 a_12040_15272# 0.01944f
C8059 sg13cmos5l_buf_1_14.A sg13cmos5l_a21oi_1_4.B1 0.06307f
C8060 sg13cmos5l_a21oi_1_4.A1 sg13cmos5l_a21oi_1_17.Y 0.06594f
C8061 sg13cmos5l_a21oi_1_25.Y bn4 0.02837f
C8062 a_4821_16043# VDD 0.09599f
C8063 sg13cmos5l_dfrbpq_1_41.CLK sg13cmos5l_a21oi_1_18.B1 0.01899f
C8064 a_14842_11424# VDD 0.27106f
C8065 a_11278_13239# a_11072_13058# 0.01604f
C8066 sg13cmos5l_a21oi_1_18.B1 sg13cmos5l_nand4_1_1.A 0.2327f
C8067 a_10864_19990# sg13cmos5l_dlygate4sd3_1_54.A 0.01949f
C8068 a_5259_14495# a_6256_14726# 0.03546f
C8069 sg13cmos5l_dfrbpq_1_28.RESET_B sg13cmos5l_inv_1_15.A 0.29099f
C8070 sg13cmos5l_inv_1_1.Y sg13cmos5l_buf_1_16.A 0.08409f
C8071 sg13cmos5l_nand4_1_12.Y a_18106_17472# 0.01321f
C8072 a_19930_12936# sg13cmos5l_dfrbpq_1_28.Q 0.27788f
C8073 sg13cmos5l_a21oi_1_4.B1 a_15610_9912# 0.01273f
C8074 sg13cmos5l_buf_8_2.A clk 0.04593f
C8075 a_3319_15960# VDD 0.17774f
C8076 sg13cmos5l_nand3_1_6.C sg13cmos5l_o21ai_1_28.A1 0.14217f
C8077 a_9765_5423# a_10513_5773# 0.01058f
C8078 sg13cmos5l_nand4_1_1.B a_10359_14020# 0.02857f
C8079 a_9867_5423# a_10864_5654# 0.03546f
C8080 sg13cmos5l_nor2_1_3.Y VDD 0.4789f
C8081 sg13cmos5l_o21ai_1_5.A1 a_10124_11424# 0.20152f
C8082 a_10896_8052# VDD 0.19538f
C8083 sg13cmos5l_buf_1_8.A bp9 0.05752f
C8084 a_8118_13790# VDD 0.16137f
C8085 a_20580_6928# a_21099_6935# 0.20754f
C8086 a_20997_6935# a_20868_7349# 0.01562f
C8087 sg13cmos5l_buf_1_10.A a_12826_9154# 0.01413f
C8088 sg13cmos5l_inv_1_24.A sg13cmos5l_dfrbpq_1_24.Q 0.01945f
C8089 sg13cmos5l_inv_1_32.Y a_14038_16742# 0.01341f
C8090 sg13cmos5l_nand2b_1_1.A_N a_9274_6888# 0.01199f
C8091 sg13cmos5l_nand2b_1_0.B sg13cmos5l_o21ai_1_0.A1 0.24348f
C8092 sg13cmos5l_inv_1_16.A sg13cmos5l_a21oi_1_15.A2 0.03422f
C8093 sg13cmos5l_a21oi_1_25.Y VDD 0.3972f
C8094 sg13cmos5l_o21ai_1_21.B1 code7 0.04953f
C8095 sg13cmos5l_o21ai_1_24.Y bn4 0.05159f
C8096 sg13cmos5l_buf_1_59.A bn5 0.09631f
C8097 sg13cmos5l_dfrbpq_1_28.RESET_B sg13cmos5l_a21oi_1_17.Y 0.05434f
C8098 sg13cmos5l_o21ai_1_10.Y sg13cmos5l_o21ai_1_10.A2 0.32136f
C8099 sg13cmos5l_o21ai_1_13.B1 sg13cmos5l_buf_1_24.A 0.0816f
C8100 sg13cmos5l_a21oi_1_13.Y a_20554_14452# 0.02151f
C8101 sg13cmos5l_nand3_1_5.Y a_5334_17532# 0.01574f
C8102 sg13cmos5l_nor2b_1_1.A sg13cmos5l_nand4_1_8.B 0.30457f
C8103 sg13cmos5l_inv_1_1.A sg13cmos5l_buf_1_57.A 0.02473f
C8104 sg13cmos5l_buf_1_7.X a_20984_10702# 0.01702f
C8105 sg13cmos5l_a21oi_1_19.Y sg13cmos5l_inv_1_25.Y 0.28439f
C8106 sg13cmos5l_a21oi_1_0.A2 a_18593_10214# 0.01621f
C8107 sg13cmos5l_o21ai_1_20.B1 VDD 0.32967f
C8108 a_22096_10190# a_21839_10309# 0.23043f
C8109 sg13cmos5l_inv_1_15.A bn1 0.05764f
C8110 sg13cmos5l_a21oi_1_23.A2 a_18101_14020# 0.08326f
C8111 sg13cmos5l_nand2_1_1.Y sg13cmos5l_dlygate4sd3_1_13.A 0.15562f
C8112 sg13cmos5l_a21oi_1_21.A1 bn1 0.02121f
C8113 sg13cmos5l_nor3_1_6.Y sg13cmos5l_dlygate4sd3_1_18.A 0.01795f
C8114 sg13cmos5l_inv_1_1.A sg13cmos5l_nand2_1_1.A 0.02486f
C8115 sg13cmos5l_nand3_1_2.Y a_12987_12214# 0.06077f
C8116 sg13cmos5l_nand4_1_1.B bn2 0.02135f
C8117 sg13cmos5l_a21oi_1_2.B1 sg13cmos5l_inv_1_4.Y 0.05432f
C8118 sg13cmos5l_nand4_1_18.A VDD 0.5645f
C8119 sg13cmos5l_buf_1_1.A a_18832_8678# 0.01097f
C8120 sg13cmos5l_a21oi_1_2.B1 a_19930_4618# 0.01544f
C8121 sg13cmos5l_dfrbpq_1_24.Q a_9176_13726# 0.08395f
C8122 sg13cmos5l_buf_1_66.X sg13cmos5l_o21ai_1_12.Y 0.03136f
C8123 sg13cmos5l_inv_1_9.Y sg13cmos5l_dlygate4sd3_1_18.A 0.40652f
C8124 sg13cmos5l_inv_1_9.Y a_16078_9186# 0.01655f
C8125 sg13cmos5l_buf_1_1.A sg13cmos5l_dfrbpq_1_11.Q 0.01022f
C8126 sg13cmos5l_buf_1_13.X a_18374_10698# 0.09011f
C8127 sg13cmos5l_dfrbpq_1_28.RESET_B sg13cmos5l_nand4_1_5.D 0.10922f
C8128 sg13cmos5l_or4_1_0.D sg13cmos5l_nand4_1_0.C 0.04509f
C8129 sg13cmos5l_nand2b_1_1.A_N a_14854_12236# 0.01758f
C8130 sg13cmos5l_o21ai_1_24.Y VDD 0.5799f
C8131 sg13cmos5l_o21ai_1_5.A1 a_11368_16878# 0.04844f
C8132 sg13cmos5l_nand4_1_15.B sg13cmos5l_nor4_1_1.D 0.26955f
C8133 sg13cmos5l_nor3_1_2.B clk 0.0449f
C8134 sg13cmos5l_buf_1_13.X sg13cmos5l_buf_1_0.A 0.02319f
C8135 sg13cmos5l_dfrbpq_1_13.RESET_B a_7047_6380# 0.2806f
C8136 sg13cmos5l_o21ai_1_6.Y sg13cmos5l_dfrbpq_1_15.Q 0.05535f
C8137 sg13cmos5l_o21ai_1_15.B1 sg13cmos5l_o21ai_1_10.A2 0.1756f
C8138 sg13cmos5l_a21oi_1_3.A2 sg13cmos5l_a21oi_1_3.Y 0.09556f
C8139 sg13cmos5l_o21ai_1_12.Y VDD 0.38572f
C8140 sg13cmos5l_nand3b_1_1.Y sg13cmos5l_nand3b_1_1.C 0.02186f
C8141 a_14517_13880# VDD 0.09643f
C8142 sg13cmos5l_dlygate4sd3_1_9.A a_14144_7806# 0.04099f
C8143 sg13cmos5l_dlygate4sd3_1_16.A bp3 0.04083f
C8144 sg13cmos5l_dfrbpq_1_15.Q sg13cmos5l_nor2_1_2.A 0.07518f
C8145 sg13cmos5l_nand2_1_19.A sg13cmos5l_nand3b_1_0.C 0.03727f
C8146 sg13cmos5l_a21oi_1_6.Y bp1 0.02003f
C8147 a_13505_7864# a_13786_7642# 0.18796f
C8148 sg13cmos5l_inv_1_25.Y bn0 0.0244f
C8149 a_13198_9228# sg13cmos5l_nor2_1_0.Y 0.01339f
C8150 sg13cmos5l_o21ai_1_4.Y a_15404_6888# 0.0163f
C8151 sg13cmos5l_dlygate4sd3_1_8.X VDD 0.23958f
C8152 sg13cmos5l_o21ai_1_0.Y VDD 0.69229f
C8153 sg13cmos5l_nand3b_1_0.C sg13cmos5l_nor2_1_0.Y 0.0245f
C8154 sg13cmos5l_and2_1_3.X sg13cmos5l_inv_1_24.A 0.01539f
C8155 sg13cmos5l_buf_1_66.X a_8434_17886# 0.05708f
C8156 sg13cmos5l_dlygate4sd3_1_65.A a_8830_17874# 0.01576f
C8157 sg13cmos5l_dfrbpq_1_41.CLK sg13cmos5l_inv_1_1.A 0.02402f
C8158 sg13cmos5l_buf_1_15.A sg13cmos5l_a21oi_1_12.Y 0.07905f
C8159 sg13cmos5l_dfrbpq_1_39.D sg13cmos5l_nand4_1_17.Y 0.08737f
C8160 a_16810_19993# a_17253_19749# 0.02241f
C8161 sg13cmos5l_o21ai_1_19.Y a_7498_18988# 0.0303f
C8162 sg13cmos5l_dlygate4sd3_1_82.X a_16836_20088# 0.03479f
C8163 a_5098_9409# a_5124_9504# 0.24169f
C8164 sg13cmos5l_a21oi_1_27.A1 VDD 0.61166f
C8165 sg13cmos5l_inv_1_1.A sg13cmos5l_nand4_1_1.A 0.01323f
C8166 sg13cmos5l_a21oi_1_9.A1 sg13cmos5l_dlygate4sd3_1_7.X 0.02702f
C8167 sg13cmos5l_a21o_1_2.B1 a_7907_15532# 0.03214f
C8168 sg13cmos5l_nand3_1_5.Y sg13cmos5l_nand3b_1_1.Y 0.50469f
C8169 sg13cmos5l_o21ai_1_7.B1 a_6760_15366# 0.02326f
C8170 a_9147_13028# a_9349_13342# 0.01126f
C8171 a_21646_15423# bn7 0.012f
C8172 sg13cmos5l_nor2_1_3.Y a_12172_10996# 0.01686f
C8173 sg13cmos5l_inv_1_17.A sg13cmos5l_buf_1_13.X 0.04048f
C8174 sg13cmos5l_nand3_1_5.Y a_4220_17488# 0.01284f
C8175 a_1192_14484# start 0.01494f
C8176 sg13cmos5l_dlygate4sd3_1_62.A a_7964_17064# 0.01087f
C8177 a_22506_9948# sg13cmos5l_dlygate4sd3_1_16.A 0.07585f
C8178 sg13cmos5l_dfrbpq_1_13.Q sg13cmos5l_nand2b_1_3.B 0.01773f
C8179 sg13cmos5l_a21oi_1_2.Y a_20024_6166# 0.04135f
C8180 sg13cmos5l_dlygate4sd3_1_58.X a_9062_19770# 0.16725f
C8181 sg13cmos5l_o21ai_1_26.B1 bn1 0.02139f
C8182 sg13cmos5l_buf_1_7.X a_17931_6935# 0.29379f
C8183 sg13cmos5l_mux2_1_0.S a_10461_11730# 0.18312f
C8184 a_10771_9380# sg13cmos5l_o21ai_1_0.A2 0.15637f
C8185 a_6958_16935# sg13cmos5l_o21ai_1_11.B1 0.10701f
C8186 sg13cmos5l_inv_1_13.Y sg13cmos5l_nand4_1_18.C 0.02554f
C8187 sg13cmos5l_o21ai_1_5.A1 valid 0.03928f
C8188 sg13cmos5l_o21ai_1_0.A1 sg13cmos5l_nand2b_1_3.B 0.02528f
C8189 sg13cmos5l_buf_1_63.A a_17253_19749# 0.01653f
C8190 sg13cmos5l_nand3_1_8.Y sg13cmos5l_nand4_1_1.C 0.75556f
C8191 sg13cmos5l_dfrbpq_1_35.D sg13cmos5l_buf_1_26.A 0.04894f
C8192 sg13cmos5l_a21oi_1_3.A2 a_17318_11898# 0.01157f
C8193 sg13cmos5l_buf_8_2.A sg13cmos5l_inv_1_20.Y 0.02389f
C8194 sg13cmos5l_inv_1_1.Y a_20294_11898# 0.01642f
C8195 sg13cmos5l_o21ai_1_15.Y sg13cmos5l_o21ai_1_10.A2 0.03695f
C8196 a_20294_4650# VDD 0.52387f
C8197 sg13cmos5l_nand2b_1_4.B sg13cmos5l_dlygate4sd3_1_43.A 0.04116f
C8198 sg13cmos5l_inv_1_13.Y a_18374_10698# 0.02762f
C8199 sg13cmos5l_a21oi_1_2.B1 sg13cmos5l_nand3_1_0.Y 0.10224f
C8200 sg13cmos5l_dlygate4sd3_1_22.A VDD 0.23324f
C8201 sg13cmos5l_and4_1_1.A sg13cmos5l_dfrbpq_1_45.Q 0.37987f
C8202 sg13cmos5l_mux2_1_1.A0 sg13cmos5l_dfrbpq_1_13.RESET_B 0.04031f
C8203 sg13cmos5l_dlygate4sd3_1_29.X a_18497_6352# 0.01537f
C8204 sg13cmos5l_buf_1_42.A a_17526_16362# 0.01809f
C8205 a_18587_4948# VDD 0.16089f
C8206 a_17429_12508# VDD 0.16162f
C8207 a_13738_15964# a_13764_16000# 0.24169f
C8208 a_9646_6351# sg13cmos5l_dfrbpq_1_13.D 0.10639f
C8209 sg13cmos5l_dlygate4sd3_1_18.X a_18374_10698# 0.16976f
C8210 a_18634_10921# a_18660_11016# 0.24169f
C8211 sg13cmos5l_dlygate4sd3_1_77.A sg13cmos5l_nand4_1_1.A 0.01836f
C8212 sg13cmos5l_nand4_1_18.B sg13cmos5l_a21oi_1_4.A2 0.11982f
C8213 sg13cmos5l_o21ai_1_0.A2 a_12512_5699# 0.06316f
C8214 sg13cmos5l_buf_1_13.X sg13cmos5l_dlygate4sd3_1_25.A 0.03435f
C8215 sg13cmos5l_dfrbpq_1_24.RESET_B sg13cmos5l_buf_1_66.X 0.07094f
C8216 sg13cmos5l_buf_1_13.A a_15436_7674# 0.09636f
C8217 sg13cmos5l_dfrbpq_1_28.RESET_B sg13cmos5l_dlygate4sd3_1_76.A 0.10492f
C8218 sg13cmos5l_dfrbpq_1_5.CLK bn3 0.03367f
C8219 sg13cmos5l_inv_1_4.Y a_16773_5423# 0.02641f
C8220 sg13cmos5l_nor2b_1_1.A sg13cmos5l_inv_1_25.Y 0.11349f
C8221 a_6487_6126# a_6958_6162# 0.16704f
C8222 sg13cmos5l_dfrbpq_1_15.CLK a_7275_11471# 0.04994f
C8223 sg13cmos5l_dfrbpq_1_13.CLK a_14253_13320# 0.01243f
C8224 a_13210_19738# VDD 0.26811f
C8225 sg13cmos5l_buf_1_5.A a_19342_10215# 0.10792f
C8226 sg13cmos5l_nand4_1_15.B sg13cmos5l_nand2_1_1.Y 0.01741f
C8227 sg13cmos5l_a21oi_1_2.A2 a_16875_5423# 0.04285f
C8228 a_12428_12936# sg13cmos5l_and2_1_6.A 0.12499f
C8229 sg13cmos5l_a21oi_1_4.A2 code0 0.04438f
C8230 sg13cmos5l_nand2b_1_1.A_N sg13cmos5l_nor2_1_0.Y 0.11336f
C8231 a_10230_18326# sg13cmos5l_dlygate4sd3_1_56.X 0.12355f
C8232 sg13cmos5l_o21ai_1_3.Y a_15208_9318# 0.01745f
C8233 sg13cmos5l_a21oi_1_27.B1 sg13cmos5l_nor4_1_1.D 0.6865f
C8234 sg13cmos5l_inv_1_15.A a_21084_16357# 0.01181f
C8235 a_12512_5699# a_12631_5376# 0.09257f
C8236 a_11274_5412# a_11656_5498# 0.01648f
C8237 a_6368_6337# a_6700_6162# 0.07015f
C8238 sg13cmos5l_dfrbpq_1_44.Q bn2 0.12205f
C8239 a_19930_12936# a_19649_13238# 0.18796f
C8240 sg13cmos5l_buf_1_9.A a_21152_3986# 0.03221f
C8241 sg13cmos5l_inv_1_36.Y sg13cmos5l_nand2_1_0.A 0.01869f
C8242 sg13cmos5l_buf_1_7.X bp1 0.0749f
C8243 sg13cmos5l_nand3b_1_3.C sg13cmos5l_inv_1_24.A 0.01211f
C8244 sg13cmos5l_buf_1_59.A a_14761_15238# 0.01811f
C8245 a_12140_19734# sg13cmos5l_buf_1_63.A 0.01298f
C8246 sg13cmos5l_dfrbpq_1_24.RESET_B VDD 8.73189f
C8247 sg13cmos5l_nand4_1_15.B sg13cmos5l_o21ai_1_5.A1 0.04783f
C8248 sg13cmos5l_o21ai_1_10.A2 sg13cmos5l_nand4_1_1.B 0.42761f
C8249 sg13cmos5l_buf_1_15.A sg13cmos5l_a21oi_1_6.A2 0.01554f
C8250 sg13cmos5l_inv_1_32.Y a_13686_18326# 0.01251f
C8251 sg13cmos5l_o21ai_1_21.A2 sg13cmos5l_nor2b_1_1.A 0.02111f
C8252 sg13cmos5l_a21oi_1_18.B1 sg13cmos5l_nor4_1_2.Y 0.03328f
C8253 sg13cmos5l_dfrbpq_1_41.CLK a_15014_19020# 0.05375f
C8254 sg13cmos5l_buf_1_15.A sg13cmos5l_inv_1_15.A 0.19453f
C8255 sg13cmos5l_inv_1_9.Y sg13cmos5l_buf_1_10.A 0.03769f
C8256 sg13cmos5l_nand4_1_12.Y sg13cmos5l_dfrbpq_1_38.Q 0.04064f
C8257 sg13cmos5l_nor2b_1_0.B_N sg13cmos5l_dlygate4sd3_1_15.X 0.01165f
C8258 sg13cmos5l_a21oi_1_6.Y a_22522_9154# 0.05617f
C8259 sg13cmos5l_dfrbpq_1_13.CLK sg13cmos5l_a22oi_1_0.B2 0.29379f
C8260 sg13cmos5l_buf_1_42.A a_20294_14922# 0.0143f
C8261 sg13cmos5l_dfrbpq_1_23.Q a_4952_17549# 0.27393f
C8262 sg13cmos5l_nand4_1_18.C a_19240_13058# 0.0105f
C8263 sg13cmos5l_inv_1_20.Y sg13cmos5l_nor3_1_2.B 0.02441f
C8264 a_5604_12976# VDD 0.07378f
C8265 a_4114_17886# sg13cmos5l_o21ai_1_21.Y 0.03403f
C8266 sg13cmos5l_nand4_1_18.B sg13cmos5l_buf_1_57.A 0.03138f
C8267 sg13cmos5l_mux2_1_1.A1 a_10316_12936# 0.15638f
C8268 sg13cmos5l_a21oi_1_13.Y bn6 0.03157f
C8269 sg13cmos5l_inv_1_1.A sg13cmos5l_dfrbpq_1_3.D 0.0319f
C8270 sg13cmos5l_a21oi_1_5.A2 sg13cmos5l_inv_1_11.Y 0.02697f
C8271 a_9274_6888# VDD 0.26459f
C8272 sg13cmos5l_a21oi_1_9.A2 sg13cmos5l_dfrbpq_1_47.Q 0.15401f
C8273 sg13cmos5l_o21ai_1_5.A2 valid 0.09423f
C8274 sg13cmos5l_a21oi_1_2.A2 sg13cmos5l_buf_1_3.A 0.32462f
C8275 sg13cmos5l_buf_1_57.A code0 0.0197f
C8276 sg13cmos5l_nand3_1_3.Y sg13cmos5l_a21oi_1_9.A2 0.24082f
C8277 sg13cmos5l_nor3_1_6.Y sg13cmos5l_nand3_1_0.B 0.02257f
C8278 a_22096_4870# VDD 0.1363f
C8279 a_18374_10698# a_18948_10711# 0.18486f
C8280 sg13cmos5l_buf_1_5.A a_18948_7687# 0.01193f
C8281 a_9322_5380# VDD 0.09426f
C8282 sg13cmos5l_buf_1_9.A sg13cmos5l_buf_1_0.A 0.17601f
C8283 a_14181_16007# a_14283_16007# 0.3643f
C8284 sg13cmos5l_nand3_1_0.B sg13cmos5l_inv_1_9.Y 0.02314f
C8285 sg13cmos5l_inv_1_15.Y sg13cmos5l_a21oi_1_3.A2 0.06348f
C8286 sg13cmos5l_nand3b_1_3.C bn0 0.01482f
C8287 sg13cmos5l_dfrbpq_1_39.D bn4 0.01404f
C8288 sg13cmos5l_o21ai_1_9.B1 a_5554_13718# 0.02424f
C8289 sg13cmos5l_inv_1_20.Y sg13cmos5l_a21oi_1_15.Y 0.0658f
C8290 sg13cmos5l_nand4_1_5.D a_15784_15272# 0.01781f
C8291 sg13cmos5l_a21oi_1_8.Y a_8872_6294# 0.03976f
C8292 a_9077_6460# sg13cmos5l_a21oi_1_10.Y 0.10351f
C8293 sg13cmos5l_dfrbpq_1_13.CLK sg13cmos5l_dlygate4sd3_1_13.A 0.01971f
C8294 sg13cmos5l_buf_1_15.A sg13cmos5l_nand4_1_5.D 0.09698f
C8295 sg13cmos5l_buf_8_2.A sg13cmos5l_nand2_1_0.B 0.09291f
C8296 sg13cmos5l_nand4_1_18.D sg13cmos5l_nand4_1_1.A 0.68193f
C8297 a_17434_14448# sg13cmos5l_a21oi_1_20.Y 0.29271f
C8298 sg13cmos5l_dlygate4sd3_1_25.A sg13cmos5l_dlygate4sd3_1_18.X 0.01765f
C8299 sg13cmos5l_dlygate4sd3_1_58.X sg13cmos5l_a21oi_1_24.A1 0.02949f
C8300 sg13cmos5l_buf_1_45.X a_14283_17519# 0.29328f
C8301 sg13cmos5l_o21ai_1_11.Y sg13cmos5l_o21ai_1_11.B1 0.64427f
C8302 sg13cmos5l_dfrbpq_1_15.Q a_8671_7996# 0.0105f
C8303 sg13cmos5l_o21ai_1_5.A1 sg13cmos5l_nor2_1_16.Y 0.2466f
C8304 sg13cmos5l_dfrbpq_1_30.D a_21063_16964# 0.05341f
C8305 a_21215_15967# a_21866_16276# 0.01562f
C8306 sg13cmos5l_buf_1_14.A sg13cmos5l_nand2_1_2.Y 0.22698f
C8307 sg13cmos5l_nor4_1_2.Y a_18544_15454# 0.04894f
C8308 a_16440_11016# sg13cmos5l_dlygate4sd3_1_25.A 0.01087f
C8309 sg13cmos5l_o21ai_1_25.Y a_13764_17512# 0.0123f
C8310 sg13cmos5l_nor3_1_6.Y sg13cmos5l_a21oi_1_27.A2 0.09132f
C8311 a_13727_13992# a_14378_13880# 0.01562f
C8312 a_7047_6380# a_7068_6126# 0.20754f
C8313 a_7199_6432# a_7989_6320# 0.02241f
C8314 sg13cmos5l_o21ai_1_0.B1 a_13460_6924# 0.08754f
C8315 sg13cmos5l_nor2_1_10.Y sg13cmos5l_or4_1_1.X 0.16708f
C8316 a_13727_13992# a_13596_13686# 0.28418f
C8317 sg13cmos5l_dfrbpq_1_15.CLK a_6289_9263# 0.01113f
C8318 sg13cmos5l_inv_1_8.A sg13cmos5l_inv_1_18.A 0.41752f
C8319 sg13cmos5l_nand4_1_15.B sg13cmos5l_o21ai_1_5.A2 0.06802f
C8320 sg13cmos5l_inv_1_1.Y sg13cmos5l_a21oi_1_2.B1 0.03883f
C8321 sg13cmos5l_dfrbpq_1_1.D a_18948_5416# 0.03603f
C8322 a_4646_19458# a_4932_19024# 0.26205f
C8323 sg13cmos5l_a21oi_1_26.A1 sg13cmos5l_a21oi_1_26.A2 0.12243f
C8324 a_11278_13239# VDD 0.15846f
C8325 sg13cmos5l_dlygate4sd3_1_71.X a_20294_12210# 0.02831f
C8326 sg13cmos5l_buf_1_53.A a_13768_14484# 0.19493f
C8327 sg13cmos5l_dlygate4sd3_1_80.X bn2 0.01836f
C8328 sg13cmos5l_buf_1_45.X sg13cmos5l_inv_1_24.Y 0.02044f
C8329 sg13cmos5l_o21ai_1_7.Y a_7196_15552# 0.01188f
C8330 sg13cmos5l_or4_1_1.X a_9526_16742# 0.08622f
C8331 sg13cmos5l_nor3_1_0.Y a_15597_12256# 0.01718f
C8332 sg13cmos5l_buf_8_2.A sg13cmos5l_a21oi_1_4.A2 0.01802f
C8333 sg13cmos5l_dfrbpq_1_39.D VDD 0.19968f
C8334 sg13cmos5l_nand4_1_18.B sg13cmos5l_dfrbpq_1_41.CLK 0.02555f
C8335 a_15480_8752# sg13cmos5l_dfrbpq_1_2.D 0.09411f
C8336 a_12957_7194# sg13cmos5l_o21ai_1_0.B1 0.08697f
C8337 a_20554_11428# a_20997_11471# 0.02241f
C8338 a_17253_19749# sg13cmos5l_inv_1_31.A 0.20323f
C8339 sg13cmos5l_inv_1_32.Y sg13cmos5l_buf_1_24.A 0.01862f
C8340 a_5124_9504# a_5643_9308# 0.20773f
C8341 sg13cmos5l_nand2b_1_0.B sg13cmos5l_o21ai_1_1.Y 0.0452f
C8342 sg13cmos5l_nand4_1_18.B sg13cmos5l_nand4_1_1.A 0.04355f
C8343 sg13cmos5l_inv_1_17.A sg13cmos5l_buf_1_9.A 0.0214f
C8344 sg13cmos5l_inv_1_17.Y sg13cmos5l_a21oi_1_6.Y 0.07338f
C8345 a_8337_13362# VDD 0.49362f
C8346 sg13cmos5l_o21ai_1_4.Y a_12430_6980# 0.01617f
C8347 sg13cmos5l_a21oi_1_9.A1 a_13460_6924# 0.01559f
C8348 sg13cmos5l_dlygate4sd3_1_55.X a_11558_19020# 0.01048f
C8349 sg13cmos5l_buf_1_1.A bp9 0.0284f
C8350 a_11372_10662# VDD 0.18537f
C8351 sg13cmos5l_a21oi_1_26.Y sg13cmos5l_a21oi_1_26.A2 0.01046f
C8352 a_6863_13333# VDD 0.17336f
C8353 sg13cmos5l_inv_1_18.A sg13cmos5l_inv_1_22.Y 0.03277f
C8354 sg13cmos5l_dfrbpq_1_28.RESET_B a_19169_18448# 0.02615f
C8355 sg13cmos5l_dfrbpq_1_41.CLK code0 0.62284f
C8356 sg13cmos5l_nor4_1_2.Y sg13cmos5l_inv_1_1.A 0.01495f
C8357 VDD bp3 0.37232f
C8358 sg13cmos5l_inv_1_13.Y bp0 0.01404f
C8359 sg13cmos5l_dlygate4sd3_1_64.X sg13cmos5l_dlygate4sd3_1_50.X 0.0792f
C8360 a_12040_6294# a_12224_6294# 0.05762f
C8361 sg13cmos5l_inv_1_17.Y a_21370_6130# 0.05305f
C8362 sg13cmos5l_a21oi_1_27.B1 sg13cmos5l_o21ai_1_5.A1 0.25644f
C8363 a_9348_20088# sg13cmos5l_dfrbpq_1_19.CLK 0.07634f
C8364 a_9765_19749# a_9867_19892# 0.36168f
C8365 sg13cmos5l_a21oi_1_7.A2 sg13cmos5l_buf_1_7.X 0.05798f
C8366 sg13cmos5l_inv_1_1.A sg13cmos5l_dlygate4sd3_1_4.A 0.01946f
C8367 sg13cmos5l_nand4_1_8.B a_11656_15272# 0.01266f
C8368 sg13cmos5l_a21oi_1_0.A2 a_18660_11016# 0.03039f
C8369 sg13cmos5l_a21oi_1_9.A1 a_10803_6188# 0.01265f
C8370 sg13cmos5l_nor3_1_2.B sg13cmos5l_nand2_1_0.B 0.42907f
C8371 sg13cmos5l_nand4_1_6.B bn5 0.6192f
C8372 a_7073_16936# a_7354_16714# 0.18796f
C8373 a_10408_6294# a_10592_6294# 0.05762f
C8374 a_22241_3328# a_22522_3106# 0.18796f
C8375 sg13cmos5l_buf_8_2.A a_17710_17775# 0.01045f
C8376 a_9350_12210# a_9636_12528# 0.26205f
C8377 sg13cmos5l_inv_1_32.Y sg13cmos5l_nor2_1_15.Y 0.09187f
C8378 sg13cmos5l_nor3_1_6.Y sg13cmos5l_inv_1_16.A 0.04406f
C8379 a_5999_14845# VDD 0.17509f
C8380 sg13cmos5l_nor4_1_0.C a_12022_8814# 0.05915f
C8381 sg13cmos5l_nand3b_1_3.C sg13cmos5l_nor2b_1_1.A 0.02807f
C8382 a_10607_5773# VDD 0.17855f
C8383 sg13cmos5l_nand4_1_17.Y bn5 0.02395f
C8384 sg13cmos5l_nand4_1_8.B a_10389_16258# 0.01062f
C8385 a_9761_6352# a_10042_6130# 0.18796f
C8386 a_15280_16238# a_15023_16357# 0.23043f
C8387 sg13cmos5l_dfrbpq_1_35.Q bn3 0.09428f
C8388 sg13cmos5l_inv_1_5.A a_16078_9186# 0.01811f
C8389 sg13cmos5l_dfrbpq_1_24.Q a_7530_12972# 0.08454f
C8390 sg13cmos5l_buf_1_17.A VDD 0.2059f
C8391 sg13cmos5l_o21ai_1_11.A2 a_7048_16082# 0.02883f
C8392 sg13cmos5l_a21oi_1_2.A2 sg13cmos5l_dfrbpq_1_9.D 0.59587f
C8393 sg13cmos5l_buf_1_7.X a_17098_6130# 0.03654f
C8394 sg13cmos5l_buf_8_2.A sg13cmos5l_buf_1_57.A 0.05685f
C8395 sg13cmos5l_o21ai_1_23.B1 sg13cmos5l_buf_1_59.A 0.01305f
C8396 sg13cmos5l_nand3_1_2.Y sg13cmos5l_inv_1_24.Y 0.01362f
C8397 sg13cmos5l_inv_1_15.A sg13cmos5l_buf_1_54.A 0.04745f
C8398 sg13cmos5l_buf_8_2.A a_13478_17946# 0.02612f
C8399 sg13cmos5l_nand4_1_5.D a_19066_15960# 0.03387f
C8400 a_22506_9948# VDD 0.27567f
C8401 bp1 bp4 0.02458f
C8402 sg13cmos5l_a21oi_1_2.A2 sg13cmos5l_a21oi_1_3.Y 0.01326f
C8403 sg13cmos5l_a21oi_1_1.A2 sg13cmos5l_dlygate4sd3_1_1.A 0.04465f
C8404 sg13cmos5l_buf_1_9.A sg13cmos5l_a22oi_1_2.Y 0.01755f
C8405 bp9 bn9 0.10917f
C8406 bp6 bp3 0.04099f
C8407 sg13cmos5l_a21oi_1_2.B1 sg13cmos5l_inv_1_0.Y 0.0675f
C8408 sg13cmos5l_a22oi_1_1.B2 sg13cmos5l_nand2_1_3.Y 0.10566f
C8409 sg13cmos5l_a21oi_1_21.A1 a_14244_20088# 0.01663f
C8410 sg13cmos5l_nand4_1_1.B sg13cmos5l_nand3_1_8.Y 0.01996f
C8411 sg13cmos5l_inv_1_32.Y a_13596_13686# 0.0437f
C8412 sg13cmos5l_nand2_1_1.A sg13cmos5l_a21oi_1_13.A2 0.02812f
C8413 sg13cmos5l_dfrbpq_1_3.D a_16188_9150# 0.02945f
C8414 sg13cmos5l_buf_8_2.A sg13cmos5l_nand2_1_1.A 0.02392f
C8415 sg13cmos5l_nor4_1_2.Y sg13cmos5l_dlygate4sd3_1_77.A 0.05593f
C8416 sg13cmos5l_a21oi_1_19.Y sg13cmos5l_a21oi_1_25.A2 0.46041f
C8417 a_7416_12404# a_7482_12508# 0.03336f
C8418 sg13cmos5l_buf_1_42.A sg13cmos5l_inv_1_24.Y 0.01454f
C8419 sg13cmos5l_nand4_1_1.B sg13cmos5l_nand4_1_1.C 0.17646f
C8420 a_13212_5773# a_13343_5383# 0.28324f
C8421 sg13cmos5l_or4_1_0.D sg13cmos5l_dfrbpq_1_17.Q 0.08245f
C8422 sg13cmos5l_nand2_1_19.A VDD 1.17618f
C8423 sg13cmos5l_buf_1_13.A a_14938_6888# 0.06166f
C8424 a_21839_14845# a_21839_13799# 0.01202f
C8425 a_5349_19031# a_5220_19445# 0.01562f
C8426 a_4932_19024# a_5451_19031# 0.20754f
C8427 a_19649_16262# VDD 0.20672f
C8428 a_21185_7864# bp2 0.06311f
C8429 sg13cmos5l_buf_1_54.A sg13cmos5l_a21oi_1_17.Y 0.43164f
C8430 a_12040_13058# VDD 0.12125f
C8431 sg13cmos5l_buf_1_14.A sg13cmos5l_buf_1_5.A 0.02447f
C8432 sg13cmos5l_buf_1_63.A sg13cmos5l_o21ai_1_5.A1 0.12495f
C8433 sg13cmos5l_nor2_1_0.Y VDD 0.26075f
C8434 a_20580_11464# a_21839_11821# 0.01412f
C8435 a_5124_9504# sg13cmos5l_nor3_1_2.Y 0.01948f
C8436 a_9848_18262# sg13cmos5l_o21ai_1_22.Y 0.27591f
C8437 a_21099_8447# bp2 0.01101f
C8438 sg13cmos5l_o21ai_1_17.Y a_10980_18576# 0.03509f
C8439 a_11670_14484# VDD 0.01711f
C8440 sg13cmos5l_dlygate4sd3_1_20.A sg13cmos5l_dlygate4sd3_1_16.A 0.20067f
C8441 sg13cmos5l_dfrbpq_1_19.CLK a_5451_19031# 0.02269f
C8442 sg13cmos5l_nand4_1_15.B sg13cmos5l_dfrbpq_1_13.CLK 0.02948f
C8443 sg13cmos5l_buf_1_1.A a_21640_3900# 0.04539f
C8444 sg13cmos5l_nand2_1_19.Y sg13cmos5l_nand3b_1_0.C 0.13602f
C8445 sg13cmos5l_inv_1_1.Y a_20384_16283# 0.0611f
C8446 a_9500_8416# VDD 0.01784f
C8447 sg13cmos5l_o21ai_1_21.Y a_4700_17488# 0.01087f
C8448 sg13cmos5l_buf_1_16.A a_18282_5412# 0.04592f
C8449 sg13cmos5l_inv_1_17.Y sg13cmos5l_buf_1_7.X 0.04199f
C8450 sg13cmos5l_o21ai_1_17.Y sg13cmos5l_a21oi_1_24.A1 0.01469f
C8451 sg13cmos5l_o21ai_1_15.B1 sg13cmos5l_o21ai_1_15.Y 0.9281f
C8452 sg13cmos5l_a21oi_1_27.B1 sg13cmos5l_o21ai_1_5.A2 0.37615f
C8453 a_14926_16935# bn2 0.04102f
C8454 sg13cmos5l_buf_1_2.A bp9 0.84458f
C8455 sg13cmos5l_inv_1_12.A bn8 0.02389f
C8456 sg13cmos5l_a22oi_1_0.B2 sg13cmos5l_o21ai_1_3.A2 0.08473f
C8457 sg13cmos5l_nor3_1_2.B a_13566_8412# 0.10473f
C8458 sg13cmos5l_buf_1_54.A sg13cmos5l_nand4_1_5.D 0.29406f
C8459 sg13cmos5l_a22oi_1_0.B2 a_14746_9912# 0.28288f
C8460 sg13cmos5l_nand2b_1_0.B sg13cmos5l_or2_1_1.X 0.11808f
C8461 sg13cmos5l_buf_1_26.A sg13cmos5l_dfrbpq_1_33.Q 0.11687f
C8462 sg13cmos5l_a21oi_1_4.A1 bn1 0.01405f
C8463 sg13cmos5l_buf_8_2.A a_18756_17512# 0.01286f
C8464 sg13cmos5l_nand4_1_1.B a_19035_16750# 0.01119f
C8465 sg13cmos5l_a21oi_1_9.A1 a_13974_6230# 0.0185f
C8466 sg13cmos5l_nand4_1_6.B sg13cmos5l_dfrbpq_1_18.Q 0.0122f
C8467 sg13cmos5l_buf_1_5.A comp_clk 0.01742f
C8468 sg13cmos5l_buf_1_21.A a_12045_11808# 0.01285f
C8469 sg13cmos5l_o21ai_1_1.Y sg13cmos5l_nand2b_1_3.B 0.05129f
C8470 a_1409_19960# a_1690_19738# 0.18796f
C8471 sg13cmos5l_dfrbpq_1_41.CLK sg13cmos5l_buf_8_2.A 0.0809f
C8472 sg13cmos5l_a21oi_1_5.A2 sg13cmos5l_inv_1_2.A 0.08932f
C8473 sg13cmos5l_nand4_1_7.B sg13cmos5l_a21oi_1_16.A2 0.06582f
C8474 sg13cmos5l_nand2b_1_3.Y sg13cmos5l_nand2b_1_3.B 0.2101f
C8475 sg13cmos5l_nor3_1_6.Y sg13cmos5l_nor4_1_1.D 0.31783f
C8476 sg13cmos5l_nand4_1_1.A sg13cmos5l_a21oi_1_13.A2 0.1642f
C8477 sg13cmos5l_buf_8_2.A sg13cmos5l_nand4_1_1.A 0.02577f
C8478 a_20984_10702# sg13cmos5l_dfrbpq_1_5.Q 0.32578f
C8479 sg13cmos5l_mux2_1_0.S a_10833_14874# 0.0801f
C8480 a_12844_5850# VDD 0.14903f
C8481 sg13cmos5l_dfrbpq_1_24.Q sg13cmos5l_a21oi_1_27.A2 0.1155f
C8482 sg13cmos5l_nand4_1_6.B sg13cmos5l_buf_1_43.X 0.1533f
C8483 sg13cmos5l_nand4_1_7.B sg13cmos5l_inv_1_16.Y 0.0139f
C8484 sg13cmos5l_dfrbpq_1_38.Q sg13cmos5l_buf_1_42.A 0.01992f
C8485 sg13cmos5l_inv_1_14.Y sg13cmos5l_buf_1_8.A 0.0935f
C8486 sg13cmos5l_buf_8_2.A sg13cmos5l_dfrbpq_1_11.Q 0.01938f
C8487 sg13cmos5l_nand4_1_3.B sg13cmos5l_a21oi_1_16.A2 0.01033f
C8488 a_16836_20088# VDD 0.0721f
C8489 a_3415_16710# a_3319_15960# 0.01013f
C8490 a_4838_9186# VDD 0.52814f
C8491 sg13cmos5l_buf_8_2.A sg13cmos5l_dlygate4sd3_1_72.A 0.15197f
C8492 sg13cmos5l_inv_1_6.Y a_20294_4650# 0.01833f
C8493 sg13cmos5l_nand3_1_0.Y a_17316_8440# 0.04555f
C8494 sg13cmos5l_buf_1_7.X a_18778_6130# 0.02784f
C8495 sg13cmos5l_dfrbpq_1_13.RESET_B a_7275_11471# 0.28133f
C8496 sg13cmos5l_nand2_1_9.Y a_8698_16366# 0.01503f
C8497 sg13cmos5l_nor3_1_2.B a_10474_9916# 0.0262f
C8498 sg13cmos5l_nand4_1_17.Y sg13cmos5l_buf_1_43.X 0.05174f
C8499 sg13cmos5l_buf_1_47.X sg13cmos5l_nand2_1_12.A 0.2355f
C8500 sg13cmos5l_nand4_1_8.B sg13cmos5l_nor4_1_1.D 0.35195f
C8501 sg13cmos5l_a21o_1_1.A2 sg13cmos5l_nor3_1_2.B 0.91453f
C8502 sg13cmos5l_dlygate4sd3_1_18.A a_19342_10215# 0.01596f
C8503 sg13cmos5l_o21ai_1_5.A2 a_16085_12508# 0.0834f
C8504 sg13cmos5l_inv_1_32.Y sg13cmos5l_buf_1_59.A 0.02048f
C8505 sg13cmos5l_nand4_1_3.B sg13cmos5l_inv_1_16.Y 0.04819f
C8506 a_17412_6928# a_17829_6935# 0.28418f
C8507 a_17126_7362# a_17700_7349# 0.18486f
C8508 VDD code7 0.25591f
C8509 sg13cmos5l_a21oi_1_2.A2 a_16838_9948# 0.02085f
C8510 sg13cmos5l_nor2b_1_1.A sg13cmos5l_buf_1_65.A 0.25925f
C8511 sg13cmos5l_dfrbpq_1_5.CLK sg13cmos5l_dlygate4sd3_1_71.X 0.01858f
C8512 sg13cmos5l_buf_1_26.A sg13cmos5l_o21ai_1_28.A1 0.02649f
C8513 a_18574_14751# VDD 0.16166f
C8514 sg13cmos5l_dfrbpq_1_37.D a_21084_18222# 0.01361f
C8515 a_7048_16082# VDD 0.13642f
C8516 a_13191_5499# a_13994_5692# 0.07823f
C8517 sg13cmos5l_nor3_1_2.Y a_5829_8436# 0.02512f
C8518 sg13cmos5l_nor4_1_2.Y sg13cmos5l_nand4_1_18.D 0.0157f
C8519 a_16172_15960# code1 0.04133f
C8520 a_6448_19262# a_6191_19381# 0.23043f
C8521 sg13cmos5l_buf_1_63.A sg13cmos5l_o21ai_1_5.A2 0.01495f
C8522 sg13cmos5l_nor3_1_6.Y sg13cmos5l_inv_1_36.Y 0.01046f
C8523 sg13cmos5l_inv_1_17.A a_21745_12287# 0.01704f
C8524 sg13cmos5l_buf_1_45.X sg13cmos5l_nand2_1_18.A 0.03693f
C8525 a_10954_18481# a_10980_18576# 0.24169f
C8526 sg13cmos5l_buf_1_10.A a_20580_8440# 0.01124f
C8527 sg13cmos5l_o21ai_1_1.Y a_14230_7670# 0.0663f
C8528 sg13cmos5l_and2_1_3.X sg13cmos5l_nand3_1_0.B 0.07967f
C8529 a_17445_15213# a_17434_14448# 0.01088f
C8530 sg13cmos5l_dfrbpq_1_13.CLK sg13cmos5l_nand2_1_0.A 0.15161f
C8531 a_20580_12528# a_21099_12332# 0.20773f
C8532 a_22096_11702# a_22506_11460# 0.07015f
C8533 a_7050_9484# sg13cmos5l_nor3_1_2.Y 0.01013f
C8534 sg13cmos5l_inv_1_24.A a_12381_13912# 0.02767f
C8535 sg13cmos5l_o21ai_1_1.B1 sg13cmos5l_a22oi_1_0.B2 0.31072f
C8536 sg13cmos5l_nor2b_1_0.B_N sg13cmos5l_buf_1_14.A 0.25788f
C8537 sg13cmos5l_nand2_1_19.Y sg13cmos5l_nand2b_1_1.A_N 0.13276f
C8538 sg13cmos5l_o21ai_1_5.A2 a_12616_14484# 0.02118f
C8539 a_21070_7863# bp2 0.01377f
C8540 a_14536_14484# VDD 0.17871f
C8541 sg13cmos5l_buf_1_16.A sg13cmos5l_buf_1_57.A 0.32891f
C8542 sg13cmos5l_dfrbpq_1_19.CLK a_7238_19458# 0.02448f
C8543 a_20503_15960# a_21063_16083# 0.17382f
C8544 sg13cmos5l_a21oi_1_24.A1 a_10954_18481# 0.01206f
C8545 sg13cmos5l_dlygate4sd3_1_76.X a_19930_12936# 0.04949f
C8546 sg13cmos5l_o21ai_1_26.B1 sg13cmos5l_buf_1_26.A 0.98592f
C8547 sg13cmos5l_buf_1_10.A sg13cmos5l_inv_1_5.A 0.02089f
C8548 a_12134_19458# a_12394_18988# 0.45119f
C8549 sg13cmos5l_a21oi_1_24.A1 a_9848_18262# 0.01128f
C8550 bn4 bn5 0.08797f
C8551 code1 busy 0.09857f
C8552 bn2 bn0 0.01546f
C8553 sg13cmos5l_a21oi_1_24.A1 busy 0.02933f
C8554 bn3 code0 0.01549f
C8555 sg13cmos5l_a21oi_1_18.B1 a_17038_14751# 0.01775f
C8556 sg13cmos5l_buf_1_3.A bp8 0.02708f
C8557 sg13cmos5l_a21o_1_2.B1 a_7446_14508# 0.01436f
C8558 sg13cmos5l_nor2b_1_0.B_N a_15610_9912# 0.02137f
C8559 sg13cmos5l_nand4_1_7.B code1 0.04879f
C8560 sg13cmos5l_buf_1_16.A sg13cmos5l_nand2_1_1.A 0.03f
C8561 sg13cmos5l_nand4_1_18.B sg13cmos5l_nor4_1_2.Y 0.0125f
C8562 a_10053_12189# VDD 0.25067f
C8563 a_7841_8702# VDD 0.20651f
C8564 sg13cmos5l_inv_1_18.A sg13cmos5l_a21o_1_0.A1 0.17009f
C8565 a_9636_12528# a_10801_12287# 0.25046f
C8566 a_10155_12332# a_9924_12223# 0.07823f
C8567 sg13cmos5l_buf_1_1.A a_21839_7285# 0.03818f
C8568 a_22005_16043# sg13cmos5l_inv_1_25.Y 0.0292f
C8569 sg13cmos5l_nor4_1_2.Y code0 0.02347f
C8570 a_13191_5499# VDD 0.21605f
C8571 sg13cmos5l_and4_1_0.D sg13cmos5l_dfrbpq_1_47.Q 0.06458f
C8572 sg13cmos5l_o21ai_1_9.A2 a_8026_14854# 0.01547f
C8573 sg13cmos5l_o21ai_1_28.Y a_12406_15230# 0.06506f
C8574 a_21099_11471# VDD 0.20496f
C8575 a_6640_9406# VDD 0.13544f
C8576 sg13cmos5l_nor2_1_6.Y a_4838_15238# 0.01021f
C8577 VDD bn5 0.70691f
C8578 sg13cmos5l_a21oi_1_1.A2 sg13cmos5l_dfrbpq_1_0.D 0.60746f
C8579 sg13cmos5l_nand3_1_2.Y sg13cmos5l_nand2_1_18.A 0.13483f
C8580 sg13cmos5l_nand3_1_3.Y sg13cmos5l_and4_1_0.D 0.78916f
C8581 sg13cmos5l_nand3_1_0.Y a_18575_8797# 0.01093f
C8582 sg13cmos5l_dfrbpq_1_13.RESET_B a_9260_11424# 0.0489f
C8583 a_13670_15238# a_13782_15302# 0.3854f
C8584 sg13cmos5l_nor3_1_2.B a_10788_10373# 0.02089f
C8585 sg13cmos5l_nor3_1_4.A sg13cmos5l_mux2_1_1.A1 0.62422f
C8586 sg13cmos5l_a21oi_1_2.A2 a_16725_7832# 0.01514f
C8587 a_9716_15202# VDD 0.21363f
C8588 sg13cmos5l_nor3_1_2.B sg13cmos5l_inv_1_18.Y 0.30511f
C8589 sg13cmos5l_nand3_1_4.Y sg13cmos5l_a21oi_1_10.A2 0.01238f
C8590 sg13cmos5l_nand4_1_1.A sg13cmos5l_a21oi_1_15.Y 0.10369f
C8591 sg13cmos5l_nand4_1_15.B sg13cmos5l_mux2_1_0.A1 0.27132f
C8592 a_12987_12214# clk 0.35203f
C8593 a_9934_9375# a_10049_9376# 0.3854f
C8594 sg13cmos5l_nor3_1_6.Y sg13cmos5l_nand2_1_1.Y 0.03827f
C8595 sg13cmos5l_inv_1_15.Y sg13cmos5l_a21oi_1_2.A2 0.04494f
C8596 sg13cmos5l_buf_8_2.A sg13cmos5l_dfrbpq_1_3.D 0.05544f
C8597 sg13cmos5l_inv_1_1.Y a_20294_14922# 0.02321f
C8598 sg13cmos5l_nand3_1_0.B sg13cmos5l_inv_1_5.A 0.06693f
C8599 sg13cmos5l_nand3_1_0.C sg13cmos5l_nand3_1_0.Y 0.40472f
C8600 sg13cmos5l_nand4_1_15.B bn6 0.01309f
C8601 sg13cmos5l_dfrbpq_1_24.RESET_B sg13cmos5l_dfrbpq_1_15.CLK 0.14564f
C8602 a_2156_19734# VDD 0.22965f
C8603 sg13cmos5l_a21oi_1_23.A2 VDD 0.58699f
C8604 sg13cmos5l_a21oi_1_6.A2 a_19457_10214# 0.03423f
C8605 sg13cmos5l_inv_1_15.Y sg13cmos5l_a21oi_1_6.A2 0.01992f
C8606 a_13994_5692# a_14039_5459# 0.18486f
C8607 sg13cmos5l_inv_1_15.A sg13cmos5l_inv_1_15.Y 0.16924f
C8608 sg13cmos5l_and4_1_1.A sg13cmos5l_mux2_1_0.S 1.54164f
C8609 sg13cmos5l_buf_1_0.A a_20406_6230# 0.03746f
C8610 sg13cmos5l_o21ai_1_5.A1 sg13cmos5l_nor3_1_6.Y 0.03249f
C8611 sg13cmos5l_nand4_1_18.B sg13cmos5l_o21ai_1_18.A2 0.05801f
C8612 sg13cmos5l_dfrbpq_1_41.CLK sg13cmos5l_buf_1_16.A 0.05067f
C8613 sg13cmos5l_buf_1_63.A a_13958_19770# 0.01467f
C8614 sg13cmos5l_buf_1_29.A VDD 0.20636f
C8615 sg13cmos5l_a21oi_1_2.Y bp3 0.01006f
C8616 sg13cmos5l_buf_1_16.A sg13cmos5l_nand4_1_1.A 0.01539f
C8617 sg13cmos5l_nand2_1_3.Y sg13cmos5l_nor2_1_2.A 0.23586f
C8618 a_10980_18576# a_12239_18335# 0.01412f
C8619 sg13cmos5l_inv_1_17.Y bp4 0.04212f
C8620 a_10696_15272# a_11180_15198# 0.01737f
C8621 sg13cmos5l_inv_1_2.Y sg13cmos5l_inv_1_0.A 0.03784f
C8622 sg13cmos5l_dfrbpq_1_33.D sg13cmos5l_a21oi_1_24.A1 0.02112f
C8623 sg13cmos5l_dfrbpq_1_15.CLK a_5604_12976# 0.08961f
C8624 sg13cmos5l_dfrbpq_1_33.D code1 0.12478f
C8625 a_20580_12528# a_20868_12223# 0.24435f
C8626 sg13cmos5l_buf_1_16.A sg13cmos5l_dfrbpq_1_11.Q 0.62637f
C8627 sg13cmos5l_dfrbpq_1_15.Q a_7726_8703# 0.01072f
C8628 a_13015_13686# a_13486_13722# 0.16704f
C8629 sg13cmos5l_inv_1_20.Y sg13cmos5l_a21oi_1_2.B1 0.03737f
C8630 sg13cmos5l_inv_1_8.A a_15480_8752# 0.01147f
C8631 sg13cmos5l_o21ai_1_19.Y a_7498_18226# 0.06039f
C8632 sg13cmos5l_buf_1_16.A sg13cmos5l_dlygate4sd3_1_72.A 0.57107f
C8633 sg13cmos5l_nand4_1_8.B sg13cmos5l_o21ai_1_5.A1 0.2277f
C8634 sg13cmos5l_nor4_1_1.D sg13cmos5l_dfrbpq_1_24.Q 0.18107f
C8635 a_21084_16357# a_21911_16043# 0.26205f
C8636 sg13cmos5l_dfrbpq_1_19.CLK a_7812_19445# 0.01505f
C8637 sg13cmos5l_buf_1_15.A sg13cmos5l_a21oi_1_4.A1 0.1312f
C8638 sg13cmos5l_inv_1_15.Y sg13cmos5l_a21oi_1_17.Y 0.05281f
C8639 a_15480_8752# sg13cmos5l_a22oi_1_2.Y 0.09767f
C8640 a_19930_15960# a_19649_16262# 0.18796f
C8641 sg13cmos5l_buf_1_15.A a_21911_16043# 0.07358f
C8642 sg13cmos5l_buf_1_66.X sg13cmos5l_dfrbpq_1_18.Q 0.04429f
C8643 a_11152_12430# VDD 0.13942f
C8644 a_4740_14488# a_5259_14495# 0.20754f
C8645 a_21089_6352# bp2 0.03839f
C8646 sg13cmos5l_nand4_1_7.B sg13cmos5l_nor4_1_4.C 0.09253f
C8647 sg13cmos5l_o21ai_1_4.A1 a_12430_6980# 0.01411f
C8648 sg13cmos5l_inv_1_18.A a_14264_10702# 0.01045f
C8649 sg13cmos5l_a21oi_1_20.A2 a_16742_15234# 0.0235f
C8650 sg13cmos5l_dfrbpq_1_34.Q bn2 0.48972f
C8651 sg13cmos5l_inv_1_6.Y bp3 0.03151f
C8652 sg13cmos5l_a21o_1_0.A2 VDD 0.33617f
C8653 sg13cmos5l_o21ai_1_5.A2 sg13cmos5l_nand2_1_15.B 0.17017f
C8654 a_15496_5498# VDD 0.12051f
C8655 sg13cmos5l_buf_8_2.A bn3 0.01942f
C8656 sg13cmos5l_dfrbpq_1_19.D a_5686_16374# 0.0211f
C8657 sg13cmos5l_buf_1_15.A sg13cmos5l_o21ai_1_18.B1 0.01459f
C8658 a_9096_15996# a_9832_16082# 0.01572f
C8659 a_10895_12287# a_10801_12287# 0.16704f
C8660 sg13cmos5l_o21ai_1_0.A1 sg13cmos5l_a22oi_1_2.Y 0.06373f
C8661 sg13cmos5l_o21ai_1_0.A1 a_13434_6887# 0.02531f
C8662 sg13cmos5l_nor4_1_4.C sg13cmos5l_nand4_1_3.B 0.01226f
C8663 sg13cmos5l_a21oi_1_0.A2 a_18577_7285# 0.01869f
C8664 a_14039_5459# VDD 0.5247f
C8665 sg13cmos5l_a21oi_1_2.A2 sg13cmos5l_buf_1_7.X 0.06911f
C8666 sg13cmos5l_dfrbpq_1_28.RESET_B a_15784_15272# 0.16622f
C8667 sg13cmos5l_inv_1_15.Y sg13cmos5l_nand4_1_5.D 0.03038f
C8668 sg13cmos5l_a21oi_1_4.A2 sg13cmos5l_buf_1_53.A 0.01481f
C8669 sg13cmos5l_dlygate4sd3_1_64.X sg13cmos5l_o21ai_1_21.A2 0.34279f
C8670 sg13cmos5l_dfrbpq_1_18.Q VDD 0.65334f
C8671 sg13cmos5l_a21oi_1_1.A2 a_19457_10214# 0.04706f
C8672 sg13cmos5l_dlygate4sd3_1_20.A VDD 0.42759f
C8673 sg13cmos5l_buf_1_15.A sg13cmos5l_dfrbpq_1_28.RESET_B 0.10009f
C8674 sg13cmos5l_nor4_1_2.Y a_18780_13730# 0.01114f
C8675 sg13cmos5l_o21ai_1_9.A2 sg13cmos5l_mux2_1_0.A1 0.14834f
C8676 a_8411_15532# VDD 0.18392f
C8677 sg13cmos5l_buf_1_15.A sg13cmos5l_mux2_1_1.A1 0.65658f
C8678 sg13cmos5l_dfrbpq_1_24.RESET_B a_3415_16710# 0.1115f
C8679 sg13cmos5l_buf_8_2.A sg13cmos5l_nor4_1_2.Y 0.04694f
C8680 sg13cmos5l_inv_1_15.A sg13cmos5l_buf_1_7.X 0.22843f
C8681 sg13cmos5l_buf_1_43.X VDD 0.87475f
C8682 sg13cmos5l_nand3_1_0.Y a_15804_7638# 0.03765f
C8683 a_18671_7285# a_19338_6924# 0.09257f
C8684 sg13cmos5l_inv_1_19.Y a_8671_7656# 0.01871f
C8685 sg13cmos5l_o21ai_1_23.A2 a_14378_15532# 0.01511f
C8686 sg13cmos5l_inv_1_8.Y sg13cmos5l_inv_1_5.Y 0.04154f
C8687 sg13cmos5l_nand2_1_12.A sg13cmos5l_o21ai_1_24.Y 0.09695f
C8688 sg13cmos5l_a21oi_1_27.B1 sg13cmos5l_o21ai_1_7.A2 0.08268f
C8689 sg13cmos5l_dlygate4sd3_1_4.A a_20554_4873# 0.01974f
C8690 sg13cmos5l_nor2b_1_1.A sg13cmos5l_o21ai_1_14.A1 0.15864f
C8691 sg13cmos5l_o21ai_1_5.A2 sg13cmos5l_nor3_1_6.Y 1.24161f
C8692 sg13cmos5l_dfrbpq_1_24.Q a_9064_14570# 0.01721f
C8693 sg13cmos5l_nor3_1_2.B sg13cmos5l_nand3_1_4.Y 0.15332f
C8694 sg13cmos5l_dlygate4sd3_1_43.A a_7520_7010# 0.03907f
C8695 sg13cmos5l_inv_1_1.Y a_20176_7894# 0.01491f
C8696 sg13cmos5l_buf_8_2.A a_13015_13686# 0.01209f
C8697 sg13cmos5l_o21ai_1_7.Y sg13cmos5l_o21ai_1_19.Y 0.01457f
C8698 sg13cmos5l_buf_1_9.A sg13cmos5l_nor2b_1_2.Y 0.01225f
C8699 sg13cmos5l_inv_1_1.Y a_19173_17519# 0.01271f
C8700 sg13cmos5l_o21ai_1_23.B1 sg13cmos5l_nand4_1_6.B 0.02997f
C8701 sg13cmos5l_nand2b_1_4.Y sg13cmos5l_nand2_1_3.Y 0.01297f
C8702 sg13cmos5l_mux2_1_0.S clk 0.02253f
C8703 a_7238_19458# a_7524_19024# 0.26205f
C8704 a_15104_13058# VDD 0.07873f
C8705 a_11499_18380# a_11268_18271# 0.07823f
C8706 a_10980_18576# a_12145_18335# 0.25046f
C8707 a_12239_18335# a_12906_18556# 0.09257f
C8708 sg13cmos5l_a21oi_1_27.B1 sg13cmos5l_mux2_1_0.A1 0.02344f
C8709 sg13cmos5l_buf_1_13.A a_17126_7362# 0.01069f
C8710 sg13cmos5l_dfrbpq_1_45.D a_6470_11898# 0.16933f
C8711 sg13cmos5l_or4_1_0.D a_8122_8400# 0.31418f
C8712 a_21839_12287# a_21745_12287# 0.16704f
C8713 a_8296_4782# VDD 0.17305f
C8714 sg13cmos5l_dlygate4sd3_1_3.A bp7 0.0253f
C8715 sg13cmos5l_nand4_1_17.Y sg13cmos5l_o21ai_1_23.B1 0.4372f
C8716 sg13cmos5l_nand4_1_8.B sg13cmos5l_o21ai_1_5.A2 0.59713f
C8717 sg13cmos5l_nand4_1_18.B a_18104_12218# 0.01164f
C8718 sg13cmos5l_nand2b_1_0.B sg13cmos5l_nand2b_1_1.A_N 0.8801f
C8719 sg13cmos5l_dfrbpq_1_19.CLK a_4455_18476# 0.04601f
C8720 a_12837_19031# a_13585_19381# 0.01058f
C8721 sg13cmos5l_dfrbpq_1_28.Q bn8 0.09378f
C8722 sg13cmos5l_nor3_1_0.Y a_15197_10996# 0.02954f
C8723 sg13cmos5l_o21ai_1_13.B1 VDD 0.34612f
C8724 a_13014_17532# VDD 0.1816f
C8725 sg13cmos5l_nand2_1_19.Y VDD 0.52624f
C8726 sg13cmos5l_o21ai_1_5.A1 a_9924_12223# 0.01081f
C8727 sg13cmos5l_o21ai_1_14.Y a_7350_17532# 0.0629f
C8728 a_20503_15960# VDD 0.17059f
C8729 a_17028_15552# a_17445_15213# 0.28324f
C8730 a_16742_15234# a_17547_15356# 0.07916f
C8731 sg13cmos5l_nor2b_1_2.Y sg13cmos5l_dfrbpq_1_47.D 0.02806f
C8732 a_11274_20068# a_11756_19734# 0.01735f
C8733 sg13cmos5l_nand2b_1_3.Y a_11474_7972# 0.02124f
C8734 sg13cmos5l_a21oi_1_7.A2 a_20580_12528# 0.03883f
C8735 a_14761_15238# VDD 0.24945f
C8736 sg13cmos5l_buf_1_45.X a_13738_15964# 0.19444f
C8737 sg13cmos5l_a21oi_1_1.A2 sg13cmos5l_buf_1_7.X 0.038f
C8738 sg13cmos5l_buf_1_17.X a_1294_9375# 0.05833f
C8739 sg13cmos5l_nor2_1_10.Y a_10118_18262# 0.06912f
C8740 sg13cmos5l_buf_1_8.A sg13cmos5l_inv_1_7.Y 0.02037f
C8741 sg13cmos5l_buf_1_7.X a_20997_4629# 0.036f
C8742 sg13cmos5l_a21oi_1_5.A2 sg13cmos5l_nor3_1_7.Y 0.01013f
C8743 sg13cmos5l_dlygate4sd3_1_65.A a_9185_18448# 0.01984f
C8744 sg13cmos5l_a21oi_1_18.B1 a_16742_15234# 0.05111f
C8745 sg13cmos5l_inv_1_17.Y a_20176_10918# 0.0111f
C8746 sg13cmos5l_o21ai_1_5.A1 sg13cmos5l_dfrbpq_1_24.Q 0.02884f
C8747 sg13cmos5l_buf_1_1.A sg13cmos5l_a21oi_1_0.A2 0.32651f
C8748 sg13cmos5l_buf_1_66.X sg13cmos5l_a21o_1_2.A1 0.68726f
C8749 sg13cmos5l_dlygate4sd3_1_50.X code8 0.01852f
C8750 sg13cmos5l_a21oi_1_7.A2 sg13cmos5l_dfrbpq_1_5.Q 0.02345f
C8751 sg13cmos5l_buf_1_10.A a_11665_10309# 0.01731f
C8752 sg13cmos5l_a21oi_1_4.A2 sg13cmos5l_nand4_1_3.D 0.02555f
C8753 sg13cmos5l_nand2_1_15.B sg13cmos5l_dfrbpq_1_13.CLK 0.03429f
C8754 sg13cmos5l_nand3_1_8.Y sg13cmos5l_inv_1_12.Y 0.12316f
C8755 sg13cmos5l_inv_1_2.A a_20294_4650# 0.01081f
C8756 sg13cmos5l_o21ai_1_5.A1 sg13cmos5l_inv_1_25.Y 0.04126f
C8757 a_21953_19960# a_22234_19738# 0.18796f
C8758 sg13cmos5l_buf_1_65.A sg13cmos5l_a21oi_1_27.A2 0.74664f
C8759 sg13cmos5l_inv_1_2.A sg13cmos5l_dlygate4sd3_1_22.A 0.10955f
C8760 sg13cmos5l_dfrbpq_1_24.RESET_B a_4917_16904# 0.20753f
C8761 a_16356_5416# a_16773_5423# 0.28418f
C8762 a_16070_5850# a_16875_5423# 0.07916f
C8763 sg13cmos5l_o21ai_1_0.A2 sg13cmos5l_inv_1_18.Y 0.02486f
C8764 sg13cmos5l_nor2b_1_1.A sg13cmos5l_o21ai_1_10.A2 0.06413f
C8765 sg13cmos5l_a21oi_1_27.A1 sg13cmos5l_dfrbpq_1_13.RESET_B 0.08339f
C8766 a_21370_19738# sg13cmos5l_buf_1_25.A 0.05151f
C8767 sg13cmos5l_nand4_1_1.C sg13cmos5l_inv_1_12.Y 0.02177f
C8768 sg13cmos5l_inv_1_12.A a_21099_9959# 0.02189f
C8769 sg13cmos5l_nand4_1_3.B sg13cmos5l_a21oi_1_3.A2 0.01098f
C8770 sg13cmos5l_buf_1_54.A sg13cmos5l_a21oi_1_4.A1 0.01099f
C8771 sg13cmos5l_nand4_1_1.C a_15976_12972# 0.02173f
C8772 sg13cmos5l_a21o_1_2.A1 VDD 0.39102f
C8773 sg13cmos5l_dlygate4sd3_1_13.A a_17240_10702# 0.26993f
C8774 a_7524_19024# a_7812_19445# 0.24435f
C8775 sg13cmos5l_buf_1_16.A a_19120_11702# 0.04008f
C8776 a_8321_9376# a_8602_9154# 0.18796f
C8777 sg13cmos5l_inv_1_32.Y sg13cmos5l_nand4_1_6.B 0.02108f
C8778 sg13cmos5l_nor2_1_2.B a_10878_7180# 0.09329f
C8779 sg13cmos5l_inv_1_32.Y a_13676_12936# 0.06085f
C8780 sg13cmos5l_dfrbpq_1_28.RESET_B a_20580_14488# 0.27325f
C8781 sg13cmos5l_o21ai_1_1.B1 sg13cmos5l_nand2_1_0.A 0.01869f
C8782 sg13cmos5l_buf_1_24.A sg13cmos5l_dlygate4sd3_1_56.X 0.02988f
C8783 sg13cmos5l_a21oi_1_27.B1 sg13cmos5l_nand3b_1_1.C 0.18531f
C8784 sg13cmos5l_o21ai_1_18.B1 sg13cmos5l_o21ai_1_20.A1 0.07604f
C8785 sg13cmos5l_buf_1_53.A sg13cmos5l_nand4_1_1.A 0.03365f
C8786 a_12712_4782# VDD 0.17866f
C8787 sg13cmos5l_dlygate4sd3_1_64.X sg13cmos5l_nand3b_1_3.C 0.11742f
C8788 sg13cmos5l_nor3_1_6.Y sg13cmos5l_dfrbpq_1_13.CLK 0.01862f
C8789 sg13cmos5l_or4_1_0.C sg13cmos5l_nor3_1_2.A 0.02168f
C8790 a_19246_19959# sg13cmos5l_dfrbpq_1_40.Q 0.01422f
C8791 a_18954_15532# a_19336_15366# 0.01648f
C8792 sg13cmos5l_nand3_1_2.Y sg13cmos5l_buf_1_20.A 0.08689f
C8793 sg13cmos5l_and4_1_1.A sg13cmos5l_dlygate4sd3_1_45.X 0.06589f
C8794 sg13cmos5l_dfrbpq_1_28.RESET_B a_18470_17946# 0.07532f
C8795 sg13cmos5l_buf_1_65.A a_10389_16258# 0.17007f
C8796 sg13cmos5l_dlygate4sd3_1_72.A sg13cmos5l_buf_1_53.A 0.04946f
C8797 sg13cmos5l_buf_1_16.A sg13cmos5l_nor4_1_2.Y 0.09257f
C8798 sg13cmos5l_inv_1_17.A bn8 0.0687f
C8799 sg13cmos5l_dfrbpq_1_13.CLK sg13cmos5l_inv_1_9.Y 0.01686f
C8800 sg13cmos5l_nand2_1_13.A sg13cmos5l_nand2_1_13.Y 0.13246f
C8801 sg13cmos5l_nand3_1_2.A sg13cmos5l_inv_1_18.A 0.19285f
C8802 sg13cmos5l_inv_1_1.A sg13cmos5l_a21oi_1_0.A2 0.01562f
C8803 a_22126_9375# bp1 0.04453f
C8804 sg13cmos5l_and2_1_3.X sg13cmos5l_nand2_1_1.Y 0.05744f
C8805 sg13cmos5l_dfrbpq_1_28.RESET_B sg13cmos5l_buf_1_54.A 0.09586f
C8806 sg13cmos5l_o21ai_1_1.Y sg13cmos5l_buf_1_0.A 0.09923f
C8807 sg13cmos5l_buf_1_4.A bp3 0.01841f
C8808 sg13cmos5l_o21ai_1_1.Y a_14657_7190# 0.01101f
C8809 sg13cmos5l_nor2_1_15.Y a_13764_16000# 0.02205f
C8810 a_5345_19960# a_5626_19738# 0.18796f
C8811 a_17028_15552# a_18287_15311# 0.01412f
C8812 sg13cmos5l_inv_1_1.Y a_20464_5654# 0.01351f
C8813 sg13cmos5l_nand2_1_1.A sg13cmos5l_a21oi_1_2.B1 0.0223f
C8814 sg13cmos5l_inv_1_1.A sg13cmos5l_inv_1_14.Y 0.02057f
C8815 a_14438_6162# a_15141_6141# 0.02453f
C8816 sg13cmos5l_buf_1_45.X a_15280_16238# 0.0963f
C8817 sg13cmos5l_inv_1_5.A a_15680_5498# 0.01825f
C8818 sg13cmos5l_dfrbpq_1_28.D a_20294_12210# 0.16818f
C8819 sg13cmos5l_o21ai_1_11.B1 sg13cmos5l_o21ai_1_12.Y 0.06124f
C8820 a_9348_20088# a_10513_19847# 0.25046f
C8821 sg13cmos5l_inv_1_18.A a_13590_11484# 0.10721f
C8822 a_9867_19892# a_9636_19783# 0.07823f
C8823 a_18730_18988# a_19173_19031# 0.02241f
C8824 sg13cmos5l_a21oi_1_4.A1 sg13cmos5l_o21ai_1_9.B1 0.0398f
C8825 sg13cmos5l_buf_1_47.X a_10980_18576# 0.05335f
C8826 sg13cmos5l_nand2_1_12.Y a_12632_17549# 0.26604f
C8827 sg13cmos5l_nand2b_1_1.A_N sg13cmos5l_nand2b_1_3.B 0.16741f
C8828 sg13cmos5l_nor2_1_3.Y a_12045_11808# 0.23943f
C8829 sg13cmos5l_buf_1_47.X sg13cmos5l_a21oi_1_24.A1 1.15461f
C8830 sg13cmos5l_dfrbpq_1_20.D sg13cmos5l_o21ai_1_11.Y 0.02206f
C8831 sg13cmos5l_o21ai_1_5.A2 sg13cmos5l_inv_1_25.Y 0.0177f
C8832 sg13cmos5l_dfrbpq_1_13.CLK sg13cmos5l_nor4_1_0.C 0.15258f
C8833 sg13cmos5l_buf_1_15.A a_21084_16357# 0.28543f
C8834 sg13cmos5l_a21oi_1_24.A2 bn5 0.02164f
C8835 sg13cmos5l_a21oi_1_18.B1 sg13cmos5l_a21oi_1_26.A1 0.18309f
C8836 sg13cmos5l_buf_1_26.A sg13cmos5l_dfrbpq_1_28.RESET_B 0.35623f
C8837 sg13cmos5l_dlygate4sd3_1_82.A a_17717_19020# 0.11011f
C8838 sg13cmos5l_o21ai_1_18.B1 a_9846_17532# 0.10991f
C8839 sg13cmos5l_a21oi_1_15.Y a_19448_12214# 0.27974f
C8840 sg13cmos5l_o21ai_1_17.B1 sg13cmos5l_dlygate4sd3_1_56.X 0.01398f
C8841 a_16356_5416# a_17521_5773# 0.25046f
C8842 sg13cmos5l_nor3_1_6.Y a_4264_14570# 0.01271f
C8843 sg13cmos5l_dfrbpq_1_13.CLK a_13343_5383# 0.20351f
C8844 sg13cmos5l_dlygate4sd3_1_82.A sg13cmos5l_a21oi_1_26.A1 0.38717f
C8845 sg13cmos5l_buf_1_25.A sg13cmos5l_dfrbpq_1_5.CLK 0.01617f
C8846 sg13cmos5l_buf_1_13.X sg13cmos5l_inv_1_4.Y 0.72552f
C8847 sg13cmos5l_nand4_1_18.D a_17621_12972# 0.02654f
C8848 a_22241_7864# VDD 0.20472f
C8849 sg13cmos5l_buf_1_25.A sg13cmos5l_a21oi_1_18.B1 1.0874f
C8850 a_16193_19286# sg13cmos5l_a21oi_1_18.B1 0.04091f
C8851 sg13cmos5l_nand4_1_1.C a_18689_14750# 0.01966f
C8852 sg13cmos5l_nand4_1_1.A a_18206_14850# 0.01771f
C8853 a_20997_9959# a_21099_9959# 0.3643f
C8854 sg13cmos5l_nand3_1_2.Y sg13cmos5l_inv_1_18.A 0.33527f
C8855 sg13cmos5l_a21oi_1_26.Y sg13cmos5l_a21oi_1_18.B1 0.81588f
C8856 sg13cmos5l_a21oi_1_2.B1 a_21745_8797# 0.01757f
C8857 a_17338_18984# a_17057_19286# 0.18796f
C8858 sg13cmos5l_inv_1_14.Y a_19642_6130# 0.05661f
C8859 a_8043_19031# a_9040_19262# 0.03546f
C8860 sg13cmos5l_or4_1_0.C a_10049_9376# 0.02049f
C8861 sg13cmos5l_a21oi_1_6.A2 a_19077_10677# 0.02743f
C8862 sg13cmos5l_inv_1_1.Y sg13cmos5l_dfrbpq_1_7.D 0.05408f
C8863 a_19179_7796# VDD 0.20439f
C8864 sg13cmos5l_buf_1_16.A a_19448_12214# 0.04583f
C8865 a_6470_11898# a_7173_11471# 0.02431f
C8866 sg13cmos5l_buf_1_26.A bn1 0.01926f
C8867 sg13cmos5l_o21ai_1_20.Y sg13cmos5l_dfrbpq_1_23.Q 0.01175f
C8868 sg13cmos5l_o21ai_1_23.B1 VDD 0.80759f
C8869 sg13cmos5l_nand4_1_3.D sg13cmos5l_nand4_1_1.A 1.48356f
C8870 a_14283_16007# code0 0.01422f
C8871 sg13cmos5l_nand2_1_15.B sg13cmos5l_mux2_1_0.A1 0.0131f
C8872 a_17733_8447# VDD 0.2473f
C8873 sg13cmos5l_inv_1_1.Y a_20580_9952# 0.04338f
C8874 sg13cmos5l_a21oi_1_1.A2 bp4 0.0121f
C8875 sg13cmos5l_o21ai_1_8.B1 a_7048_16082# 0.01856f
C8876 sg13cmos5l_inv_1_7.A a_20513_4166# 0.01127f
C8877 sg13cmos5l_inv_1_17.A a_22096_13942# 0.01324f
C8878 sg13cmos5l_dfrbpq_1_13.RESET_B a_9322_5380# 0.17612f
C8879 a_17633_10214# VDD 0.20572f
C8880 a_15000_8416# VDD 0.01828f
C8881 bp0 bn8 0.0171f
C8882 sg13cmos5l_dlygate4sd3_1_0.A bp9 0.04209f
C8883 sg13cmos5l_buf_1_65.A sg13cmos5l_nor4_1_1.D 0.1643f
C8884 sg13cmos5l_buf_1_42.A sg13cmos5l_dfrbpq_1_30.Q 0.05105f
C8885 sg13cmos5l_o21ai_1_25.B1 code1 0.05002f
C8886 sg13cmos5l_o21ai_1_25.B1 sg13cmos5l_a21oi_1_24.A1 0.01595f
C8887 sg13cmos5l_inv_1_8.A sg13cmos5l_o21ai_1_1.Y 0.10765f
C8888 sg13cmos5l_buf_1_13.A a_14724_6480# 0.32215f
C8889 sg13cmos5l_nand2b_1_1.A_N a_14465_10214# 0.04335f
C8890 sg13cmos5l_nor2b_1_0.B_N sg13cmos5l_a21oi_1_4.B1 0.04122f
C8891 sg13cmos5l_buf_1_7.X bp8 0.01597f
C8892 a_17028_15552# a_18193_15311# 0.25046f
C8893 sg13cmos5l_dlygate4sd3_1_81.X sg13cmos5l_inv_1_24.A 0.01071f
C8894 a_17547_15356# a_17316_15247# 0.07823f
C8895 a_13738_17476# VDD 0.09442f
C8896 a_13727_13992# VDD 0.24729f
C8897 sg13cmos5l_nand2b_1_0.B VDD 1.30168f
C8898 sg13cmos5l_a21oi_1_17.Y a_17153_14750# 0.02789f
C8899 a_19450_18226# sg13cmos5l_a21oi_1_24.Y 0.28822f
C8900 sg13cmos5l_a21oi_1_18.B1 sg13cmos5l_a21oi_1_13.Y 0.13167f
C8901 sg13cmos5l_nand2b_1_1.A_N a_14350_10215# 0.04815f
C8902 sg13cmos5l_o21ai_1_5.A2 sg13cmos5l_and2_1_3.X 0.22397f
C8903 a_15243_6284# a_15983_6239# 0.17382f
C8904 sg13cmos5l_inv_1_2.A bp3 0.01827f
C8905 sg13cmos5l_buf_1_66.X a_8830_17874# 0.02162f
C8906 sg13cmos5l_nand2_1_13.A sg13cmos5l_nand2b_1_1.A_N 0.01572f
C8907 a_18756_19024# a_20015_19381# 0.01412f
C8908 sg13cmos5l_nand3b_1_3.C sg13cmos5l_o21ai_1_5.A1 0.05905f
C8909 a_15480_8752# sg13cmos5l_nor2b_1_2.Y 0.14288f
C8910 sg13cmos5l_o21ai_1_1.Y sg13cmos5l_a22oi_1_2.Y 0.025f
C8911 sg13cmos5l_dlygate4sd3_1_97.X a_12902_17508# 0.01098f
C8912 sg13cmos5l_buf_1_45.X a_13670_15238# 0.01098f
C8913 sg13cmos5l_a21oi_1_19.A2 VDD 0.50997f
C8914 sg13cmos5l_inv_1_18.A sg13cmos5l_nand3_1_1.Y 0.01788f
C8915 sg13cmos5l_a21oi_1_19.Y a_16556_15960# 0.02396f
C8916 sg13cmos5l_nor3_1_6.Y sg13cmos5l_mux2_1_0.A1 0.01897f
C8917 sg13cmos5l_dfrbpq_1_47.Q sg13cmos5l_o21ai_1_4.Y 0.0406f
C8918 sg13cmos5l_inv_1_20.Y a_10500_9952# 0.01423f
C8919 a_10917_9959# VDD 0.25317f
C8920 sg13cmos5l_nand2_1_1.A a_20384_16283# 0.01621f
C8921 sg13cmos5l_nand3_1_0.A a_12632_8477# 0.08776f
C8922 sg13cmos5l_o21ai_1_0.Y a_12344_6166# 0.01661f
C8923 sg13cmos5l_dfrbpq_1_20.Q a_4108_18258# 0.0134f
C8924 sg13cmos5l_o21ai_1_0.A1 sg13cmos5l_nor2b_1_2.Y 0.03309f
C8925 sg13cmos5l_nor3_1_6.Y bn6 0.01381f
C8926 sg13cmos5l_a21oi_1_5.A2 sg13cmos5l_dfrbpq_1_9.Q 0.02643f
C8927 a_8830_17874# VDD 0.19909f
C8928 sg13cmos5l_nand3b_1_3.C a_15400_15272# 0.04329f
C8929 sg13cmos5l_buf_1_45.X a_12837_19031# 0.05433f
C8930 a_7334_14484# VDD 0.20723f
C8931 sg13cmos5l_or4_1_1.X sg13cmos5l_o21ai_1_22.B1 0.13668f
C8932 sg13cmos5l_a21oi_1_24.A2 sg13cmos5l_buf_1_43.X 0.04425f
C8933 sg13cmos5l_a21oi_1_1.A2 a_19077_10677# 0.04415f
C8934 sg13cmos5l_dlygate4sd3_1_50.X sg13cmos5l_nand3_1_5.Y 0.01244f
C8935 sg13cmos5l_inv_1_32.Y bn4 0.03534f
C8936 a_19624_8522# a_19829_8436# 0.01003f
C8937 sg13cmos5l_nor4_1_0.Y sg13cmos5l_and4_1_0.D 0.27208f
C8938 a_20294_8874# a_20868_8861# 0.18486f
C8939 sg13cmos5l_dlygate4sd3_1_98.A bn5 0.16265f
C8940 a_7334_10386# VDD 0.527f
C8941 a_22096_14726# VDD 0.13583f
C8942 sg13cmos5l_buf_1_13.X sg13cmos5l_nand3_1_0.Y 0.02978f
C8943 sg13cmos5l_inv_1_31.A sg13cmos5l_a21oi_1_24.Y 0.28709f
C8944 sg13cmos5l_nand4_1_8.B bn6 0.0231f
C8945 sg13cmos5l_buf_1_15.A sg13cmos5l_a21oi_1_9.A2 0.08903f
C8946 a_15358_14850# bn6 0.01101f
C8947 sg13cmos5l_o21ai_1_7.B1 a_5451_19031# 0.02149f
C8948 a_3894_9972# VDD 0.16733f
C8949 sg13cmos5l_dfrbpq_1_8.D VDD 0.19197f
C8950 sg13cmos5l_dfrbpq_1_33.D a_15494_18258# 0.17465f
C8951 a_9934_9375# sg13cmos5l_nand4_1_0.C 0.1068f
C8952 a_5157_14495# VDD 0.24753f
C8953 sg13cmos5l_dfrbpq_1_9.Q a_20024_6166# 0.27085f
C8954 a_20586_7972# VDD 0.276f
C8955 a_3895_18222# a_4455_18476# 0.17382f
C8956 sg13cmos5l_dfrbpq_1_28.RESET_B a_22241_17774# 0.07062f
C8957 a_6756_11464# a_7275_11471# 0.20754f
C8958 a_7173_11471# a_7044_11885# 0.01562f
C8959 a_16283_17508# VDD 0.16157f
C8960 sg13cmos5l_nand4_1_1.B sg13cmos5l_inv_1_12.Y 0.10611f
C8961 sg13cmos5l_nand4_1_3.B a_13575_13940# 0.01675f
C8962 sg13cmos5l_nor3_1_2.B sg13cmos5l_o21ai_1_6.B1 0.05519f
C8963 sg13cmos5l_a21oi_1_2.B1 a_17604_11464# 0.045f
C8964 sg13cmos5l_nand2b_1_1.A_N a_14548_12508# 0.23697f
C8965 sg13cmos5l_nand2b_1_4.Y sg13cmos5l_a22oi_1_1.B2 0.09227f
C8966 sg13cmos5l_inv_1_19.Y sg13cmos5l_nand2_1_3.Y 0.12797f
C8967 sg13cmos5l_o21ai_1_9.B1 a_8410_14854# 0.01546f
C8968 a_11274_20068# code5 0.01125f
C8969 sg13cmos5l_nand4_1_1.B a_10880_16878# 0.02373f
C8970 a_15872_11546# VDD 0.08132f
C8971 sg13cmos5l_inv_1_32.Y VDD 0.6455f
C8972 sg13cmos5l_dfrbpq_1_40.Q sg13cmos5l_dfrbpq_1_35.D 0.11414f
C8973 a_19242_8436# VDD 0.27692f
C8974 sg13cmos5l_nand4_1_18.B sg13cmos5l_nand3b_1_1.Y 0.06235f
C8975 sg13cmos5l_dfrbpq_1_19.CLK a_6785_18448# 0.01604f
C8976 sg13cmos5l_inv_1_7.A a_22241_4166# 0.012f
C8977 sg13cmos5l_dfrbpq_1_13.RESET_B a_10607_5773# 0.10879f
C8978 sg13cmos5l_nor4_1_2.Y sg13cmos5l_buf_1_53.A 0.01832f
C8979 sg13cmos5l_dfrbpq_1_5.CLK sg13cmos5l_dfrbpq_1_28.D 0.02628f
C8980 sg13cmos5l_nand4_1_1.B sg13cmos5l_inv_1_24.A 0.02919f
C8981 sg13cmos5l_a21oi_1_18.B1 sg13cmos5l_dfrbpq_1_28.D 0.12611f
C8982 a_15104_7849# VDD 0.27734f
C8983 sg13cmos5l_buf_1_13.A a_16650_6460# 0.01751f
C8984 sg13cmos5l_a21oi_1_25.Y sg13cmos5l_a21oi_1_24.A1 0.01055f
C8985 a_15280_17750# VDD 0.13653f
C8986 sg13cmos5l_a21oi_1_19.Y sg13cmos5l_nand4_1_1.B 0.01173f
C8987 sg13cmos5l_nor2_1_2.B a_5412_7992# 0.02517f
C8988 sg13cmos5l_nand2_1_18.A sg13cmos5l_and2_1_6.A 0.04619f
C8989 a_17518_10215# VDD 0.16135f
C8990 a_15141_6141# a_15889_6239# 0.01058f
C8991 sg13cmos5l_buf_1_15.A sg13cmos5l_o21ai_1_20.A1 0.0202f
C8992 sg13cmos5l_nand3b_1_3.C sg13cmos5l_o21ai_1_5.A2 0.09029f
C8993 sg13cmos5l_a21oi_1_2.B1 a_19467_5423# 0.02802f
C8994 sg13cmos5l_dlygate4sd3_1_20.A a_22696_10830# 0.01539f
C8995 a_20272_19262# a_20682_19020# 0.07015f
C8996 sg13cmos5l_buf_1_15.A sg13cmos5l_buf_1_54.A 0.04661f
C8997 sg13cmos5l_dfrbpq_1_28.RESET_B sg13cmos5l_inv_1_15.Y 0.02692f
C8998 a_18948_5416# VDD 0.07295f
C8999 sg13cmos5l_inv_1_31.A sg13cmos5l_dfrbpq_1_30.D 0.12562f
C9000 sg13cmos5l_dfrbpq_1_28.RESET_B a_21063_18476# 0.27982f
C9001 sg13cmos5l_o21ai_1_15.B1 sg13cmos5l_nor2b_1_1.A 0.02628f
C9002 sg13cmos5l_buf_1_59.A a_15023_16357# 0.02641f
C9003 sg13cmos5l_buf_1_45.X a_16942_19287# 0.04525f
C9004 sg13cmos5l_nand4_1_18.A a_18974_13338# 0.01851f
C9005 sg13cmos5l_buf_1_8.A bp2 0.03768f
C9006 sg13cmos5l_buf_1_7.X a_20580_11464# 0.28021f
C9007 a_12016_10190# VDD 0.13832f
C9008 sg13cmos5l_dfrbpq_1_39.Q sg13cmos5l_a21oi_1_19.Y 0.09734f
C9009 sg13cmos5l_buf_1_25.A sg13cmos5l_dfrbpq_1_35.Q 0.10093f
C9010 sg13cmos5l_buf_1_57.A sg13cmos5l_mux2_1_0.S 0.03618f
C9011 sg13cmos5l_buf_1_9.A sg13cmos5l_inv_1_4.Y 0.84035f
C9012 sg13cmos5l_o21ai_1_21.B1 sg13cmos5l_o21ai_1_21.Y 0.15774f
C9013 sg13cmos5l_nand2b_1_3.B VDD 0.67057f
C9014 sg13cmos5l_buf_1_65.A sg13cmos5l_o21ai_1_5.A1 0.40571f
C9015 sg13cmos5l_o21ai_1_14.A1 a_9624_17064# 0.01043f
C9016 sg13cmos5l_buf_1_45.X a_14346_19020# 0.07264f
C9017 sg13cmos5l_buf_8_2.A a_21934_10887# 0.05831f
C9018 sg13cmos5l_or2_1_1.X sg13cmos5l_a22oi_1_2.Y 0.26611f
C9019 a_20997_8447# a_20868_8861# 0.01562f
C9020 a_20580_8440# a_21099_8447# 0.20754f
C9021 sg13cmos5l_buf_1_26.A a_11374_17775# 0.03845f
C9022 sg13cmos5l_a21oi_1_27.A2 a_9610_12433# 0.02048f
C9023 sg13cmos5l_inv_1_15.A busy 0.12249f
C9024 a_5036_13686# VDD 0.21081f
C9025 sg13cmos5l_nand3b_1_1.C sg13cmos5l_nand4_1_8.B 0.29517f
C9026 a_18660_7992# a_19077_7653# 0.28324f
C9027 a_18374_7674# a_19179_7796# 0.07916f
C9028 sg13cmos5l_inv_1_15.A sg13cmos5l_nand4_1_7.B 0.02189f
C9029 a_21215_17016# a_21866_16904# 0.01562f
C9030 sg13cmos5l_inv_1_4.Y a_17412_6928# 0.04817f
C9031 sg13cmos5l_buf_1_42.A a_20026_15202# 0.04525f
C9032 sg13cmos5l_inv_1_13.Y sg13cmos5l_nand3_1_0.Y 0.03712f
C9033 sg13cmos5l_a21oi_1_18.B1 a_15780_18576# 0.01032f
C9034 sg13cmos5l_a21oi_1_21.A1 busy 0.02286f
C9035 a_18948_5416# bp6 0.01636f
C9036 sg13cmos5l_nand2_1_18.A clk 0.29721f
C9037 a_5126_7674# VDD 0.5281f
C9038 sg13cmos5l_nand4_1_1.B bn0 0.01503f
C9039 a_21215_18528# bn4 0.01058f
C9040 sg13cmos5l_buf_1_10.A a_22241_4166# 0.01632f
C9041 sg13cmos5l_a21oi_1_16.A2 a_17429_12508# 0.07976f
C9042 a_4455_18476# a_5303_18649# 0.07916f
C9043 sg13cmos5l_buf_1_13.X a_22096_10190# 0.09622f
C9044 a_7275_11471# a_8015_11821# 0.17382f
C9045 a_20015_17869# VDD 0.17316f
C9046 a_20503_18222# bn4 0.01045f
C9047 sg13cmos5l_inv_1_15.A sg13cmos5l_nand4_1_3.B 0.66481f
C9048 a_22049_10888# VDD 0.20777f
C9049 sg13cmos5l_buf_1_25.A a_15014_19020# 0.01498f
C9050 sg13cmos5l_a21oi_1_26.Y a_15754_18481# 0.01377f
C9051 sg13cmos5l_nand4_1_3.B a_15496_13760# 0.01059f
C9052 sg13cmos5l_buf_1_15.A sg13cmos5l_o21ai_1_9.B1 0.01154f
C9053 sg13cmos5l_dfrbpq_1_11.Q a_19624_8522# 0.02428f
C9054 a_20406_6230# a_20974_6351# 0.01641f
C9055 bp8 bp4 0.01754f
C9056 sg13cmos5l_buf_1_24.A a_11268_18271# 0.036f
C9057 sg13cmos5l_dfrbpq_1_5.CLK a_21099_13844# 0.02885f
C9058 sg13cmos5l_a22oi_1_1.B2 a_8671_7996# 0.05392f
C9059 sg13cmos5l_o21ai_1_10.A2 a_10389_16258# 0.03871f
C9060 sg13cmos5l_buf_1_42.A a_17028_15552# 0.04013f
C9061 sg13cmos5l_dfrbpq_1_24.RESET_B a_4952_17549# 0.04755f
C9062 sg13cmos5l_a21oi_1_14.Y a_21911_16043# 0.06114f
C9063 a_16101_11460# VDD 0.01366f
C9064 sg13cmos5l_dfrbpq_1_40.Q a_20506_19738# 0.28655f
C9065 sg13cmos5l_a21oi_1_18.B1 a_21099_13844# 0.02299f
C9066 sg13cmos5l_or4_1_0.D sg13cmos5l_nand2b_1_4.B 0.01025f
C9067 sg13cmos5l_nand4_1_7.B sg13cmos5l_a21oi_1_17.Y 0.48219f
C9068 a_17290_8404# a_17316_8440# 0.24169f
C9069 sg13cmos5l_o21ai_1_22.B1 bn3 0.09889f
C9070 sg13cmos5l_inv_1_12.A VDD 0.81014f
C9071 sg13cmos5l_buf_1_13.A sg13cmos5l_a21oi_1_0.Y 0.01406f
C9072 sg13cmos5l_nand4_1_5.D a_16172_15960# 0.0687f
C9073 sg13cmos5l_dfrbpq_1_24.Q sg13cmos5l_mux2_1_0.A1 0.18842f
C9074 sg13cmos5l_inv_1_5.A a_16454_8436# 0.02338f
C9075 sg13cmos5l_dfrbpq_1_28.RESET_B sg13cmos5l_buf_1_7.X 0.06005f
C9076 a_18272_10034# VDD 0.07755f
C9077 sg13cmos5l_nand2_1_2.Y sg13cmos5l_buf_1_5.A 0.13652f
C9078 sg13cmos5l_dfrbpq_1_13.RESET_B a_4838_9186# 0.11045f
C9079 sg13cmos5l_inv_1_1.Y sg13cmos5l_buf_1_13.X 0.04103f
C9080 sg13cmos5l_nand3b_1_1.Y a_7954_17886# 0.05994f
C9081 sg13cmos5l_a21oi_1_3.A2 sg13cmos5l_nor3_1_0.Y 0.02736f
C9082 a_21215_18528# VDD 0.24933f
C9083 sg13cmos5l_nand4_1_3.B sg13cmos5l_a21oi_1_17.Y 0.0121f
C9084 sg13cmos5l_nor2_1_2.B a_7338_7972# 0.03534f
C9085 sg13cmos5l_o21ai_1_15.Y sg13cmos5l_nor2b_1_1.A 0.06553f
C9086 a_16184_8477# a_16454_8436# 0.18796f
C9087 a_21754_5376# VDD 0.26193f
C9088 a_20503_18222# VDD 0.17316f
C9089 sg13cmos5l_inv_1_25.Y bn6 0.01465f
C9090 sg13cmos5l_dfrbpq_1_28.RESET_B sg13cmos5l_a21oi_1_14.Y 0.07614f
C9091 sg13cmos5l_o21ai_1_7.A2 sg13cmos5l_o21ai_1_21.A2 0.01897f
C9092 a_20207_5773# VDD 0.17243f
C9093 sg13cmos5l_inv_1_1.A sg13cmos5l_dfrbpq_1_28.D 0.01492f
C9094 a_12939_19031# bn0 0.02174f
C9095 a_18756_19024# sg13cmos5l_a21oi_1_19.Y 0.01766f
C9096 sg13cmos5l_buf_8_2.A sg13cmos5l_dfrbpq_1_45.D 0.01802f
C9097 sg13cmos5l_buf_1_59.A sg13cmos5l_nand4_1_16.D 0.02596f
C9098 a_14465_10214# VDD 0.20801f
C9099 sg13cmos5l_a21o_1_2.A1 a_7064_14525# 0.06721f
C9100 sg13cmos5l_nand4_1_7.B sg13cmos5l_nand4_1_5.D 0.01912f
C9101 a_11286_14020# VDD 0.01715f
C9102 sg13cmos5l_dlygate4sd3_1_3.A a_22506_4948# 0.01098f
C9103 a_20554_14452# a_20997_14495# 0.02241f
C9104 a_20294_14922# a_20868_14909# 0.18486f
C9105 sg13cmos5l_inv_1_15.A sg13cmos5l_buf_1_21.A 0.01012f
C9106 sg13cmos5l_buf_1_7.X a_21839_11821# 0.10879f
C9107 sg13cmos5l_nand4_1_7.B sg13cmos5l_o21ai_1_28.A1 0.04935f
C9108 a_14350_10215# VDD 0.16046f
C9109 sg13cmos5l_buf_1_25.A a_21350_19020# 0.01512f
C9110 sg13cmos5l_nand2_1_13.A VDD 0.54563f
C9111 sg13cmos5l_dfrbpq_1_13.CLK sg13cmos5l_dlygate4sd3_1_15.X 0.28808f
C9112 sg13cmos5l_buf_1_65.A sg13cmos5l_o21ai_1_5.A2 0.27661f
C9113 sg13cmos5l_buf_8_2.A sg13cmos5l_a21oi_1_0.A2 0.02716f
C9114 sg13cmos5l_nor2_1_7.Y sg13cmos5l_o21ai_1_9.A2 0.12483f
C9115 sg13cmos5l_a21oi_1_0.A2 a_19160_9190# 0.01453f
C9116 sg13cmos5l_dfrbpq_1_21.D a_7238_19458# 0.17282f
C9117 sg13cmos5l_buf_1_2.A sg13cmos5l_inv_1_7.Y 0.01772f
C9118 a_21099_8447# a_21839_8797# 0.17382f
C9119 a_8955_9228# VDD 0.19563f
C9120 sg13cmos5l_buf_1_15.A a_15329_10214# 0.01296f
C9121 sg13cmos5l_dfrbpq_1_13.CLK a_10214_10386# 0.01781f
C9122 sg13cmos5l_buf_1_9.A sg13cmos5l_nand3_1_0.Y 0.02036f
C9123 sg13cmos5l_buf_1_8.A a_20868_4663# 0.01327f
C9124 sg13cmos5l_nor2b_1_1.A sg13cmos5l_nand4_1_1.B 0.02566f
C9125 sg13cmos5l_or2_1_1.X sg13cmos5l_nand2_1_5.Y 0.06981f
C9126 a_3975_16964# VDD 0.20543f
C9127 sg13cmos5l_inv_1_17.Y a_20024_6166# 0.02275f
C9128 sg13cmos5l_o21ai_1_26.B1 busy 0.01585f
C9129 a_6760_17594# VDD 0.13471f
C9130 sg13cmos5l_buf_1_20.A a_11393_13238# 0.04127f
C9131 sg13cmos5l_a21oi_1_25.Y a_19173_19031# 0.02916f
C9132 a_6928_7894# VDD 0.13589f
C9133 sg13cmos5l_buf_1_5.A a_19048_3900# 0.01307f
C9134 sg13cmos5l_dfrbpq_1_13.RESET_B a_10053_12189# 0.03562f
C9135 sg13cmos5l_a21oi_1_27.B1 sg13cmos5l_dfrbpq_1_19.CLK 0.05337f
C9136 a_21350_17508# VDD 0.2083f
C9137 sg13cmos5l_dfrbpq_1_24.RESET_B a_10980_18576# 0.26085f
C9138 sg13cmos5l_o21ai_1_5.A1 bn2 0.88143f
C9139 a_21640_3176# bp3 0.06507f
C9140 a_13958_19770# a_14661_19749# 0.02453f
C9141 sg13cmos5l_a21oi_1_27.B1 sg13cmos5l_nor2_1_7.Y 0.11485f
C9142 a_13686_18326# a_14218_18226# 0.01845f
C9143 a_10474_9916# a_10500_9952# 0.24169f
C9144 sg13cmos5l_mux2_1_1.A1 a_8411_12252# 0.11678f
C9145 sg13cmos5l_a21oi_1_3.A2 a_17015_9577# 0.02087f
C9146 sg13cmos5l_a21oi_1_4.A2 sg13cmos5l_inv_1_24.Y 0.74207f
C9147 sg13cmos5l_inv_1_36.A a_12814_13239# 0.01201f
C9148 sg13cmos5l_a21oi_1_18.B1 a_21839_13799# 0.01949f
C9149 a_19530_11460# VDD 0.27694f
C9150 sg13cmos5l_dfrbpq_1_24.RESET_B sg13cmos5l_a21oi_1_24.A1 0.10746f
C9151 sg13cmos5l_buf_1_13.A a_17109_9344# 0.17144f
C9152 a_6113_13912# a_6394_13690# 0.18796f
C9153 a_17733_8447# a_17835_8447# 0.3643f
C9154 sg13cmos5l_and2_1_3.X bn6 0.08647f
C9155 sg13cmos5l_buf_1_25.A code0 0.01894f
C9156 sg13cmos5l_nand3_1_0.C a_16586_7832# 0.01365f
C9157 sg13cmos5l_buf_1_10.A sg13cmos5l_dlygate4sd3_1_3.A 1.3327f
C9158 sg13cmos5l_nand2_1_1.Y sg13cmos5l_buf_1_14.A 0.01889f
C9159 sg13cmos5l_dfrbpq_1_13.RESET_B a_6640_9406# 0.10107f
C9160 a_20997_9959# VDD 0.24751f
C9161 a_14744_19061# a_15014_19020# 0.18796f
C9162 a_15126_19044# a_15692_18984# 0.01642f
C9163 a_14548_12508# VDD 0.16303f
C9164 a_22005_18416# VDD 0.0953f
C9165 sg13cmos5l_dfrbpq_1_14.D a_7144_10034# 0.04077f
C9166 sg13cmos5l_a21oi_1_18.B1 valid 0.03142f
C9167 sg13cmos5l_buf_1_5.A sg13cmos5l_a21oi_1_0.Y 0.02156f
C9168 sg13cmos5l_nor2_1_2.B a_8118_7742# 0.01655f
C9169 sg13cmos5l_nand3_1_2.A a_14144_10830# 0.02641f
C9170 sg13cmos5l_dfrbpq_1_34.Q sg13cmos5l_dfrbpq_1_39.Q 0.03358f
C9171 a_19630_15423# sg13cmos5l_inv_1_24.A 0.10682f
C9172 sg13cmos5l_o21ai_1_19.B1 a_8434_17886# 0.06172f
C9173 sg13cmos5l_nand4_1_12.Y a_15322_16714# 0.03656f
C9174 sg13cmos5l_nand3b_1_1.C sg13cmos5l_inv_1_25.Y 0.03478f
C9175 sg13cmos5l_buf_1_20.A sg13cmos5l_and4_1_1.A 0.03171f
C9176 sg13cmos5l_dfrbpq_1_35.Q a_21462_19044# 0.01526f
C9177 sg13cmos5l_nand2b_1_1.A_N a_13786_7642# 0.01686f
C9178 sg13cmos5l_dlygate4sd3_1_82.A valid 0.03182f
C9179 sg13cmos5l_buf_1_7.X a_16070_5850# 0.11282f
C9180 sg13cmos5l_buf_1_26.A a_18470_17946# 0.01038f
C9181 a_6958_19959# sg13cmos5l_dfrbpq_1_25.Q 0.06401f
C9182 a_12987_12214# a_14240_12342# 0.01906f
C9183 sg13cmos5l_inv_1_8.A sg13cmos5l_nand3b_1_0.C 0.10158f
C9184 sg13cmos5l_dlygate4sd3_1_76.X bn8 0.25924f
C9185 a_20015_19381# sg13cmos5l_a21oi_1_19.Y 0.01797f
C9186 a_13478_17946# a_14283_17519# 0.07916f
C9187 sg13cmos5l_dfrbpq_1_30.D sg13cmos5l_inv_1_25.Y 0.02212f
C9188 sg13cmos5l_nor2b_1_1.A a_9832_16082# 0.02395f
C9189 sg13cmos5l_buf_8_2.A sg13cmos5l_o21ai_1_23.A2 0.01919f
C9190 sg13cmos5l_dfrbpq_1_2.D VDD 0.33267f
C9191 a_22522_17472# bn5 0.01213f
C9192 sg13cmos5l_buf_1_42.A a_16840_16878# 0.01823f
C9193 a_15692_18984# code2 0.15509f
C9194 a_20868_14909# a_21099_14495# 0.07823f
C9195 sg13cmos5l_buf_1_66.X sg13cmos5l_dfrbpq_1_19.D 0.03099f
C9196 sg13cmos5l_dfrbpq_1_34.Q a_18762_20068# 0.01088f
C9197 sg13cmos5l_dlygate4sd3_1_1.A sg13cmos5l_dfrbpq_1_0.D 0.04919f
C9198 sg13cmos5l_a21oi_1_27.B1 a_4950_15302# 0.03491f
C9199 sg13cmos5l_dlygate4sd3_1_71.X a_20294_11898# 0.16534f
C9200 sg13cmos5l_nand3_1_0.A sg13cmos5l_a22oi_1_0.A2 0.02535f
C9201 sg13cmos5l_buf_1_15.A sg13cmos5l_inv_1_15.Y 0.0968f
C9202 sg13cmos5l_inv_1_18.A a_13749_9386# 0.11742f
C9203 sg13cmos5l_inv_1_17.A sg13cmos5l_dlygate4sd3_1_16.A 0.01264f
C9204 sg13cmos5l_o21ai_1_21.A2 sg13cmos5l_nand3b_1_1.C 0.13654f
C9205 sg13cmos5l_nand4_1_15.B a_17547_15356# 0.01611f
C9206 a_6490_19738# code6 0.02209f
C9207 sg13cmos5l_buf_1_26.A a_14181_17519# 0.01523f
C9208 sg13cmos5l_buf_1_1.A a_21839_13799# 0.02044f
C9209 sg13cmos5l_inv_1_24.Y sg13cmos5l_buf_1_57.A 0.03103f
C9210 sg13cmos5l_nand2_1_0.B a_12808_10034# 0.01718f
C9211 a_4714_14452# a_4740_14488# 0.24169f
C9212 sg13cmos5l_dfrbpq_1_47.Q sg13cmos5l_o21ai_1_4.A1 0.17682f
C9213 sg13cmos5l_a21oi_1_26.A1 a_16068_18271# 0.02141f
C9214 sg13cmos5l_nand2_1_0.B a_12987_10318# 0.02507f
C9215 a_19919_7751# a_20176_7894# 0.23043f
C9216 a_19077_7653# a_19825_7751# 0.01058f
C9217 sg13cmos5l_a21oi_1_0.A2 sg13cmos5l_a21oi_1_15.Y 0.02325f
C9218 sg13cmos5l_dfrbpq_1_19.D VDD 0.22184f
C9219 sg13cmos5l_nand2b_1_0.B sg13cmos5l_nand2_1_6.A 0.25556f
C9220 sg13cmos5l_buf_1_20.A sg13cmos5l_and2_1_6.A 0.02393f
C9221 a_18756_17512# a_19173_17519# 0.28418f
C9222 sg13cmos5l_a21oi_1_18.B1 sg13cmos5l_nand4_1_15.B 0.20442f
C9223 sg13cmos5l_nor4_1_0.C a_11576_7972# 0.01877f
C9224 sg13cmos5l_inv_1_1.Y sg13cmos5l_dfrbpq_1_30.Q 0.04091f
C9225 sg13cmos5l_buf_1_47.X a_12694_16742# 0.07903f
C9226 a_8006_7678# VDD 0.207f
C9227 a_20398_4167# VDD 0.16012f
C9228 sg13cmos5l_o21ai_1_7.A2 sg13cmos5l_nand3b_1_3.C 0.02504f
C9229 sg13cmos5l_nand3_1_8.Y sg13cmos5l_inv_1_16.A 0.46767f
C9230 sg13cmos5l_o21ai_1_5.A2 bn2 0.02344f
C9231 sg13cmos5l_buf_1_47.X a_13409_16936# 0.01336f
C9232 sg13cmos5l_buf_1_54.A a_17243_17508# 0.0446f
C9233 sg13cmos5l_dfrbpq_1_13.RESET_B a_11152_12430# 0.09967f
C9234 sg13cmos5l_a21oi_1_4.A1 sg13cmos5l_inv_1_36.A 0.02529f
C9235 a_9260_11424# a_9056_11546# 0.01689f
C9236 sg13cmos5l_inv_1_11.Y a_19179_7796# 0.03358f
C9237 sg13cmos5l_buf_1_45.X code2 0.02099f
C9238 sg13cmos5l_a21oi_1_26.Y a_16068_18271# 0.01063f
C9239 a_4476_18222# a_5258_18416# 0.24435f
C9240 sg13cmos5l_nand3_1_5.Y sg13cmos5l_o21ai_1_21.A2 0.03699f
C9241 sg13cmos5l_dfrbpq_1_13.RESET_B sg13cmos5l_a21o_1_0.A2 0.01778f
C9242 a_10500_9952# a_10788_10373# 0.24435f
C9243 a_15754_18481# a_15780_18576# 0.24169f
C9244 sg13cmos5l_nand4_1_1.C sg13cmos5l_inv_1_16.A 0.46656f
C9245 sg13cmos5l_buf_1_16.A sg13cmos5l_a21oi_1_0.A2 0.12871f
C9246 sg13cmos5l_nand4_1_1.C a_18970_14448# 0.01591f
C9247 sg13cmos5l_o21ai_1_7.B1 sg13cmos5l_o21ai_1_10.B1 0.14983f
C9248 sg13cmos5l_nand4_1_18.D sg13cmos5l_dfrbpq_1_28.D 0.4371f
C9249 sg13cmos5l_dfrbpq_1_20.Q sg13cmos5l_o21ai_1_20.Y 0.05417f
C9250 sg13cmos5l_a21oi_1_2.Y a_18948_5416# 0.04699f
C9251 sg13cmos5l_o21ai_1_25.B1 a_15494_18258# 0.01379f
C9252 sg13cmos5l_or4_1_0.C sg13cmos5l_nand4_1_0.C 0.06192f
C9253 a_18832_8678# a_18575_8797# 0.23043f
C9254 sg13cmos5l_inv_1_12.Y sg13cmos5l_buf_1_5.A 0.07138f
C9255 a_15804_7638# a_16586_7832# 0.24435f
C9256 sg13cmos5l_nand3b_1_3.C bn6 0.01213f
C9257 a_20294_7362# VDD 0.52437f
C9258 a_14218_19993# sg13cmos5l_buf_1_45.X 0.17026f
C9259 sg13cmos5l_dfrbpq_1_41.CLK a_14283_17519# 0.04054f
C9260 sg13cmos5l_inv_1_1.Y sg13cmos5l_buf_1_9.A 0.04676f
C9261 sg13cmos5l_dfrbpq_1_35.D sg13cmos5l_a21oi_1_25.Y 0.02366f
C9262 sg13cmos5l_inv_1_19.Y sg13cmos5l_a22oi_1_1.B2 0.08919f
C9263 sg13cmos5l_buf_1_16.A sg13cmos5l_inv_1_14.Y 0.20063f
C9264 sg13cmos5l_inv_1_8.A sg13cmos5l_nand2b_1_1.A_N 0.06106f
C9265 sg13cmos5l_dlygate4sd3_1_50.X sg13cmos5l_dfrbpq_1_19.CLK 0.04301f
C9266 sg13cmos5l_inv_1_9.Y a_17240_10702# 0.02908f
C9267 sg13cmos5l_dlygate4sd3_1_38.X a_7334_10386# 0.05373f
C9268 sg13cmos5l_dlygate4sd3_1_50.X sg13cmos5l_nor2_1_7.Y 0.29875f
C9269 a_21462_19044# a_21350_19020# 0.3854f
C9270 a_7064_14525# a_7334_14484# 0.18796f
C9271 sg13cmos5l_buf_1_7.X a_16875_5423# 0.29463f
C9272 sg13cmos5l_a21oi_1_18.B1 sg13cmos5l_a21oi_1_15.A2 0.04017f
C9273 sg13cmos5l_buf_1_25.A sg13cmos5l_buf_8_2.A 0.02475f
C9274 sg13cmos5l_buf_1_20.A clk 0.02883f
C9275 sg13cmos5l_inv_1_36.A sg13cmos5l_mux2_1_1.A1 0.41748f
C9276 a_13764_17512# a_14929_17869# 0.25046f
C9277 a_14052_17933# a_14283_17519# 0.07823f
C9278 sg13cmos5l_a21oi_1_14.Y a_21084_16357# 0.04253f
C9279 sg13cmos5l_nand2b_1_1.A_N sg13cmos5l_a22oi_1_2.Y 0.0261f
C9280 a_7334_10386# a_8037_9959# 0.02431f
C9281 sg13cmos5l_dfrbpq_1_41.CLK sg13cmos5l_inv_1_24.Y 1.46098f
C9282 sg13cmos5l_nand4_1_18.B sg13cmos5l_dfrbpq_1_28.D 0.22019f
C9283 a_22096_4870# bp1 0.04126f
C9284 a_21269_9484# bp2 0.02173f
C9285 sg13cmos5l_o21ai_1_3.Y a_15000_8416# 0.01087f
C9286 a_21839_14845# a_21745_14845# 0.16704f
C9287 a_20294_13722# a_20997_13701# 0.02453f
C9288 sg13cmos5l_dlygate4sd3_1_80.X bn0 0.01735f
C9289 sg13cmos5l_dfrbpq_1_28.RESET_B a_17153_14750# 0.01109f
C9290 sg13cmos5l_nand2b_1_0.B a_15597_12256# 0.17509f
C9291 sg13cmos5l_a21o_1_2.X sg13cmos5l_o21ai_1_9.B1 0.02309f
C9292 a_20997_14495# bn6 0.01857f
C9293 sg13cmos5l_o21ai_1_10.A2 sg13cmos5l_o21ai_1_5.A1 0.07729f
C9294 a_3894_9972# sg13cmos5l_dlygate4sd3_1_33.X 0.11531f
C9295 sg13cmos5l_buf_1_15.A sg13cmos5l_a21oi_1_14.Y 0.01272f
C9296 sg13cmos5l_buf_1_45.X a_16197_18237# 0.05001f
C9297 a_5386_7897# a_5412_7992# 0.24169f
C9298 sg13cmos5l_buf_1_26.A a_15690_17508# 0.01214f
C9299 sg13cmos5l_nand2b_1_1.A_N a_10592_6294# 0.02342f
C9300 sg13cmos5l_nor4_1_2.Y sg13cmos5l_mux2_1_0.S 0.05891f
C9301 sg13cmos5l_buf_1_17.X a_3512_9989# 0.27722f
C9302 sg13cmos5l_buf_1_45.X sg13cmos5l_buf_1_24.A 0.04099f
C9303 sg13cmos5l_nand4_1_18.A sg13cmos5l_inv_1_17.Y 0.05828f
C9304 sg13cmos5l_a21oi_1_13.A2 a_19829_14020# 0.0768f
C9305 sg13cmos5l_buf_1_1.A bp2 0.09777f
C9306 sg13cmos5l_o21ai_1_20.B1 sg13cmos5l_dfrbpq_1_20.D 0.02836f
C9307 a_5157_14495# sg13cmos5l_dfrbpq_1_15.CLK 0.21259f
C9308 a_18662_5850# a_18948_5416# 0.26205f
C9309 a_8218_19738# a_7941_19031# 0.01139f
C9310 a_19995_9190# sg13cmos5l_dfrbpq_1_6.D 0.08998f
C9311 sg13cmos5l_a21oi_1_6.Y a_22096_8678# 0.01039f
C9312 sg13cmos5l_nand3_1_0.A sg13cmos5l_nor4_1_0.Y 0.13917f
C9313 a_19173_17519# a_19275_17519# 0.3643f
C9314 sg13cmos5l_a21oi_1_5.A2 sg13cmos5l_a21oi_1_2.A2 0.02777f
C9315 sg13cmos5l_dfrbpq_1_30.Q a_18785_16262# 0.01731f
C9316 a_21152_3986# VDD 0.07324f
C9317 a_13958_19770# bn2 0.03197f
C9318 sg13cmos5l_a21oi_1_7.A2 sg13cmos5l_dlygate4sd3_1_22.A 0.01968f
C9319 sg13cmos5l_buf_1_7.X a_20554_8404# 0.20838f
C9320 sg13cmos5l_dlygate4sd3_1_50.X a_4950_15302# 0.11403f
C9321 sg13cmos5l_buf_1_1.A a_21099_4772# 0.01196f
C9322 sg13cmos5l_a21oi_1_6.A2 sg13cmos5l_a21oi_1_5.A2 0.01331f
C9323 sg13cmos5l_dfrbpq_1_24.RESET_B sg13cmos5l_dfrbpq_1_24.D 0.35837f
C9324 a_16197_18237# a_16299_18380# 0.36168f
C9325 a_10788_10373# a_11019_9959# 0.07823f
C9326 sg13cmos5l_inv_1_15.A sg13cmos5l_a21oi_1_5.A2 2.40117f
C9327 sg13cmos5l_buf_1_63.A a_18095_19847# 0.01882f
C9328 sg13cmos5l_nand3_1_2.Y a_13208_11501# 0.01065f
C9329 sg13cmos5l_a21oi_1_25.A2 a_16763_17508# 0.07904f
C9330 sg13cmos5l_nand4_1_15.B sg13cmos5l_inv_1_1.A 0.96828f
C9331 sg13cmos5l_dfrbpq_1_28.Q VDD 0.41559f
C9332 sg13cmos5l_and4_1_0.D sg13cmos5l_a21oi_1_9.A2 0.06347f
C9333 sg13cmos5l_buf_1_45.X sg13cmos5l_nor2_1_15.Y 0.02351f
C9334 sg13cmos5l_a21oi_1_2.B1 a_21839_7285# 0.03911f
C9335 sg13cmos5l_o21ai_1_25.Y a_14136_17064# 0.01459f
C9336 sg13cmos5l_inv_1_18.A clk 0.02839f
C9337 a_13764_17512# bn2 0.04047f
C9338 sg13cmos5l_nand3b_1_3.C sg13cmos5l_nand3b_1_1.C 0.34418f
C9339 a_7432_13854# a_7616_13854# 0.05762f
C9340 sg13cmos5l_nand2_1_6.A sg13cmos5l_nand2b_1_3.B 1.40761f
C9341 a_20192_7010# VDD 0.07725f
C9342 sg13cmos5l_buf_8_2.A a_18382_6351# 0.02058f
C9343 sg13cmos5l_inv_1_15.Y sg13cmos5l_buf_1_54.A 0.02232f
C9344 sg13cmos5l_o21ai_1_18.B1 sg13cmos5l_o21ai_1_17.Y 0.01687f
C9345 bp1 bp3 0.14978f
C9346 bp2 bn9 0.15037f
C9347 sg13cmos5l_or4_1_0.C a_10214_10386# 0.01074f
C9348 sg13cmos5l_nand2b_1_4.Y a_8671_7996# 0.03873f
C9349 sg13cmos5l_dfrbpq_1_24.D a_5604_12976# 0.0361f
C9350 sg13cmos5l_dfrbpq_1_28.RESET_B a_20398_13239# 0.02237f
C9351 sg13cmos5l_buf_1_45.X a_14378_13880# 0.01835f
C9352 a_19361_19960# a_19642_19738# 0.18796f
C9353 a_9761_6352# clk 0.04131f
C9354 sg13cmos5l_nand4_1_18.C VDD 0.49721f
C9355 sg13cmos5l_dfrbpq_1_9.D a_16725_7832# 0.02547f
C9356 sg13cmos5l_o21ai_1_17.B1 sg13cmos5l_buf_1_45.X 0.06268f
C9357 sg13cmos5l_buf_1_65.A sg13cmos5l_mux2_1_0.A1 0.08615f
C9358 sg13cmos5l_dlygate4sd3_1_38.X a_7908_10373# 0.02143f
C9359 sg13cmos5l_inv_1_1.A bp2 0.02013f
C9360 sg13cmos5l_buf_1_7.X sg13cmos5l_dlygate4sd3_1_1.A 0.42544f
C9361 sg13cmos5l_inv_1_15.Y sg13cmos5l_dfrbpq_1_9.D 0.04038f
C9362 sg13cmos5l_buf_1_45.X a_13596_13686# 0.29729f
C9363 a_15223_7638# a_15436_7674# 0.23043f
C9364 sg13cmos5l_nor3_1_2.A sg13cmos5l_nor3_1_2.C 0.42607f
C9365 a_18374_10698# VDD 0.52442f
C9366 sg13cmos5l_inv_1_15.Y sg13cmos5l_a21oi_1_3.Y 0.09346f
C9367 a_15023_17869# a_14929_17869# 0.16704f
C9368 a_7620_9952# a_8139_9959# 0.20754f
C9369 a_8037_9959# a_7908_10373# 0.01562f
C9370 sg13cmos5l_dfrbpq_1_24.RESET_B a_4108_18258# 0.09623f
C9371 sg13cmos5l_a21oi_1_6.A2 sg13cmos5l_nor3_1_0.Y 0.02341f
C9372 sg13cmos5l_buf_1_0.A VDD 0.83184f
C9373 sg13cmos5l_dfrbpq_1_3.D sg13cmos5l_nand3_1_0.C 0.17068f
C9374 a_20384_18433# sg13cmos5l_dlygate4sd3_1_72.A 0.07866f
C9375 sg13cmos5l_nand3b_1_3.C sg13cmos5l_nand3_1_5.Y 0.06534f
C9376 sg13cmos5l_inv_1_17.A a_21745_11821# 0.01956f
C9377 a_14657_7190# VDD 0.20804f
C9378 sg13cmos5l_o21ai_1_1.B1 sg13cmos5l_dlygate4sd3_1_15.X 0.0213f
C9379 sg13cmos5l_inv_1_36.A sg13cmos5l_nor3_1_4.A 0.01893f
C9380 a_16950_9972# sg13cmos5l_dfrbpq_1_3.D 0.10665f
C9381 a_13786_7642# VDD 0.27661f
C9382 sg13cmos5l_dfrbpq_1_13.CLK sg13cmos5l_buf_1_14.A 0.15977f
C9383 a_21745_14845# bn6 0.0194f
C9384 sg13cmos5l_inv_1_1.A sg13cmos5l_a21oi_1_15.A2 0.01844f
C9385 sg13cmos5l_dlygate4sd3_1_43.X a_6671_7751# 0.01745f
C9386 sg13cmos5l_nand4_1_18.B sg13cmos5l_dlygate4sd3_1_13.A 0.0949f
C9387 sg13cmos5l_buf_1_26.A sg13cmos5l_inv_1_15.Y 0.09648f
C9388 sg13cmos5l_inv_1_11.Y sg13cmos5l_nand2b_1_3.B 0.38528f
C9389 sg13cmos5l_buf_1_13.X a_16356_5416# 0.02785f
C9390 a_3900_16357# a_4821_16043# 0.24169f
C9391 sg13cmos5l_dfrbpq_1_15.CLK a_5126_7674# 0.01391f
C9392 a_15041_16936# code0 0.05649f
C9393 sg13cmos5l_nand4_1_6.B sg13cmos5l_nand4_1_16.D 0.02921f
C9394 sg13cmos5l_nand4_1_7.B sg13cmos5l_nand3_1_6.C 0.1719f
C9395 sg13cmos5l_a21oi_1_27.B1 a_8783_19381# 0.02097f
C9396 a_18948_5416# a_19236_5837# 0.24435f
C9397 sg13cmos5l_a21oi_1_19.Y a_17039_18335# 0.02387f
C9398 sg13cmos5l_a21oi_1_1.A2 sg13cmos5l_a21oi_1_5.A2 0.01691f
C9399 sg13cmos5l_inv_1_0.Y sg13cmos5l_inv_1_2.Y 0.02397f
C9400 sg13cmos5l_buf_1_6.A a_19048_3900# 0.03021f
C9401 a_3200_16283# sg13cmos5l_dlygate4sd3_1_50.A 0.09188f
C9402 a_3319_15960# a_3900_16357# 0.01412f
C9403 sg13cmos5l_inv_1_17.Y sg13cmos5l_dlygate4sd3_1_22.A 0.02212f
C9404 sg13cmos5l_dlygate4sd3_1_64.X sg13cmos5l_dfrbpq_1_23.D 0.22477f
C9405 a_19275_17519# a_20272_17750# 0.03546f
C9406 a_6209_16936# VDD 0.20825f
C9407 sg13cmos5l_dfrbpq_1_28.RESET_B a_17002_15457# 0.18216f
C9408 a_20104_3176# VDD 0.17966f
C9409 a_13294_16935# bn0 0.01384f
C9410 sg13cmos5l_a21oi_1_9.A2 a_14542_7191# 0.03111f
C9411 sg13cmos5l_buf_1_7.X a_22096_8678# 0.09622f
C9412 code5 bn3 0.01275f
C9413 sg13cmos5l_a21oi_1_4.A1 busy 0.02867f
C9414 a_13764_16000# VDD 0.07278f
C9415 sg13cmos5l_buf_1_0.A bp6 0.02166f
C9416 a_10896_8052# a_10784_7806# 0.01147f
C9417 sg13cmos5l_nand4_1_7.B sg13cmos5l_a21oi_1_4.A1 0.01296f
C9418 sg13cmos5l_buf_1_66.X sg13cmos5l_o21ai_1_21.Y 0.07147f
C9419 sg13cmos5l_o21ai_1_21.A2 a_4594_17886# 0.04784f
C9420 sg13cmos5l_o21ai_1_24.Y a_12694_16742# 0.06017f
C9421 sg13cmos5l_nor2_1_4.Y a_8332_15996# 0.01294f
C9422 sg13cmos5l_o21ai_1_21.B1 a_4476_18222# 0.03385f
C9423 sg13cmos5l_buf_1_7.X a_18634_7897# 0.19942f
C9424 a_15780_18576# a_16068_18271# 0.24435f
C9425 a_11759_10309# a_11665_10309# 0.16704f
C9426 sg13cmos5l_o21ai_1_9.A2 sg13cmos5l_o21ai_1_9.Y 0.0334f
C9427 sg13cmos5l_o21ai_1_0.B1 a_13343_5383# 0.03222f
C9428 sg13cmos5l_inv_1_2.A a_20868_8861# 0.02108f
C9429 sg13cmos5l_nand2b_1_3.Y a_9885_7194# 0.06627f
C9430 sg13cmos5l_buf_1_15.A sg13cmos5l_dlygate4sd3_1_58.X 0.06243f
C9431 sg13cmos5l_inv_1_24.A bn0 0.15122f
C9432 sg13cmos5l_dlygate4sd3_1_56.X VDD 0.24732f
C9433 a_7199_6432# VDD 0.26734f
C9434 sg13cmos5l_inv_1_17.A VDD 1.0697f
C9435 sg13cmos5l_nand3_1_3.Y a_10896_8052# 0.1548f
C9436 a_17604_11464# a_18021_11471# 0.28418f
C9437 sg13cmos5l_a21oi_1_2.A2 a_17015_9577# 0.04416f
C9438 sg13cmos5l_a21oi_1_4.A1 sg13cmos5l_nand4_1_3.B 0.07799f
C9439 sg13cmos5l_dfrbpq_1_7.D sg13cmos5l_dfrbpq_1_11.Q 0.01219f
C9440 sg13cmos5l_dlygate4sd3_1_98.A a_20015_17869# 0.03967f
C9441 a_8993_7190# sg13cmos5l_a21oi_1_10.A1 0.03604f
C9442 sg13cmos5l_buf_1_7.X sg13cmos5l_dfrbpq_1_9.D 0.06292f
C9443 sg13cmos5l_o21ai_1_18.B1 a_12134_19458# 0.05139f
C9444 sg13cmos5l_o21ai_1_26.B1 sg13cmos5l_buf_1_47.X 0.04087f
C9445 sg13cmos5l_inv_1_16.Y sg13cmos5l_a21oi_1_23.A2 0.2725f
C9446 sg13cmos5l_mux2_1_1.A1 sg13cmos5l_mux2_1_1.A0 0.26733f
C9447 a_9464_17549# sg13cmos5l_o21ai_1_14.A1 0.09372f
C9448 sg13cmos5l_o21ai_1_21.Y VDD 0.36515f
C9449 a_10510_19287# VDD 0.15895f
C9450 sg13cmos5l_nand4_1_1.B sg13cmos5l_inv_1_16.A 0.025f
C9451 sg13cmos5l_dfrbpq_1_28.RESET_B a_20580_12528# 0.26666f
C9452 sg13cmos5l_o21ai_1_13.B1 a_11670_19044# 0.02004f
C9453 VDD code4 0.2458f
C9454 sg13cmos5l_buf_1_45.X sg13cmos5l_buf_1_59.A 0.06221f
C9455 sg13cmos5l_buf_1_5.A sg13cmos5l_buf_1_6.A 0.28571f
C9456 sg13cmos5l_dlygate4sd3_1_18.A sg13cmos5l_buf_1_5.A 0.35514f
C9457 a_15935_7944# a_16725_7832# 0.02241f
C9458 sg13cmos5l_nor3_1_2.B a_8206_9375# 0.01487f
C9459 sg13cmos5l_nand3b_1_1.C sg13cmos5l_buf_1_65.A 0.46897f
C9460 sg13cmos5l_dfrbpq_1_28.RESET_B sg13cmos5l_nand4_1_7.B 0.10358f
C9461 a_10864_19990# code4 0.01129f
C9462 sg13cmos5l_buf_1_10.A a_22241_9376# 0.01094f
C9463 sg13cmos5l_dfrbpq_1_37.D sg13cmos5l_inv_1_15.A 1.09967f
C9464 sg13cmos5l_dfrbpq_1_24.RESET_B sg13cmos5l_dfrbpq_1_20.D 0.0658f
C9465 sg13cmos5l_buf_8_2.A sg13cmos5l_a22oi_1_0.B2 0.05166f
C9466 a_8139_9959# a_8879_10309# 0.17382f
C9467 sg13cmos5l_a21oi_1_2.B1 a_17386_6892# 0.01384f
C9468 a_7736_7678# sg13cmos5l_nand2b_1_4.Y 0.02154f
C9469 sg13cmos5l_inv_1_7.A bp7 0.02431f
C9470 sg13cmos5l_inv_1_31.A sg13cmos5l_dlygate4sd3_1_74.A 0.0521f
C9471 a_22522_9154# bp3 0.01802f
C9472 sg13cmos5l_inv_1_8.A VDD 1.34833f
C9473 sg13cmos5l_inv_1_19.Y sg13cmos5l_nor2_1_2.A 0.09435f
C9474 a_20997_13701# a_20868_13735# 0.01562f
C9475 sg13cmos5l_a21oi_1_20.Y VDD 0.17014f
C9476 sg13cmos5l_dfrbpq_1_13.CLK a_16954_11424# 0.01136f
C9477 a_6958_19959# sg13cmos5l_o21ai_1_7.Y 0.01331f
C9478 a_15905_7190# VDD 0.20661f
C9479 sg13cmos5l_inv_1_17.A bp6 0.05815f
C9480 sg13cmos5l_dfrbpq_1_15.Q a_9274_6888# 0.29013f
C9481 sg13cmos5l_dlygate4sd3_1_25.A VDD 0.35943f
C9482 sg13cmos5l_buf_1_15.A sg13cmos5l_inv_1_36.A 0.54972f
C9483 sg13cmos5l_nand4_1_3.B sg13cmos5l_mux2_1_1.A1 0.15343f
C9484 sg13cmos5l_dlygate4sd3_1_43.X a_6577_7751# 0.02034f
C9485 a_4906_18988# VDD 0.09518f
C9486 sg13cmos5l_inv_1_7.A a_19048_3900# 0.02195f
C9487 sg13cmos5l_nor3_1_2.A a_6682_8400# 0.0184f
C9488 sg13cmos5l_buf_1_15.A a_22042_15202# 0.01306f
C9489 sg13cmos5l_buf_1_16.A a_18382_6351# 0.03496f
C9490 sg13cmos5l_o21ai_1_21.A2 a_6490_16714# 0.01156f
C9491 sg13cmos5l_a22oi_1_2.Y VDD 0.4593f
C9492 a_17355_19892# a_18352_19990# 0.03412f
C9493 sg13cmos5l_a21oi_1_4.A1 sg13cmos5l_buf_1_21.A 0.92594f
C9494 a_13434_6887# VDD 0.1824f
C9495 a_5412_7992# a_5931_7796# 0.20773f
C9496 sg13cmos5l_inv_1_20.Y sg13cmos5l_inv_1_18.A 0.12669f
C9497 sg13cmos5l_nor4_1_2.Y sg13cmos5l_inv_1_24.Y 0.0641f
C9498 a_19467_5423# a_20464_5654# 0.03546f
C9499 sg13cmos5l_nand4_1_15.B sg13cmos5l_nand4_1_18.D 0.15842f
C9500 valid code0 0.07844f
C9501 bn1 busy 0.68355f
C9502 code1 bn5 0.15442f
C9503 sg13cmos5l_a21oi_1_19.Y a_16945_18335# 0.01756f
C9504 sg13cmos5l_nand4_1_8.B sg13cmos5l_a21oi_1_20.A2 0.03746f
C9505 sg13cmos5l_inv_1_22.Y VDD 0.12162f
C9506 sg13cmos5l_o21ai_1_20.B1 a_6670_18447# 0.0451f
C9507 sg13cmos5l_buf_1_10.A sg13cmos5l_buf_1_13.A 0.02573f
C9508 sg13cmos5l_nand2_1_0.B a_13505_7864# 0.02247f
C9509 a_12224_6294# VDD 0.0658f
C9510 sg13cmos5l_nand4_1_7.B bn1 0.01584f
C9511 a_9867_19892# VDD 0.20335f
C9512 sg13cmos5l_nand3b_1_0.C a_14264_10702# 0.01936f
C9513 a_4182_19044# sg13cmos5l_dlygate4sd3_1_51.X 0.13267f
C9514 a_15214_10215# a_15329_10214# 0.3854f
C9515 sg13cmos5l_inv_1_8.A a_15016_5498# 0.02711f
C9516 a_10592_6294# VDD 0.06411f
C9517 a_7354_16714# VDD 0.26932f
C9518 a_22522_3106# VDD 0.25434f
C9519 sg13cmos5l_nand4_1_18.B sg13cmos5l_nand2_1_15.Y 0.01788f
C9520 sg13cmos5l_nand2_1_19.Y a_12045_11808# 0.02827f
C9521 sg13cmos5l_inv_1_17.A a_22241_6352# 0.03798f
C9522 sg13cmos5l_dfrbpq_1_27.Q a_22096_14726# 0.04154f
C9523 a_9867_19892# a_10864_19990# 0.03412f
C9524 a_15023_16357# VDD 0.17655f
C9525 a_10042_6130# VDD 0.26759f
C9526 a_20012_14448# sg13cmos5l_nand4_1_18.A 0.15437f
C9527 sg13cmos5l_dfrbpq_1_47.Q sg13cmos5l_o21ai_1_0.Y 0.32242f
C9528 sg13cmos5l_nand4_1_18.A sg13cmos5l_a21oi_1_2.A2 0.22446f
C9529 a_17039_18335# a_16945_18335# 0.16704f
C9530 sg13cmos5l_buf_8_2.A sg13cmos5l_dlygate4sd3_1_13.A 0.4194f
C9531 sg13cmos5l_buf_1_42.A a_18101_14020# 0.02249f
C9532 sg13cmos5l_buf_1_43.X sg13cmos5l_a21oi_1_16.A2 0.14828f
C9533 sg13cmos5l_dfrbpq_1_28.D sg13cmos5l_a21oi_1_15.Y 0.09809f
C9534 sg13cmos5l_inv_1_12.Y sg13cmos5l_dlygate4sd3_1_18.A 0.03768f
C9535 sg13cmos5l_buf_8_2.A a_18094_9375# 0.01685f
C9536 a_17604_11464# a_18863_11821# 0.01412f
C9537 sg13cmos5l_o21ai_1_18.B1 a_12239_18335# 0.02476f
C9538 sg13cmos5l_nand4_1_18.B sg13cmos5l_nand4_1_15.B 0.12037f
C9539 a_19649_13238# VDD 0.20642f
C9540 sg13cmos5l_buf_1_43.X sg13cmos5l_inv_1_16.Y 0.10491f
C9541 VDD bp0 0.54721f
C9542 sg13cmos5l_nor3_1_2.B sg13cmos5l_a22oi_1_0.B2 0.4038f
C9543 sg13cmos5l_buf_1_5.A sg13cmos5l_inv_1_7.A 0.08445f
C9544 sg13cmos5l_inv_1_15.A sg13cmos5l_nand4_1_18.A 0.0211f
C9545 a_20554_12433# VDD 0.0945f
C9546 sg13cmos5l_o21ai_1_25.Y sg13cmos5l_buf_8_2.A 0.02978f
C9547 sg13cmos5l_mux2_1_0.A1 a_12381_13912# 0.1866f
C9548 sg13cmos5l_a21oi_1_0.A2 sg13cmos5l_a21oi_1_2.B1 0.03604f
C9549 sg13cmos5l_buf_1_10.A bp7 0.02828f
C9550 a_9185_18448# VDD 0.206f
C9551 sg13cmos5l_inv_1_1.Y a_20554_13945# 0.01763f
C9552 sg13cmos5l_dfrbpq_1_13.RESET_B a_10917_9959# 0.0371f
C9553 a_10625_19286# VDD 0.20828f
C9554 a_5998_17775# VDD 0.15922f
C9555 sg13cmos5l_o21ai_1_20.B1 sg13cmos5l_o21ai_1_20.Y 0.22325f
C9556 sg13cmos5l_nand4_1_18.D sg13cmos5l_a21oi_1_15.A2 0.03099f
C9557 sg13cmos5l_buf_1_7.X sg13cmos5l_dfrbpq_1_0.D 0.08877f
C9558 sg13cmos5l_nand4_1_1.B sg13cmos5l_nor4_1_1.D 0.26682f
C9559 sg13cmos5l_nand3_1_0.B sg13cmos5l_nand2_1_2.Y 0.14836f
C9560 a_16954_11424# a_16673_11726# 0.18796f
C9561 a_22241_4166# bp5 0.04698f
C9562 sg13cmos5l_buf_1_0.A a_18374_7674# 0.02f
C9563 sg13cmos5l_nand3_1_0.B sg13cmos5l_buf_1_13.A 0.02141f
C9564 sg13cmos5l_buf_1_16.A sg13cmos5l_dfrbpq_1_28.D 0.01237f
C9565 sg13cmos5l_a21oi_1_2.B1 sg13cmos5l_inv_1_14.Y 0.30766f
C9566 sg13cmos5l_nand2_1_1.A a_19930_12936# 0.07407f
C9567 sg13cmos5l_buf_1_4.A a_21754_5376# 0.06033f
C9568 sg13cmos5l_buf_1_13.X a_17290_8404# 0.19326f
C9569 a_4838_15238# VDD 0.20153f
C9570 sg13cmos5l_dfrbpq_1_5.CLK a_20997_11471# 0.21996f
C9571 sg13cmos5l_inv_1_31.A sg13cmos5l_dfrbpq_1_5.CLK 0.14963f
C9572 a_8879_10309# sg13cmos5l_or4_1_0.C 0.01217f
C9573 sg13cmos5l_inv_1_19.Y sg13cmos5l_nand2b_1_4.Y 0.13869f
C9574 a_7338_7972# sg13cmos5l_dlygate4sd3_1_43.A 0.05571f
C9575 sg13cmos5l_dfrbpq_1_13.RESET_B a_7334_10386# 0.098f
C9576 sg13cmos5l_a21oi_1_4.A2 a_13738_15964# 0.01646f
C9577 sg13cmos5l_inv_1_31.A sg13cmos5l_a21oi_1_18.B1 0.08249f
C9578 a_21215_18528# a_21084_18222# 0.28418f
C9579 sg13cmos5l_dfrbpq_1_2.D sg13cmos5l_inv_1_11.Y 1.20711f
C9580 a_22096_13942# a_22506_14020# 0.07015f
C9581 a_17829_6935# VDD 0.24598f
C9582 sg13cmos5l_or4_1_0.C sg13cmos5l_dfrbpq_1_17.Q 0.13356f
C9583 a_3415_16710# a_3975_16964# 0.17382f
C9584 a_14423_14113# sg13cmos5l_nand2_1_15.Y 0.16718f
C9585 sg13cmos5l_inv_1_5.A a_15790_7191# 0.01952f
C9586 a_12814_19959# a_12929_19960# 0.3854f
C9587 sg13cmos5l_nor3_1_0.Y a_15488_12342# 0.02421f
C9588 sg13cmos5l_buf_1_20.A sg13cmos5l_a21oi_1_4.A2 0.03907f
C9589 sg13cmos5l_inv_1_31.A sg13cmos5l_dlygate4sd3_1_82.A 0.11578f
C9590 a_20503_18222# a_21084_18222# 0.01412f
C9591 sg13cmos5l_inv_1_2.A a_18948_5416# 0.0718f
C9592 sg13cmos5l_inv_1_1.Y a_20406_6230# 0.04376f
C9593 sg13cmos5l_nand4_1_7.B sg13cmos5l_nor3_1_4.A 0.02364f
C9594 a_6191_19381# VDD 0.17464f
C9595 sg13cmos5l_nand4_1_18.B sg13cmos5l_a21oi_1_15.A2 0.03087f
C9596 sg13cmos5l_dfrbpq_1_17.Q a_7338_7972# 0.09429f
C9597 sg13cmos5l_nand2b_1_1.A_N sg13cmos5l_nor2b_1_2.Y 0.11452f
C9598 sg13cmos5l_nand2_1_1.A sg13cmos5l_buf_1_13.X 0.16869f
C9599 a_5126_7674# a_5700_7687# 0.18486f
C9600 sg13cmos5l_nand2b_1_1.A_N a_14264_10702# 0.05928f
C9601 sg13cmos5l_nand2b_1_0.B a_13018_7678# 0.01965f
C9602 a_3879_16083# a_4727_16043# 0.07916f
C9603 a_4031_15967# a_4821_16043# 0.02241f
C9604 sg13cmos5l_nand4_1_3.B sg13cmos5l_nor3_1_4.A 0.12295f
C9605 sg13cmos5l_a21oi_1_18.B1 sg13cmos5l_nor3_1_6.Y 0.02342f
C9606 sg13cmos5l_nand2_1_5.Y VDD 0.43677f
C9607 sg13cmos5l_o21ai_1_3.Y sg13cmos5l_dfrbpq_1_2.D 0.07747f
C9608 sg13cmos5l_a21oi_1_9.A1 a_10811_4948# 0.06516f
C9609 sg13cmos5l_buf_1_43.X code1 0.13363f
C9610 a_3532_16434# a_3879_16083# 0.03412f
C9611 a_3900_16357# a_3790_16434# 0.25046f
C9612 sg13cmos5l_a21oi_1_27.B1 a_9526_16742# 0.01322f
C9613 sg13cmos5l_dfrbpq_1_24.RESET_B a_3900_16357# 0.32009f
C9614 sg13cmos5l_nand4_1_18.A sg13cmos5l_a21oi_1_1.A2 0.53559f
C9615 sg13cmos5l_buf_1_10.A sg13cmos5l_buf_1_5.A 0.01886f
C9616 sg13cmos5l_nand4_1_16.D VDD 0.44856f
C9617 sg13cmos5l_o21ai_1_21.B1 a_4360_19808# 0.20877f
C9618 sg13cmos5l_inv_1_18.A sg13cmos5l_nand2_1_0.B 1.04227f
C9619 sg13cmos5l_buf_8_2.A valid 0.22487f
C9620 sg13cmos5l_a21oi_1_18.B1 sg13cmos5l_nand4_1_8.B 0.01372f
C9621 a_13782_15302# VDD 0.15929f
C9622 a_21089_19960# VDD 0.20284f
C9623 sg13cmos5l_o21ai_1_11.Y a_6524_15552# 0.01087f
C9624 sg13cmos5l_a21oi_1_9.Y a_10811_4948# 0.09952f
C9625 sg13cmos5l_dfrbpq_1_28.RESET_B a_18730_18988# 0.20139f
C9626 sg13cmos5l_buf_1_7.X sg13cmos5l_a21oi_1_6.Y 0.0331f
C9627 a_15780_18576# sg13cmos5l_buf_1_16.A 0.0103f
C9628 sg13cmos5l_buf_8_2.A a_19542_9254# 0.02761f
C9629 sg13cmos5l_dlygate4sd3_1_22.A a_19430_9190# 0.011f
C9630 sg13cmos5l_inv_1_31.A sg13cmos5l_buf_1_1.A 0.02234f
C9631 a_19649_4840# a_19930_4618# 0.18796f
C9632 a_19120_11702# a_18863_11821# 0.23043f
C9633 sg13cmos5l_o21ai_1_18.B1 a_12145_18335# 0.01405f
C9634 sg13cmos5l_buf_1_15.A sg13cmos5l_nand3_1_0.A 0.03618f
C9635 sg13cmos5l_o21ai_1_7.A2 sg13cmos5l_o21ai_1_10.A2 0.02244f
C9636 sg13cmos5l_o21ai_1_20.A1 sg13cmos5l_dfrbpq_1_23.Q 0.01222f
C9637 sg13cmos5l_buf_1_13.A a_13212_5773# 0.27419f
C9638 a_19534_4839# a_19328_4782# 0.01604f
C9639 sg13cmos5l_inv_1_0.A VDD 0.44269f
C9640 sg13cmos5l_or2_1_1.X a_12120_8416# 0.01192f
C9641 a_21839_12287# VDD 0.17188f
C9642 sg13cmos5l_buf_1_20.A sg13cmos5l_buf_1_57.A 0.02385f
C9643 sg13cmos5l_buf_1_45.X sg13cmos5l_dlygate4sd3_1_82.X 0.32321f
C9644 a_13676_19734# bn0 0.01408f
C9645 sg13cmos5l_nand4_1_17.Y a_18286_16935# 0.04901f
C9646 sg13cmos5l_dfrbpq_1_45.Q a_8682_11460# 0.07591f
C9647 sg13cmos5l_buf_1_0.A sg13cmos5l_a21oi_1_2.Y 0.04857f
C9648 sg13cmos5l_dfrbpq_1_7.D a_20554_9916# 0.01105f
C9649 sg13cmos5l_nand3b_1_3.C a_14181_16007# 0.0173f
C9650 sg13cmos5l_a21oi_1_6.A2 sg13cmos5l_dlygate4sd3_1_22.A 0.02008f
C9651 sg13cmos5l_dfrbpq_1_13.RESET_B a_12016_10190# 0.09625f
C9652 a_10172_19000# VDD 0.01784f
C9653 a_5792_17594# VDD 0.07961f
C9654 sg13cmos5l_a21oi_1_9.A2 a_11278_6351# 0.03944f
C9655 a_21256_3176# bp5 0.07149f
C9656 sg13cmos5l_inv_1_12.A sg13cmos5l_inv_1_2.A 0.42795f
C9657 sg13cmos5l_inv_1_31.A a_19275_19031# 0.03026f
C9658 sg13cmos5l_o21ai_1_7.B1 sg13cmos5l_o21ai_1_9.A2 0.03054f
C9659 sg13cmos5l_o21ai_1_26.B1 sg13cmos5l_o21ai_1_24.Y 0.02878f
C9660 sg13cmos5l_buf_1_13.X a_18832_8678# 0.09635f
C9661 a_20554_9916# a_20580_9952# 0.24169f
C9662 sg13cmos5l_a21oi_1_27.B1 sg13cmos5l_nand4_1_18.B 0.4337f
C9663 sg13cmos5l_nand3b_1_1.C sg13cmos5l_o21ai_1_14.A1 0.01475f
C9664 sg13cmos5l_o21ai_1_21.B1 sg13cmos5l_dlygate4sd3_1_51.X 0.13687f
C9665 sg13cmos5l_buf_1_13.X sg13cmos5l_dfrbpq_1_11.Q 0.02769f
C9666 a_21084_18222# a_22005_18416# 0.24169f
C9667 sg13cmos5l_nand3_1_0.B sg13cmos5l_buf_1_5.A 0.06533f
C9668 a_19338_6924# VDD 0.27671f
C9669 sg13cmos5l_buf_8_2.A sg13cmos5l_nand4_1_15.B 0.62139f
C9670 sg13cmos5l_inv_1_1.A sg13cmos5l_nand2_1_15.B 0.01074f
C9671 sg13cmos5l_buf_1_15.A busy 0.05338f
C9672 sg13cmos5l_nor3_1_2.C sg13cmos5l_nor2_1_2.B 0.02254f
C9673 sg13cmos5l_mux2_1_0.A1 a_8734_12214# 0.09623f
C9674 sg13cmos5l_o21ai_1_1.B1 sg13cmos5l_buf_1_14.A 0.02016f
C9675 a_7354_19738# sg13cmos5l_dfrbpq_1_21.D 0.09301f
C9676 sg13cmos5l_dfrbpq_1_13.RESET_B a_5126_7674# 0.12117f
C9677 sg13cmos5l_dlygate4sd3_1_20.A bp1 0.04037f
C9678 a_20494_15423# VDD 0.1591f
C9679 sg13cmos5l_nor3_1_2.Y sg13cmos5l_nor3_1_2.C 0.08795f
C9680 sg13cmos5l_buf_1_15.A sg13cmos5l_nand4_1_7.B 0.05017f
C9681 sg13cmos5l_dlygate4sd3_1_3.A bp5 0.14079f
C9682 a_7498_18988# VDD 0.09469f
C9683 sg13cmos5l_inv_1_0.A bp6 0.01826f
C9684 sg13cmos5l_buf_1_0.A sg13cmos5l_inv_1_6.Y 0.01704f
C9685 sg13cmos5l_inv_1_12.Y sg13cmos5l_buf_1_10.A 0.08843f
C9686 a_6640_9406# sg13cmos5l_dlygate4sd3_1_42.A 0.04981f
C9687 sg13cmos5l_nand3_1_2.A sg13cmos5l_nand3b_1_0.C 0.04425f
C9688 sg13cmos5l_nand2b_1_1.A_N a_14534_10702# 0.04512f
C9689 sg13cmos5l_nand2_1_1.A sg13cmos5l_inv_1_13.Y 0.02579f
C9690 sg13cmos5l_nand4_1_1.B sg13cmos5l_o21ai_1_5.A1 0.36538f
C9691 sg13cmos5l_o21ai_1_7.B1 sg13cmos5l_a21oi_1_27.B1 0.604f
C9692 sg13cmos5l_nor2_1_2.A a_7047_6380# 0.0142f
C9693 sg13cmos5l_dfrbpq_1_29.Q bn7 0.03314f
C9694 sg13cmos5l_buf_1_15.A sg13cmos5l_nand4_1_3.B 0.11584f
C9695 a_22126_17775# a_21920_17594# 0.01604f
C9696 sg13cmos5l_nor4_1_4.C sg13cmos5l_dfrbpq_1_18.Q 0.02456f
C9697 sg13cmos5l_buf_8_2.A bp2 0.05205f
C9698 a_17445_15213# VDD 0.24912f
C9699 sg13cmos5l_nand3_1_5.Y sg13cmos5l_o21ai_1_14.A1 0.19139f
C9700 sg13cmos5l_inv_1_36.A sg13cmos5l_o21ai_1_9.B1 0.31895f
C9701 a_18470_19458# VDD 0.52442f
C9702 sg13cmos5l_a21oi_1_2.Y a_21745_7285# 0.01358f
C9703 sg13cmos5l_inv_1_17.A a_22506_8436# 0.01134f
C9704 sg13cmos5l_nand3b_1_3.C a_4932_19024# 0.01003f
C9705 sg13cmos5l_dfrbpq_1_28.RESET_B a_18954_15532# 0.0145f
C9706 sg13cmos5l_buf_1_4.A a_20398_4167# 0.04025f
C9707 sg13cmos5l_inv_1_32.Y a_13478_16434# 0.03168f
C9708 sg13cmos5l_a21oi_1_7.A2 a_21099_11471# 0.05764f
C9709 a_22234_19738# VDD 0.27818f
C9710 sg13cmos5l_inv_1_1.A sg13cmos5l_nor3_1_6.Y 0.02669f
C9711 sg13cmos5l_dfrbpq_1_28.RESET_B a_20272_19262# 0.09623f
C9712 sg13cmos5l_a21o_1_0.A1 VDD 0.22095f
C9713 sg13cmos5l_dfrbpq_1_13.CLK a_11674_6130# 0.01565f
C9714 sg13cmos5l_nor2b_1_0.B_N sg13cmos5l_buf_1_10.A 0.44193f
C9715 sg13cmos5l_a21oi_1_1.A2 sg13cmos5l_dlygate4sd3_1_22.A 0.01692f
C9716 sg13cmos5l_nand4_1_18.A sg13cmos5l_dlygate4sd3_1_76.A 0.09631f
C9717 sg13cmos5l_dfrbpq_1_0.D bp4 0.01198f
C9718 sg13cmos5l_buf_1_1.A a_22506_11460# 0.0457f
C9719 sg13cmos5l_buf_8_2.A sg13cmos5l_a21oi_1_15.A2 0.01699f
C9720 a_20294_4650# a_20997_4629# 0.02453f
C9721 a_17338_18984# VDD 0.25984f
C9722 sg13cmos5l_dfrbpq_1_19.CLK sg13cmos5l_nand3b_1_3.C 0.28154f
C9723 sg13cmos5l_nand4_1_16.D a_16832_16082# 0.03026f
C9724 sg13cmos5l_and2_1_3.X sg13cmos5l_a21oi_1_20.A2 0.15448f
C9725 sg13cmos5l_inv_1_1.A sg13cmos5l_inv_1_9.Y 0.03253f
C9726 sg13cmos5l_inv_1_36.A sg13cmos5l_a21o_1_2.X 0.01466f
C9727 a_8602_9154# VDD 0.25992f
C9728 sg13cmos5l_buf_8_2.A a_18209_9376# 0.02047f
C9729 sg13cmos5l_nand3b_1_3.C sg13cmos5l_nor2_1_7.Y 0.0254f
C9730 sg13cmos5l_buf_1_63.A a_20110_19959# 0.11433f
C9731 sg13cmos5l_a21oi_1_9.A2 sg13cmos5l_o21ai_1_4.Y 0.14872f
C9732 sg13cmos5l_o21ai_1_17.Y sg13cmos5l_o21ai_1_20.A1 0.01024f
C9733 sg13cmos5l_nand4_1_8.B sg13cmos5l_inv_1_1.A 0.01582f
C9734 sg13cmos5l_nand2_1_13.A sg13cmos5l_dfrbpq_1_13.RESET_B 0.01969f
C9735 sg13cmos5l_dfrbpq_1_30.Q sg13cmos5l_nand2_1_1.A 0.04215f
C9736 sg13cmos5l_buf_1_65.A a_9557_11460# 0.01056f
C9737 sg13cmos5l_buf_1_15.A sg13cmos5l_buf_1_21.A 0.02356f
C9738 sg13cmos5l_inv_1_1.Y bn8 1.3816f
C9739 sg13cmos5l_nand3_1_0.B a_15976_12972# 0.01887f
C9740 a_5626_19738# VDD 0.25524f
C9741 sg13cmos5l_buf_1_63.A code0 0.01944f
C9742 sg13cmos5l_nand3_1_2.Y sg13cmos5l_nand3b_1_0.C 0.03623f
C9743 sg13cmos5l_nand3b_1_1.C sg13cmos5l_o21ai_1_10.A2 0.02277f
C9744 sg13cmos5l_o21ai_1_5.A2 a_9096_15996# 0.10827f
C9745 sg13cmos5l_buf_1_9.A a_17290_8404# 0.0139f
C9746 sg13cmos5l_buf_1_13.X a_17604_11464# 0.26545f
C9747 a_20997_9959# sg13cmos5l_inv_1_2.A 0.20587f
C9748 sg13cmos5l_nor3_1_2.B a_9394_8814# 0.08295f
C9749 sg13cmos5l_nand4_1_1.A sg13cmos5l_inv_1_13.Y 0.05877f
C9750 sg13cmos5l_buf_1_16.A valid 0.0366f
C9751 sg13cmos5l_buf_8_2.A sg13cmos5l_o21ai_1_9.A2 0.02577f
C9752 sg13cmos5l_dfrbpq_1_5.CLK sg13cmos5l_inv_1_25.Y 0.14195f
C9753 sg13cmos5l_inv_1_11.Y sg13cmos5l_buf_1_0.A 0.46265f
C9754 sg13cmos5l_a21oi_1_18.B1 sg13cmos5l_inv_1_25.Y 0.09129f
C9755 sg13cmos5l_nand3b_1_3.C a_6394_17472# 0.01511f
C9756 sg13cmos5l_nand3_1_2.A sg13cmos5l_nand2b_1_1.A_N 0.02308f
C9757 sg13cmos5l_o21ai_1_9.A2 sg13cmos5l_a21o_1_2.B1 0.02556f
C9758 sg13cmos5l_dfrbpq_1_13.RESET_B a_6928_7894# 0.09962f
C9759 sg13cmos5l_o21ai_1_18.B1 sg13cmos5l_buf_1_47.X 0.20178f
C9760 sg13cmos5l_buf_1_45.X sg13cmos5l_nand4_1_6.B 0.01874f
C9761 a_21646_15423# VDD 0.15996f
C9762 sg13cmos5l_dlygate4sd3_1_50.X a_3200_16283# 0.02124f
C9763 sg13cmos5l_a21oi_1_4.A1 a_15592_10736# 0.15811f
C9764 a_9040_19262# VDD 0.13563f
C9765 sg13cmos5l_buf_1_45.X a_13676_12936# 0.15822f
C9766 sg13cmos5l_buf_1_13.X sg13cmos5l_dfrbpq_1_3.D 0.08202f
C9767 sg13cmos5l_a21oi_1_2.B1 a_20294_6166# 0.03617f
C9768 sg13cmos5l_buf_1_0.A a_15783_7892# 0.02057f
C9769 a_7822_19959# sg13cmos5l_o21ai_1_7.Y 0.02009f
C9770 sg13cmos5l_nand3_1_3.Y a_10607_5773# 0.01959f
C9771 a_3776_18433# VDD 0.27825f
C9772 sg13cmos5l_dfrbpq_1_15.Q a_7841_8702# 0.01076f
C9773 sg13cmos5l_a21oi_1_4.A1 sg13cmos5l_nor3_1_0.Y 0.31248f
C9774 sg13cmos5l_nand4_1_1.B sg13cmos5l_o21ai_1_5.A2 0.01289f
C9775 a_9348_20088# code5 0.03679f
C9776 sg13cmos5l_nand4_1_12.Y bn4 0.02623f
C9777 sg13cmos5l_nand3_1_5.Y sg13cmos5l_o21ai_1_10.A2 0.02376f
C9778 a_15405_11808# VDD 0.28732f
C9779 sg13cmos5l_a21oi_1_19.Y a_17051_15996# 0.10033f
C9780 sg13cmos5l_a21oi_1_6.Y bp4 0.13521f
C9781 sg13cmos5l_o21ai_1_23.B1 a_12886_15230# 0.02425f
C9782 a_5541_9165# a_6289_9263# 0.01058f
C9783 a_18287_15311# VDD 0.17352f
C9784 sg13cmos5l_a21oi_1_27.B1 sg13cmos5l_buf_8_2.A 0.0545f
C9785 sg13cmos5l_dlygate4sd3_1_20.A a_22522_9154# 0.29529f
C9786 sg13cmos5l_dlygate4sd3_1_76.A a_20868_13735# 0.01747f
C9787 sg13cmos5l_nor2b_1_2.Y VDD 0.55709f
C9788 sg13cmos5l_a21oi_1_8.A2 a_7904_5498# 0.02186f
C9789 a_14264_10702# VDD 0.26475f
C9790 sg13cmos5l_dfrbpq_1_15.CLK a_7199_6432# 0.20707f
C9791 sg13cmos5l_a21oi_1_27.B1 sg13cmos5l_a21o_1_2.B1 0.15425f
C9792 a_3790_16434# a_4031_15967# 0.01058f
C9793 sg13cmos5l_a21oi_1_4.A1 a_7736_13726# 0.03547f
C9794 sg13cmos5l_nand3_1_0.A sg13cmos5l_a21oi_1_3.Y 0.01638f
C9795 sg13cmos5l_dfrbpq_1_24.RESET_B a_4031_15967# 0.04627f
C9796 sg13cmos5l_a22oi_1_0.A2 sg13cmos5l_dlygate4sd3_1_8.X 0.05657f
C9797 sg13cmos5l_dlygate4sd3_1_24.A sg13cmos5l_dlygate4sd3_1_3.A 0.19934f
C9798 sg13cmos5l_buf_1_16.A sg13cmos5l_nand4_1_15.B 0.01779f
C9799 sg13cmos5l_nand3b_1_0.C sg13cmos5l_nand3_1_1.Y 0.01958f
C9800 sg13cmos5l_inv_1_16.A a_20580_14040# 0.01708f
C9801 sg13cmos5l_buf_1_6.A sg13cmos5l_inv_1_7.A 0.02586f
C9802 a_21099_4772# a_21839_4727# 0.17382f
C9803 sg13cmos5l_dlygate4sd3_1_50.X sg13cmos5l_o21ai_1_7.B1 0.18854f
C9804 sg13cmos5l_nand2_1_0.A sg13cmos5l_nor3_1_2.B 0.14392f
C9805 sg13cmos5l_nand4_1_12.Y VDD 0.7983f
C9806 a_21084_16710# VDD 0.0721f
C9807 sg13cmos5l_nand2b_1_1.A_N a_9885_7194# 0.14111f
C9808 sg13cmos5l_dlygate4sd3_1_72.A sg13cmos5l_dfrbpq_1_30.Q 0.06049f
C9809 sg13cmos5l_buf_1_47.X bn1 0.20574f
C9810 sg13cmos5l_buf_1_57.A a_13670_15238# 0.01195f
C9811 sg13cmos5l_a21oi_1_27.A1 a_10316_12936# 0.03379f
C9812 sg13cmos5l_and4_1_0.D a_11678_7972# 0.01059f
C9813 a_14244_20088# busy 0.02376f
C9814 sg13cmos5l_a21oi_1_24.A1 a_17345_17856# 0.0116f
C9815 sg13cmos5l_buf_1_7.X a_20554_6892# 0.17485f
C9816 sg13cmos5l_o21ai_1_20.A1 sg13cmos5l_o21ai_1_11.Y 0.02289f
C9817 sg13cmos5l_inv_1_18.A sg13cmos5l_inv_1_18.Y 0.08019f
C9818 sg13cmos5l_inv_1_16.A sg13cmos5l_inv_1_12.Y 0.01304f
C9819 sg13cmos5l_buf_1_54.A sg13cmos5l_nand4_1_7.B 0.01908f
C9820 sg13cmos5l_a21oi_1_15.A2 sg13cmos5l_a21oi_1_15.Y 0.82793f
C9821 sg13cmos5l_nand4_1_1.C bn6 0.01635f
C9822 sg13cmos5l_nand4_1_6.B sg13cmos5l_nand3_1_2.Y 0.02059f
C9823 a_18286_16935# VDD 0.15968f
C9824 sg13cmos5l_buf_1_43.X sg13cmos5l_a21oi_1_3.A2 0.02736f
C9825 sg13cmos5l_o21ai_1_23.B1 code1 0.05354f
C9826 a_18490_9154# sg13cmos5l_nand3_1_0.Y 0.31539f
C9827 a_5312_13854# VDD 0.07497f
C9828 sg13cmos5l_a21oi_1_2.B1 sg13cmos5l_inv_1_7.Y 0.05274f
C9829 sg13cmos5l_a21oi_1_18.B1 sg13cmos5l_and2_1_3.X 0.25276f
C9830 a_19275_19031# sg13cmos5l_inv_1_25.Y 0.01174f
C9831 sg13cmos5l_dlygate4sd3_1_76.X VDD 0.20353f
C9832 sg13cmos5l_buf_1_13.X a_19120_11702# 0.09947f
C9833 a_14283_16007# sg13cmos5l_inv_1_24.Y 0.01463f
C9834 a_6286_8703# VDD 0.15907f
C9835 a_13208_11501# clk 0.02778f
C9836 sg13cmos5l_nand4_1_6.B sg13cmos5l_buf_1_42.A 0.47441f
C9837 sg13cmos5l_inv_1_13.Y a_17604_11464# 0.04996f
C9838 sg13cmos5l_dfrbpq_1_6.D VDD 0.19273f
C9839 a_5318_13410# a_6123_12983# 0.07916f
C9840 sg13cmos5l_dfrbpq_1_28.D sg13cmos5l_a21oi_1_2.B1 0.04031f
C9841 sg13cmos5l_nor3_1_2.C sg13cmos5l_nand4_1_0.C 0.20863f
C9842 sg13cmos5l_nand2_1_1.Y sg13cmos5l_nand2_1_2.Y 0.27227f
C9843 sg13cmos5l_inv_1_8.A sg13cmos5l_inv_1_11.Y 0.01872f
C9844 sg13cmos5l_buf_1_13.X a_20554_9916# 0.17223f
C9845 sg13cmos5l_buf_1_63.A sg13cmos5l_buf_8_2.A 0.04647f
C9846 sg13cmos5l_inv_1_1.Y a_19995_9190# 0.04311f
C9847 sg13cmos5l_nand4_1_17.Y sg13cmos5l_buf_1_42.A 0.33075f
C9848 sg13cmos5l_dfrbpq_1_28.RESET_B a_20294_13722# 0.10164f
C9849 sg13cmos5l_buf_1_0.A sg13cmos5l_buf_1_4.A 0.48376f
C9850 a_3996_16710# a_4778_16904# 0.24435f
C9851 sg13cmos5l_buf_1_26.A busy 0.02547f
C9852 sg13cmos5l_inv_1_9.Y a_16188_9150# 0.01088f
C9853 a_4476_18222# VDD 0.07281f
C9854 sg13cmos5l_nor3_1_2.B sg13cmos5l_nor3_1_2.A 0.1028f
C9855 sg13cmos5l_nor3_1_6.Y sg13cmos5l_nand4_1_18.D 0.02502f
C9856 a_20794_3864# a_20513_4166# 0.18796f
C9857 a_20974_6351# VDD 0.15902f
C9858 sg13cmos5l_a21oi_1_1.A2 bp3 0.02685f
C9859 a_19361_6352# VDD 0.2064f
C9860 a_22241_7864# bp1 0.02837f
C9861 sg13cmos5l_o21ai_1_0.Y a_13042_4646# 0.06019f
C9862 a_7050_9484# sg13cmos5l_or4_1_0.D 0.07745f
C9863 a_14181_16007# bn2 0.02237f
C9864 sg13cmos5l_buf_1_63.A a_12929_19960# 0.01742f
C9865 sg13cmos5l_inv_1_8.A sg13cmos5l_o21ai_1_3.Y 0.25642f
C9866 sg13cmos5l_a21oi_1_2.Y sg13cmos5l_inv_1_0.A 0.06309f
C9867 sg13cmos5l_nand4_1_8.B sg13cmos5l_nand4_1_18.D 0.48746f
C9868 sg13cmos5l_buf_1_7.X bp4 0.19089f
C9869 sg13cmos5l_dlygate4sd3_1_25.A sg13cmos5l_o21ai_1_3.Y 0.04214f
C9870 a_14534_10702# VDD 0.20815f
C9871 sg13cmos5l_nand2b_1_1.A_N sg13cmos5l_nand3_1_1.Y 0.27352f
C9872 sg13cmos5l_nand2_1_1.A a_20026_15202# 0.05617f
C9873 sg13cmos5l_nand3_1_0.A a_15935_7944# 0.01152f
C9874 sg13cmos5l_buf_1_54.A sg13cmos5l_buf_1_21.A 0.24512f
C9875 sg13cmos5l_buf_1_15.A a_9450_19020# 0.04743f
C9876 sg13cmos5l_buf_1_4.A a_20104_3176# 0.01643f
C9877 sg13cmos5l_buf_1_57.A a_17028_15552# 0.01171f
C9878 sg13cmos5l_dfrbpq_1_28.RESET_B sg13cmos5l_dfrbpq_1_37.D 0.13149f
C9879 sg13cmos5l_o21ai_1_3.Y sg13cmos5l_a22oi_1_2.Y 0.01076f
C9880 a_21839_10309# bp2 0.01025f
C9881 sg13cmos5l_nand4_1_3.B sg13cmos5l_o21ai_1_9.B1 0.01029f
C9882 sg13cmos5l_nand2b_1_1.A_N sg13cmos5l_a21oi_1_10.A1 0.21864f
C9883 sg13cmos5l_nand4_1_18.B sg13cmos5l_nor3_1_6.Y 0.14872f
C9884 sg13cmos5l_buf_1_13.A a_16644_5837# 0.0325f
C9885 a_21911_17137# VDD 0.52273f
C9886 a_16550_19770# valid 0.05296f
C9887 sg13cmos5l_dfrbpq_1_41.CLK a_11499_18380# 0.01575f
C9888 a_9062_5850# a_9636_5837# 0.18486f
C9889 a_9322_5380# a_9765_5423# 0.02241f
C9890 a_18374_18262# a_18486_18326# 0.3854f
C9891 sg13cmos5l_inv_1_17.A sg13cmos5l_buf_1_4.A 0.02911f
C9892 sg13cmos5l_nor3_1_6.Y a_19448_13730# 0.01439f
C9893 a_14218_18226# VDD 0.90661f
C9894 sg13cmos5l_dfrbpq_1_41.CLK a_12837_19031# 0.20258f
C9895 sg13cmos5l_inv_1_12.A a_21160_12972# 0.01227f
C9896 sg13cmos5l_nor4_1_2.Y sg13cmos5l_buf_1_20.A 0.09994f
C9897 sg13cmos5l_nand2_1_15.B a_14423_14113# 0.01219f
C9898 a_6394_13690# VDD 0.25711f
C9899 a_20294_7362# a_20997_6935# 0.02431f
C9900 sg13cmos5l_dfrbpq_1_6.D a_20294_8874# 0.16826f
C9901 a_15692_18984# VDD 0.18097f
C9902 sg13cmos5l_a21oi_1_0.A2 a_18575_8797# 0.02048f
C9903 sg13cmos5l_inv_1_32.Y sg13cmos5l_a21oi_1_24.A1 0.0219f
C9904 sg13cmos5l_nand4_1_3.B sg13cmos5l_a21o_1_2.X 0.07714f
C9905 sg13cmos5l_nand2_1_0.B sg13cmos5l_o21ai_1_0.A1 0.41149f
C9906 sg13cmos5l_nor3_1_7.Y a_16101_11460# 0.02599f
C9907 a_18970_14448# a_18689_14750# 0.18796f
C9908 sg13cmos5l_dfrbpq_1_35.Q sg13cmos5l_inv_1_25.Y 0.20341f
C9909 sg13cmos5l_dfrbpq_1_25.Q VDD 0.32104f
C9910 sg13cmos5l_o21ai_1_5.A1 sg13cmos5l_dlygate4sd3_1_80.X 0.0709f
C9911 sg13cmos5l_buf_1_45.X bn4 0.20295f
C9912 sg13cmos5l_inv_1_12.A a_21366_10766# 0.05088f
C9913 sg13cmos5l_buf_1_1.A a_20580_8440# 0.02541f
C9914 sg13cmos5l_nand4_1_8.B code0 0.02331f
C9915 a_15358_14850# code0 0.05664f
C9916 sg13cmos5l_a21oi_1_21.A1 a_16836_20088# 0.02845f
C9917 sg13cmos5l_a21oi_1_25.Y sg13cmos5l_dfrbpq_1_28.RESET_B 0.0391f
C9918 a_5892_13397# a_6123_12983# 0.07823f
C9919 sg13cmos5l_a21oi_1_14.Y a_22042_15202# 0.03184f
C9920 sg13cmos5l_inv_1_1.A sg13cmos5l_and2_1_3.X 0.09759f
C9921 sg13cmos5l_buf_8_2.A a_13210_12936# 0.08718f
C9922 sg13cmos5l_a21oi_1_16.A2 sg13cmos5l_inv_1_12.A 0.01377f
C9923 a_22005_16904# sg13cmos5l_inv_1_25.Y 0.01535f
C9924 a_8734_12214# a_8911_12508# 0.01068f
C9925 a_17224_12972# VDD 0.17981f
C9926 sg13cmos5l_inv_1_2.A sg13cmos5l_buf_1_0.A 0.04552f
C9927 sg13cmos5l_inv_1_16.Y sg13cmos5l_inv_1_12.A 0.01656f
C9928 sg13cmos5l_buf_1_10.A sg13cmos5l_inv_1_7.A 0.27565f
C9929 sg13cmos5l_a21oi_1_2.B1 a_18094_9375# 0.04225f
C9930 sg13cmos5l_dfrbpq_1_5.CLK a_20997_14495# 0.21619f
C9931 a_6286_16263# sg13cmos5l_o21ai_1_11.A2 0.01862f
C9932 sg13cmos5l_nand2_1_1.Y sg13cmos5l_buf_1_5.A 0.04151f
C9933 sg13cmos5l_dfrbpq_1_28.RESET_B sg13cmos5l_nand4_1_18.A 0.02578f
C9934 sg13cmos5l_dfrbpq_1_41.CLK a_17028_15552# 0.04746f
C9935 sg13cmos5l_nand3_1_2.A VDD 0.713f
C9936 sg13cmos5l_buf_1_45.X VDD 7.51236f
C9937 sg13cmos5l_inv_1_14.Y a_18922_5380# 0.01086f
C9938 a_15014_19020# sg13cmos5l_inv_1_25.Y 0.01017f
C9939 sg13cmos5l_inv_1_5.A a_15983_6239# 0.03171f
C9940 a_22426_18984# VDD 0.26453f
C9941 a_16172_14448# VDD 0.17798f
C9942 sg13cmos5l_nor2b_1_1.A a_10389_16258# 0.02099f
C9943 a_20554_6892# bp4 0.02439f
C9944 sg13cmos5l_nor3_1_6.Y a_9558_13790# 0.03467f
C9945 a_13590_11484# VDD 0.15905f
C9946 sg13cmos5l_buf_8_2.A sg13cmos5l_nand2_1_15.B 0.14098f
C9947 a_10607_19847# a_10513_19847# 0.16704f
C9948 sg13cmos5l_inv_1_36.Y sg13cmos5l_nor2b_1_0.B_N 0.01157f
C9949 sg13cmos5l_nand4_1_15.B sg13cmos5l_buf_1_53.A 0.01324f
C9950 sg13cmos5l_nand2_1_0.B a_14144_10830# 0.0381f
C9951 a_9636_5837# a_9867_5423# 0.07823f
C9952 sg13cmos5l_o21ai_1_5.A1 a_10774_10694# 0.06711f
C9953 sg13cmos5l_buf_1_66.X sg13cmos5l_nand3_1_2.Y 0.05419f
C9954 sg13cmos5l_nand2_1_18.A a_12597_11722# 0.06656f
C9955 sg13cmos5l_o21ai_1_23.B1 sg13cmos5l_o21ai_1_28.B1 0.18241f
C9956 a_10461_11730# VDD 0.23853f
C9957 sg13cmos5l_dfrbpq_1_34.Q a_17253_19749# 0.01355f
C9958 a_4736_9318# sg13cmos5l_dlygate4sd3_1_42.X 0.03662f
C9959 sg13cmos5l_nand2_1_0.A sg13cmos5l_o21ai_1_0.A2 0.3368f
C9960 sg13cmos5l_nor4_1_2.Y sg13cmos5l_dfrbpq_1_30.Q 0.14701f
C9961 sg13cmos5l_nor2_1_10.Y sg13cmos5l_inv_1_25.Y 0.02865f
C9962 sg13cmos5l_dfrbpq_1_29.Q a_22523_15532# 0.01756f
C9963 a_16299_18380# VDD 0.20501f
C9964 sg13cmos5l_inv_1_17.A sg13cmos5l_dfrbpq_1_27.Q 0.03338f
C9965 a_7616_13854# VDD 0.06591f
C9966 sg13cmos5l_inv_1_1.A sg13cmos5l_inv_1_5.A 0.05681f
C9967 sg13cmos5l_inv_1_17.A sg13cmos5l_inv_1_2.A 0.01875f
C9968 sg13cmos5l_inv_1_12.A a_21099_12332# 0.01222f
C9969 sg13cmos5l_inv_1_32.Y a_13936_19262# 0.04203f
C9970 a_3112_19902# code8 0.01067f
C9971 sg13cmos5l_buf_1_15.A sg13cmos5l_nor3_1_0.Y 0.05103f
C9972 a_9885_7194# VDD 0.19389f
C9973 a_21934_10887# sg13cmos5l_dfrbpq_1_7.D 0.1068f
C9974 sg13cmos5l_nand2b_1_1.A_N a_8061_7194# 0.12715f
C9975 sg13cmos5l_nand3_1_5.Y sg13cmos5l_dfrbpq_1_23.D 0.02089f
C9976 sg13cmos5l_nor2_1_2.Y a_8480_5498# 0.02081f
C9977 a_19642_19738# VDD 0.2577f
C9978 sg13cmos5l_nand3_1_0.A sg13cmos5l_and4_1_0.D 0.0134f
C9979 sg13cmos5l_a21oi_1_9.A2 sg13cmos5l_o21ai_1_4.A1 0.28268f
C9980 sg13cmos5l_a21oi_1_12.Y a_8411_15532# 0.09955f
C9981 sg13cmos5l_a21oi_1_13.Y a_20294_14922# 0.06007f
C9982 sg13cmos5l_inv_1_15.A bn5 0.04935f
C9983 sg13cmos5l_inv_1_16.A sg13cmos5l_dlygate4sd3_1_18.A 0.10922f
C9984 sg13cmos5l_buf_1_1.A a_21839_8797# 0.05061f
C9985 sg13cmos5l_mux2_1_1.A1 sg13cmos5l_a21oi_1_27.A1 0.34699f
C9986 sg13cmos5l_o21ai_1_18.B1 a_8434_17886# 0.04881f
C9987 sg13cmos5l_nand3_1_2.Y VDD 2.24969f
C9988 sg13cmos5l_nor3_1_6.Y sg13cmos5l_a21oi_1_13.A2 0.10571f
C9989 sg13cmos5l_inv_1_15.Y sg13cmos5l_nand4_1_7.B 0.03701f
C9990 sg13cmos5l_buf_8_2.A sg13cmos5l_nor3_1_6.Y 0.10669f
C9991 a_21099_9959# a_22096_10190# 0.03546f
C9992 sg13cmos5l_buf_1_24.A sg13cmos5l_nor2_1_12.Y 0.01404f
C9993 sg13cmos5l_nor2_1_10.Y sg13cmos5l_o21ai_1_21.A2 0.03357f
C9994 sg13cmos5l_buf_1_9.A a_20554_9916# 0.01176f
C9995 sg13cmos5l_nand4_1_1.B bn6 0.02182f
C9996 sg13cmos5l_a22oi_1_1.B2 a_9754_7678# 0.01584f
C9997 sg13cmos5l_a21o_1_2.B1 sg13cmos5l_nor3_1_6.Y 0.48695f
C9998 sg13cmos5l_buf_8_2.A sg13cmos5l_inv_1_9.Y 0.04394f
C9999 a_20984_10702# a_20997_9959# 0.01199f
C10000 sg13cmos5l_inv_1_15.Y sg13cmos5l_nand4_1_3.B 0.11107f
C10001 sg13cmos5l_inv_1_15.A sg13cmos5l_a21oi_1_23.A2 0.01247f
C10002 a_4360_19808# VDD 0.20473f
C10003 sg13cmos5l_buf_1_42.A VDD 1.15607f
C10004 sg13cmos5l_nor2_1_2.B sg13cmos5l_a21oi_1_10.A2 0.97012f
C10005 bp8 bp3 0.03286f
C10006 bp7 bp5 0.02f
C10007 sg13cmos5l_buf_8_2.A sg13cmos5l_nand4_1_8.B 0.02265f
C10008 a_22241_3328# bp9 0.0177f
C10009 sg13cmos5l_buf_1_9.A sg13cmos5l_dlygate4sd3_1_4.A 0.23928f
C10010 a_22126_4167# a_22241_4166# 0.3854f
C10011 sg13cmos5l_nand4_1_18.B sg13cmos5l_dfrbpq_1_24.Q 0.27628f
C10012 sg13cmos5l_buf_1_1.A a_21473_5678# 0.01984f
C10013 sg13cmos5l_dfrbpq_1_13.RESET_B a_7199_6432# 0.03639f
C10014 sg13cmos5l_o21ai_1_1.B1 sg13cmos5l_a21oi_1_4.B1 0.17565f
C10015 sg13cmos5l_dfrbpq_1_39.Q a_20682_17508# 0.07811f
C10016 sg13cmos5l_nor3_1_2.B a_5643_9308# 0.01864f
C10017 sg13cmos5l_buf_1_13.A a_16454_8436# 0.01347f
C10018 sg13cmos5l_o21ai_1_7.A2 sg13cmos5l_o21ai_1_14.Y 0.01048f
C10019 sg13cmos5l_dfrbpq_1_13.CLK sg13cmos5l_nand2_1_2.Y 0.02026f
C10020 a_6286_16263# VDD 0.16081f
C10021 a_20868_7349# bp4 0.01692f
C10022 sg13cmos5l_nor2_1_12.Y a_11690_17044# 0.01378f
C10023 sg13cmos5l_dfrbpq_1_13.CLK sg13cmos5l_buf_1_13.A 0.01666f
C10024 sg13cmos5l_o21ai_1_15.Y sg13cmos5l_nand3b_1_1.C 0.0101f
C10025 sg13cmos5l_inv_1_25.Y code0 0.02152f
C10026 sg13cmos5l_nand3_1_0.B sg13cmos5l_buf_1_10.A 0.02322f
C10027 sg13cmos5l_nor2b_1_1.A sg13cmos5l_nor4_1_1.D 0.02001f
C10028 a_22049_10888# bp1 0.06674f
C10029 a_5999_14845# a_5905_14845# 0.16704f
C10030 sg13cmos5l_nand4_1_18.B sg13cmos5l_o21ai_1_21.A2 0.02949f
C10031 sg13cmos5l_o21ai_1_5.A2 a_10774_10694# 0.04899f
C10032 sg13cmos5l_dlygate4sd3_1_51.X VDD 0.2447f
C10033 sg13cmos5l_nand3_1_1.Y VDD 0.77797f
C10034 a_10607_5773# a_10513_5773# 0.16704f
C10035 sg13cmos5l_dfrbpq_1_1.D a_18282_5412# 0.01836f
C10036 sg13cmos5l_a21oi_1_18.B1 sg13cmos5l_a21oi_1_25.A2 0.03999f
C10037 sg13cmos5l_nand4_1_12.Y sg13cmos5l_a21oi_1_24.A2 0.32146f
C10038 sg13cmos5l_o21ai_1_4.Y a_14542_7191# 0.01519f
C10039 sg13cmos5l_o21ai_1_18.B1 sg13cmos5l_dfrbpq_1_24.RESET_B 0.01974f
C10040 sg13cmos5l_nand4_1_15.B sg13cmos5l_nand4_1_3.D 0.02092f
C10041 a_12120_8416# VDD 0.01871f
C10042 sg13cmos5l_nand3b_1_0.C a_13749_9386# 0.10144f
C10043 sg13cmos5l_buf_1_15.A sg13cmos5l_dfrbpq_1_37.D 0.0552f
C10044 sg13cmos5l_and2_1_3.X sg13cmos5l_nand4_1_18.D 0.08792f
C10045 sg13cmos5l_dfrbpq_1_39.Q a_20716_18258# 0.02297f
C10046 a_18486_18326# sg13cmos5l_nand4_1_17.Y 0.02183f
C10047 sg13cmos5l_o21ai_1_19.Y a_7238_19458# 0.04798f
C10048 sg13cmos5l_buf_1_4.A sg13cmos5l_inv_1_0.A 0.06518f
C10049 sg13cmos5l_a21oi_1_9.B1 a_10811_4948# 0.0245f
C10050 a_16810_19993# a_16550_19770# 0.45119f
C10051 sg13cmos5l_a21oi_1_10.A1 VDD 0.37983f
C10052 a_9446_13726# VDD 0.20346f
C10053 a_20997_6935# a_21745_7285# 0.01058f
C10054 sg13cmos5l_o21ai_1_7.Y sg13cmos5l_o21ai_1_11.A2 0.048f
C10055 sg13cmos5l_a21oi_1_0.A2 a_18863_11821# 0.04067f
C10056 sg13cmos5l_inv_1_17.Y a_19179_7796# 0.01518f
C10057 sg13cmos5l_o21ai_1_0.A2 a_12826_9154# 0.02146f
C10058 sg13cmos5l_nor2_1_7.Y sg13cmos5l_o21ai_1_10.A2 0.02683f
C10059 sg13cmos5l_o21ai_1_7.B1 sg13cmos5l_o21ai_1_21.A2 0.01978f
C10060 sg13cmos5l_a21oi_1_13.Y a_21099_14495# 0.0223f
C10061 sg13cmos5l_nor2b_1_2.Y sg13cmos5l_nand2_1_6.A 0.0461f
C10062 sg13cmos5l_a21oi_1_2.B1 bp2 0.13585f
C10063 sg13cmos5l_buf_1_7.X sg13cmos5l_dfrbpq_1_5.Q 0.03054f
C10064 sg13cmos5l_a21oi_1_2.Y a_20974_6351# 0.01046f
C10065 a_22506_14020# VDD 0.27498f
C10066 sg13cmos5l_buf_1_43.X sg13cmos5l_a21oi_1_6.A2 0.01246f
C10067 sg13cmos5l_a21oi_1_27.B1 a_9056_16878# 0.0238f
C10068 sg13cmos5l_nand3b_1_1.C sg13cmos5l_nand4_1_1.B 0.02178f
C10069 sg13cmos5l_buf_1_25.A sg13cmos5l_inv_1_24.Y 0.12651f
C10070 sg13cmos5l_inv_1_15.A sg13cmos5l_buf_1_43.X 0.02149f
C10071 sg13cmos5l_buf_1_43.X a_15496_13760# 0.20188f
C10072 sg13cmos5l_nor3_1_4.A sg13cmos5l_a21oi_1_27.A1 0.1262f
C10073 sg13cmos5l_o21ai_1_0.A1 sg13cmos5l_inv_1_18.Y 0.3844f
C10074 sg13cmos5l_o21ai_1_5.A1 bn0 0.01487f
C10075 sg13cmos5l_nand4_1_18.B sg13cmos5l_and2_1_3.X 0.02175f
C10076 sg13cmos5l_a21oi_1_12.Y sg13cmos5l_a21o_1_2.A1 0.1395f
C10077 sg13cmos5l_nor3_1_6.Y sg13cmos5l_a21oi_1_15.Y 0.17172f
C10078 sg13cmos5l_inv_1_31.A sg13cmos5l_buf_1_16.A 0.09421f
C10079 a_20872_3176# bp4 0.06677f
C10080 sg13cmos5l_a21oi_1_27.B1 a_9636_12528# 0.02059f
C10081 sg13cmos5l_buf_1_63.A a_16550_19770# 0.01024f
C10082 sg13cmos5l_inv_1_4.Y VDD 0.67567f
C10083 sg13cmos5l_nor3_1_2.B sg13cmos5l_nor4_1_0.C 0.12081f
C10084 sg13cmos5l_dlygate4sd3_1_97.X bn0 0.04889f
C10085 sg13cmos5l_and4_1_1.A a_9147_13028# 0.02473f
C10086 sg13cmos5l_nand4_1_3.D sg13cmos5l_a21oi_1_15.A2 0.19535f
C10087 a_7498_18226# VDD 0.87071f
C10088 sg13cmos5l_inv_1_31.A a_19054_18447# 0.0115f
C10089 a_19930_4618# VDD 0.28648f
C10090 a_18660_11016# a_19179_10820# 0.20773f
C10091 sg13cmos5l_a21oi_1_2.B1 a_18209_9376# 0.01774f
C10092 a_16319_9456# a_17015_9577# 0.02431f
C10093 sg13cmos5l_inv_1_5.A a_16188_9150# 0.08499f
C10094 sg13cmos5l_buf_1_13.X a_18634_10921# 0.18336f
C10095 a_18952_4688# VDD 0.17773f
C10096 sg13cmos5l_buf_1_43.X sg13cmos5l_a21oi_1_17.Y 0.24375f
C10097 a_13478_16434# a_13764_16000# 0.26205f
C10098 sg13cmos5l_mux2_1_1.A0 a_8411_12252# 0.01708f
C10099 sg13cmos5l_o21ai_1_5.A2 sg13cmos5l_inv_1_24.A 0.03712f
C10100 sg13cmos5l_nor3_1_2.B sg13cmos5l_nor3_1_2.Y 1.43458f
C10101 a_17240_10702# a_17510_10702# 0.18796f
C10102 sg13cmos5l_nor3_1_2.C sg13cmos5l_dfrbpq_1_17.Q 0.03701f
C10103 sg13cmos5l_buf_1_13.A a_15223_7638# 0.11398f
C10104 sg13cmos5l_mux2_1_0.A1 a_5998_13911# 0.02461f
C10105 sg13cmos5l_nor2b_1_2.Y sg13cmos5l_inv_1_11.Y 0.02043f
C10106 sg13cmos5l_a21oi_1_3.A2 a_17518_10215# 0.01234f
C10107 sg13cmos5l_buf_1_16.A sg13cmos5l_nor3_1_6.Y 0.29274f
C10108 sg13cmos5l_o21ai_1_5.A2 a_13228_13722# 0.02034f
C10109 a_13210_12936# a_12929_13238# 0.18796f
C10110 sg13cmos5l_a21oi_1_26.A2 sg13cmos5l_nand4_1_1.B 0.01644f
C10111 sg13cmos5l_buf_1_47.X sg13cmos5l_buf_1_26.A 0.04118f
C10112 sg13cmos5l_a21oi_1_27.B1 a_8844_15424# 0.0165f
C10113 a_7350_17532# sg13cmos5l_nand3b_1_1.C 0.11297f
C10114 a_10118_18262# a_10230_18326# 0.3854f
C10115 sg13cmos5l_buf_8_2.A sg13cmos5l_dfrbpq_1_24.Q 0.01274f
C10116 a_6368_6337# a_6487_6126# 0.09257f
C10117 sg13cmos5l_o21ai_1_14.Y sg13cmos5l_nand3b_1_1.C 0.06693f
C10118 sg13cmos5l_a21oi_1_4.A1 a_6863_13333# 0.01135f
C10119 a_19534_13239# a_19240_13058# 0.01555f
C10120 a_9636_5837# clk 0.01877f
C10121 sg13cmos5l_o21ai_1_7.A2 a_8689_19381# 0.01553f
C10122 a_2920_16082# VDD 0.17909f
C10123 sg13cmos5l_buf_1_43.X sg13cmos5l_nand4_1_5.D 2.24972f
C10124 sg13cmos5l_inv_1_17.A a_22096_7166# 0.0426f
C10125 sg13cmos5l_dlygate4sd3_1_7.X sg13cmos5l_dfrbpq_1_47.D 0.05769f
C10126 sg13cmos5l_nand4_1_17.Y sg13cmos5l_inv_1_1.Y 0.15898f
C10127 sg13cmos5l_dfrbpq_1_15.CLK a_6286_8703# 0.01411f
C10128 sg13cmos5l_buf_8_2.A sg13cmos5l_inv_1_25.Y 0.03138f
C10129 sg13cmos5l_o21ai_1_19.Y a_7812_19445# 0.01828f
C10130 sg13cmos5l_buf_1_17.X a_1192_8436# 0.1544f
C10131 sg13cmos5l_o21ai_1_7.Y sg13cmos5l_buf_1_66.X 0.1863f
C10132 a_21839_7285# a_22506_6924# 0.09257f
C10133 sg13cmos5l_dfrbpq_1_41.CLK a_15126_19044# 0.04948f
C10134 sg13cmos5l_inv_1_2.A sg13cmos5l_inv_1_0.A 0.02565f
C10135 sg13cmos5l_nand2_1_0.B a_12940_10996# 0.01702f
C10136 sg13cmos5l_a21oi_1_26.Y sg13cmos5l_dfrbpq_1_38.Q 0.03041f
C10137 a_10906_18984# a_11288_19061# 0.04548f
C10138 sg13cmos5l_dfrbpq_1_28.RESET_B sg13cmos5l_dfrbpq_1_39.D 0.35366f
C10139 sg13cmos5l_nand3_1_5.Y a_7350_17532# 0.0112f
C10140 sg13cmos5l_a21oi_1_13.Y bn7 0.08437f
C10141 a_10508_10662# VDD 0.22391f
C10142 sg13cmos5l_nor2b_1_1.A sg13cmos5l_o21ai_1_5.A1 0.10559f
C10143 sg13cmos5l_nand4_1_18.B a_18200_16362# 0.01241f
C10144 sg13cmos5l_buf_8_2.A sg13cmos5l_o21ai_1_21.A2 0.02322f
C10145 sg13cmos5l_o21ai_1_14.Y sg13cmos5l_nand3_1_5.Y 0.15436f
C10146 sg13cmos5l_o21ai_1_7.Y VDD 0.48762f
C10147 a_8061_7194# VDD 0.22226f
C10148 sg13cmos5l_o21ai_1_5.A2 bn0 0.11598f
C10149 sg13cmos5l_mux2_1_1.A1 a_8337_13362# 0.08685f
C10150 sg13cmos5l_buf_1_15.A sg13cmos5l_a21oi_1_27.A1 0.17161f
C10151 a_11278_6351# a_11393_6352# 0.3854f
C10152 sg13cmos5l_nand4_1_18.B sg13cmos5l_nand3b_1_3.C 0.02021f
C10153 sg13cmos5l_inv_1_12.A sg13cmos5l_a21oi_1_7.A2 0.11192f
C10154 sg13cmos5l_a21oi_1_27.B1 sg13cmos5l_o21ai_1_22.B1 0.01652f
C10155 a_6490_16714# sg13cmos5l_o21ai_1_10.Y 0.29603f
C10156 sg13cmos5l_nand3b_1_0.C clk 0.06087f
C10157 sg13cmos5l_o21ai_1_25.B1 sg13cmos5l_buf_1_26.A 0.02288f
C10158 sg13cmos5l_nand2_1_1.A bn8 0.04596f
C10159 sg13cmos5l_a21oi_1_16.A2 sg13cmos5l_nand4_1_18.C 0.11613f
C10160 a_19179_10820# a_19919_10775# 0.17382f
C10161 sg13cmos5l_buf_1_45.X a_14763_19892# 0.28084f
C10162 a_9062_5850# VDD 0.52438f
C10163 sg13cmos5l_a21oi_1_3.A2 sg13cmos5l_inv_1_12.A 0.01386f
C10164 sg13cmos5l_buf_1_42.A a_18302_16362# 0.01729f
C10165 sg13cmos5l_nand3b_1_3.C code0 0.48572f
C10166 sg13cmos5l_inv_1_13.Y a_18634_10921# 0.03263f
C10167 a_13764_16000# a_14052_16421# 0.24435f
C10168 sg13cmos5l_nand3_1_0.Y VDD 0.61759f
C10169 sg13cmos5l_inv_1_16.Y sg13cmos5l_nand4_1_18.C 0.16776f
C10170 sg13cmos5l_buf_1_13.X a_17386_6892# 0.02206f
C10171 a_10330_9154# clk 0.01283f
C10172 a_16949_12508# VDD 0.20119f
C10173 sg13cmos5l_o21ai_1_7.B1 sg13cmos5l_nand3b_1_3.C 0.0637f
C10174 sg13cmos5l_buf_1_13.A a_16631_8065# 0.09368f
C10175 sg13cmos5l_buf_1_42.A a_19930_15960# 0.01542f
C10176 a_7068_6126# a_6958_6162# 0.25046f
C10177 sg13cmos5l_o21ai_1_1.B1 a_14561_9376# 0.02086f
C10178 sg13cmos5l_dfrbpq_1_30.D a_21215_17016# 0.0192f
C10179 a_21063_16083# a_21215_15967# 0.36168f
C10180 sg13cmos5l_a21oi_1_27.B1 a_8192_15366# 0.02112f
C10181 a_7199_6432# a_7068_6126# 0.28418f
C10182 sg13cmos5l_a21oi_1_0.Y a_19365_5423# 0.01318f
C10183 sg13cmos5l_o21ai_1_26.B1 a_13014_17532# 0.01007f
C10184 a_13727_13992# a_13575_13940# 0.3643f
C10185 sg13cmos5l_nand2_1_13.A sg13cmos5l_a21oi_1_3.A2 0.02119f
C10186 sg13cmos5l_dfrbpq_1_28.Q a_21099_12332# 0.01983f
C10187 a_19830_12278# bp0 0.01038f
C10188 sg13cmos5l_dfrbpq_1_13.CLK sg13cmos5l_nor2b_1_0.B_N 0.14497f
C10189 sg13cmos5l_dfrbpq_1_41.CLK sg13cmos5l_buf_1_24.A 0.03081f
C10190 sg13cmos5l_buf_8_2.A a_6442_10666# 0.34059f
C10191 sg13cmos5l_nor2_1_10.Y sg13cmos5l_buf_1_65.A 0.0752f
C10192 sg13cmos5l_o21ai_1_7.Y a_6418_15230# 0.01073f
C10193 a_18486_18326# VDD 0.15901f
C10194 a_12957_7194# a_13039_7294# 0.01126f
C10195 a_20294_11898# a_20997_11471# 0.02431f
C10196 a_16836_20088# a_17355_19892# 0.20773f
C10197 a_4838_9186# a_5541_9165# 0.02453f
C10198 sg13cmos5l_dfrbpq_1_28.RESET_B a_19649_16262# 0.06486f
C10199 a_10833_14874# VDD 0.49364f
C10200 a_11288_19061# a_11558_19020# 0.18796f
C10201 a_12597_11722# sg13cmos5l_inv_1_18.A 0.10795f
C10202 a_6123_12983# VDD 0.20369f
C10203 sg13cmos5l_nor2b_1_1.A sg13cmos5l_o21ai_1_5.A2 0.05236f
C10204 a_14661_19749# code0 0.03081f
C10205 sg13cmos5l_a21oi_1_0.A2 sg13cmos5l_dlygate4sd3_1_29.A 0.12998f
C10206 sg13cmos5l_dlygate4sd3_1_2.A bp7 0.02229f
C10207 sg13cmos5l_o21ai_1_25.B1 a_15690_17508# 0.01121f
C10208 sg13cmos5l_inv_1_4.Y a_20997_8447# 0.02854f
C10209 sg13cmos5l_buf_1_15.A sg13cmos5l_dfrbpq_1_24.RESET_B 0.24365f
C10210 sg13cmos5l_inv_1_4.Y a_18374_7674# 0.01303f
C10211 sg13cmos5l_inv_1_17.Y sg13cmos5l_inv_1_12.A 0.03576f
C10212 sg13cmos5l_and4_1_0.D sg13cmos5l_o21ai_1_4.A1 0.05548f
C10213 sg13cmos5l_inv_1_14.Y a_19733_6924# 0.0508f
C10214 a_9062_19770# a_9867_19892# 0.07916f
C10215 a_9348_20088# a_9765_19749# 0.28324f
C10216 sg13cmos5l_a21oi_1_8.A1 a_8480_5498# 0.01495f
C10217 sg13cmos5l_nand2b_1_1.A_N clk 0.29602f
C10218 sg13cmos5l_a21oi_1_0.A2 sg13cmos5l_buf_1_13.X 0.07793f
C10219 sg13cmos5l_nand4_1_3.B sg13cmos5l_inv_1_36.A 0.14198f
C10220 sg13cmos5l_nand4_1_15.B sg13cmos5l_mux2_1_0.S 0.03502f
C10221 sg13cmos5l_a21oi_1_11.Y a_11674_6130# 0.0103f
C10222 sg13cmos5l_inv_1_4.Y a_17621_7972# 0.0133f
C10223 sg13cmos5l_inv_1_14.Y sg13cmos5l_dlygate4sd3_1_29.A 0.08953f
C10224 sg13cmos5l_nand4_1_7.B a_17153_14750# 0.0454f
C10225 sg13cmos5l_dfrbpq_1_41.CLK sg13cmos5l_nor2_1_15.Y 0.03651f
C10226 sg13cmos5l_a21oi_1_24.A2 sg13cmos5l_buf_1_42.A 0.14781f
C10227 a_10709_6460# sg13cmos5l_a21oi_1_11.Y 0.10062f
C10228 sg13cmos5l_nor3_1_1.Y a_11674_6130# 0.01682f
C10229 a_22126_3327# a_22241_3328# 0.3854f
C10230 sg13cmos5l_a21oi_1_9.A1 a_10709_6460# 0.04497f
C10231 sg13cmos5l_a21oi_1_7.A2 a_20997_9959# 0.01316f
C10232 sg13cmos5l_buf_8_2.A sg13cmos5l_inv_1_5.A 0.06504f
C10233 a_5259_14495# VDD 0.2054f
C10234 sg13cmos5l_a21oi_1_25.Y sg13cmos5l_buf_1_26.A 0.04487f
C10235 a_19919_10775# a_20586_10996# 0.09257f
C10236 a_13764_17512# bn0 0.04733f
C10237 a_9867_5423# VDD 0.20554f
C10238 sg13cmos5l_nand4_1_1.B a_18680_12218# 0.01393f
C10239 sg13cmos5l_o21ai_1_0.A2 sg13cmos5l_nor4_1_0.C 0.07465f
C10240 sg13cmos5l_buf_1_15.A a_5604_12976# 0.07318f
C10241 sg13cmos5l_dlygate4sd3_1_42.X VDD 0.30207f
C10242 sg13cmos5l_nor3_1_2.B sg13cmos5l_nand4_1_0.C 0.26671f
C10243 a_14283_16007# a_15280_16238# 0.03546f
C10244 a_13764_16000# a_14929_16357# 0.25046f
C10245 sg13cmos5l_nand3b_1_1.Y sg13cmos5l_nand2_1_11.B 0.10288f
C10246 sg13cmos5l_nand4_1_18.B sg13cmos5l_buf_1_65.A 0.41924f
C10247 sg13cmos5l_inv_1_1.Y bn4 0.01179f
C10248 sg13cmos5l_o21ai_1_17.B1 sg13cmos5l_dfrbpq_1_41.CLK 0.02499f
C10249 sg13cmos5l_inv_1_15.A sg13cmos5l_o21ai_1_23.B1 0.01358f
C10250 a_22096_10190# VDD 0.1353f
C10251 sg13cmos5l_a21oi_1_2.B1 a_17804_4614# 0.0846f
C10252 a_8118_7742# sg13cmos5l_nand2b_1_4.B 0.13122f
C10253 sg13cmos5l_a21oi_1_9.Y sg13cmos5l_a21oi_1_10.Y 0.30779f
C10254 sg13cmos5l_inv_1_20.Y sg13cmos5l_nand2_1_13.Y 0.20749f
C10255 sg13cmos5l_inv_1_0.A a_18952_3176# 0.01717f
C10256 sg13cmos5l_mux2_1_0.A1 a_7078_14044# 0.01652f
C10257 sg13cmos5l_inv_1_32.Y a_13575_13940# 0.02771f
C10258 sg13cmos5l_buf_8_2.A sg13cmos5l_dlygate4sd3_1_15.X 0.13155f
C10259 sg13cmos5l_nand3b_1_3.C sg13cmos5l_buf_8_2.A 0.04127f
C10260 sg13cmos5l_inv_1_16.Y sg13cmos5l_a21oi_1_20.Y 0.10107f
C10261 sg13cmos5l_o21ai_1_25.Y a_14283_17519# 0.03786f
C10262 sg13cmos5l_buf_1_59.A sg13cmos5l_buf_1_57.A 0.01878f
C10263 sg13cmos5l_nand3_1_2.A a_15597_12256# 0.10602f
C10264 sg13cmos5l_a21oi_1_3.A2 sg13cmos5l_dfrbpq_1_2.D 0.03396f
C10265 sg13cmos5l_dfrbpq_1_19.CLK sg13cmos5l_o21ai_1_15.B1 0.0231f
C10266 a_7895_6553# a_7989_6320# 0.45119f
C10267 sg13cmos5l_dfrbpq_1_28.Q bp1 0.01645f
C10268 sg13cmos5l_buf_1_21.A sg13cmos5l_inv_1_36.A 0.01523f
C10269 a_21099_13844# bn7 0.03429f
C10270 a_15014_19020# bn2 0.01955f
C10271 a_20794_12936# a_20513_13238# 0.18796f
C10272 a_11393_13238# VDD 0.2092f
C10273 sg13cmos5l_dfrbpq_1_15.Q a_6928_7894# 0.05086f
C10274 sg13cmos5l_nand4_1_8.B sg13cmos5l_buf_1_53.A 0.09208f
C10275 sg13cmos5l_inv_1_1.Y VDD 1.06739f
C10276 a_13749_9386# VDD 0.17562f
C10277 a_10112_13058# VDD 0.07403f
C10278 sg13cmos5l_nor2b_1_2.Y a_15404_6888# 0.05179f
C10279 sg13cmos5l_inv_1_20.Y sg13cmos5l_nand3b_1_0.C 0.01825f
C10280 a_20580_11464# a_21099_11471# 0.20754f
C10281 a_20997_11471# a_20868_11885# 0.01562f
C10282 a_5643_9308# a_6383_9263# 0.17382f
C10283 sg13cmos5l_a21oi_1_24.A1 sg13cmos5l_dlygate4sd3_1_56.X 0.01323f
C10284 sg13cmos5l_a21oi_1_8.A2 sg13cmos5l_a21oi_1_8.A1 0.12271f
C10285 sg13cmos5l_o21ai_1_17.Y a_10954_18481# 0.01655f
C10286 sg13cmos5l_buf_1_63.A a_12632_17549# 0.07741f
C10287 a_10428_14484# VDD 0.0116f
C10288 sg13cmos5l_o21ai_1_0.B1 a_13592_6166# 0.02514f
C10289 sg13cmos5l_nor2_1_2.B sg13cmos5l_nor2_1_2.Y 0.57227f
C10290 sg13cmos5l_o21ai_1_17.B1 sg13cmos5l_or4_1_1.X 0.15207f
C10291 sg13cmos5l_a21oi_1_2.Y a_19930_4618# 0.0496f
C10292 a_5334_17532# a_5222_17508# 0.3854f
C10293 a_10771_9380# VDD 0.26419f
C10294 sg13cmos5l_nor2b_1_0.B_N a_11759_10309# 0.02342f
C10295 sg13cmos5l_a21oi_1_5.A2 sg13cmos5l_buf_1_7.X 0.05682f
C10296 sg13cmos5l_a22oi_1_0.B2 a_12808_10034# 0.02525f
C10297 sg13cmos5l_a21oi_1_1.A2 a_19179_7796# 0.04501f
C10298 code2 bn3 0.02003f
C10299 sg13cmos5l_a21oi_1_4.A1 bn5 0.09173f
C10300 sg13cmos5l_a21oi_1_16.A2 bp0 0.0254f
C10301 sg13cmos5l_a21oi_1_25.Y a_19829_18556# 0.02148f
C10302 sg13cmos5l_buf_1_0.A bp1 0.04209f
C10303 sg13cmos5l_o21ai_1_23.B1 sg13cmos5l_nand4_1_5.D 0.31741f
C10304 sg13cmos5l_a21oi_1_11.Y a_13592_6166# 0.28813f
C10305 sg13cmos5l_a22oi_1_0.B2 a_12987_10318# 0.11229f
C10306 sg13cmos5l_inv_1_24.A sg13cmos5l_mux2_1_0.A1 0.04633f
C10307 sg13cmos5l_inv_1_13.Y sg13cmos5l_a21oi_1_0.A2 0.30205f
C10308 sg13cmos5l_a21oi_1_9.A1 a_13592_6166# 0.0176f
C10309 sg13cmos5l_nand4_1_1.B a_18401_16936# 0.01918f
C10310 sg13cmos5l_buf_8_2.A sg13cmos5l_dlygate4sd3_1_29.X 0.15179f
C10311 sg13cmos5l_inv_1_16.Y bp0 0.0156f
C10312 a_14763_19892# a_14532_19783# 0.07823f
C10313 a_14244_20088# a_15409_19847# 0.25046f
C10314 sg13cmos5l_dfrbpq_1_24.Q sg13cmos5l_buf_1_22.A 0.51968f
C10315 sg13cmos5l_nand3_1_0.Y a_18374_7674# 0.01997f
C10316 sg13cmos5l_inv_1_24.A bn6 0.09554f
C10317 sg13cmos5l_buf_1_1.A a_20580_6928# 0.01546f
C10318 sg13cmos5l_nor3_1_2.B sg13cmos5l_dlygate4sd3_1_15.X 0.06604f
C10319 sg13cmos5l_inv_1_1.Y bp6 0.25339f
C10320 sg13cmos5l_and4_1_1.A VDD 1.13235f
C10321 sg13cmos5l_mux2_1_1.A1 a_10053_12189# 0.03519f
C10322 sg13cmos5l_nand2b_1_3.B sg13cmos5l_dfrbpq_1_47.Q 0.12216f
C10323 a_12512_5699# VDD 0.27868f
C10324 sg13cmos5l_buf_1_15.A a_6863_13333# 0.01386f
C10325 sg13cmos5l_nand2_1_1.Y sg13cmos5l_nand3_1_0.B 0.14311f
C10326 a_15023_16357# a_14929_16357# 0.16704f
C10327 sg13cmos5l_inv_1_12.Y a_18593_10214# 0.01301f
C10328 sg13cmos5l_inv_1_4.Y sg13cmos5l_inv_1_6.Y 0.04253f
C10329 sg13cmos5l_dfrbpq_1_24.Q sg13cmos5l_dfrbpq_1_45.Q 0.60269f
C10330 sg13cmos5l_nand3_1_3.Y sg13cmos5l_nand2b_1_3.B 0.01651f
C10331 sg13cmos5l_dfrbpq_1_41.CLK sg13cmos5l_buf_1_59.A 0.09407f
C10332 sg13cmos5l_nor3_1_2.B a_10214_10386# 0.05919f
C10333 sg13cmos5l_a21oi_1_27.B1 sg13cmos5l_mux2_1_0.S 0.06425f
C10334 sg13cmos5l_buf_1_66.X sg13cmos5l_and2_1_6.A 0.08501f
C10335 VDD code3 0.36819f
C10336 sg13cmos5l_inv_1_2.A a_19361_6352# 0.02403f
C10337 sg13cmos5l_nand4_1_7.B a_17002_15457# 0.02715f
C10338 sg13cmos5l_inv_1_32.Y sg13cmos5l_inv_1_15.A 0.01761f
C10339 sg13cmos5l_dfrbpq_1_28.RESET_B bn5 0.19569f
C10340 a_17386_6892# a_17412_6928# 0.24169f
C10341 sg13cmos5l_nand4_1_5.D sg13cmos5l_a21oi_1_19.A2 0.01351f
C10342 sg13cmos5l_inv_1_0.Y VDD 0.29188f
C10343 sg13cmos5l_dfrbpq_1_3.D sg13cmos5l_dfrbpq_1_11.D 0.03684f
C10344 sg13cmos5l_dfrbpq_1_13.CLK sg13cmos5l_dlygate4sd3_1_18.A 0.24727f
C10345 sg13cmos5l_a21oi_1_21.A1 sg13cmos5l_inv_1_32.Y 0.01753f
C10346 sg13cmos5l_or4_1_0.C sg13cmos5l_or4_1_0.D 0.10527f
C10347 sg13cmos5l_nor3_1_6.Y sg13cmos5l_a21oi_1_2.B1 0.08413f
C10348 sg13cmos5l_dfrbpq_1_37.D a_21063_18476# 0.03967f
C10349 sg13cmos5l_inv_1_1.Y a_20294_8874# 0.02414f
C10350 sg13cmos5l_inv_1_24.Y valid 0.13305f
C10351 sg13cmos5l_inv_1_7.A bp5 0.0512f
C10352 a_13102_5850# a_13343_5383# 0.01058f
C10353 sg13cmos5l_dfrbpq_1_24.RESET_B sg13cmos5l_o21ai_1_20.A1 0.03121f
C10354 sg13cmos5l_dfrbpq_1_45.D a_7416_12404# 0.01062f
C10355 a_7310_12400# a_7482_12508# 0.01068f
C10356 sg13cmos5l_inv_1_17.A bp1 2.41982f
C10357 a_22506_4948# bp5 0.06028f
C10358 sg13cmos5l_inv_1_20.Y sg13cmos5l_nand2b_1_1.A_N 0.02533f
C10359 sg13cmos5l_a21oi_1_2.B1 sg13cmos5l_inv_1_9.Y 0.10161f
C10360 a_5349_19031# a_6097_19381# 0.01058f
C10361 a_5451_19031# a_6448_19262# 0.03546f
C10362 a_21215_15967# VDD 0.24022f
C10363 sg13cmos5l_buf_1_16.A sg13cmos5l_inv_1_5.A 0.77348f
C10364 sg13cmos5l_and2_1_6.A VDD 0.49132f
C10365 sg13cmos5l_buf_1_24.A bn3 2.8552f
C10366 sg13cmos5l_dfrbpq_1_5.CLK sg13cmos5l_nand3_1_8.Y 0.02443f
C10367 a_18785_16262# VDD 0.20927f
C10368 sg13cmos5l_dlygate4sd3_1_43.X a_6881_7190# 0.0171f
C10369 sg13cmos5l_a21oi_1_18.B1 sg13cmos5l_nand3_1_8.Y 1.23506f
C10370 a_20294_12210# a_20997_12189# 0.02453f
C10371 a_21099_11471# a_21839_11821# 0.17382f
C10372 sg13cmos5l_nand4_1_8.B sg13cmos5l_nand4_1_3.D 0.13231f
C10373 a_15358_14850# sg13cmos5l_nand4_1_3.D 0.13316f
C10374 a_6383_9263# sg13cmos5l_nor3_1_2.Y 0.01295f
C10375 sg13cmos5l_dfrbpq_1_5.CLK a_19179_10820# 0.01884f
C10376 sg13cmos5l_a21oi_1_0.A2 a_19240_13058# 0.0188f
C10377 a_13768_14484# VDD 0.18012f
C10378 a_9466_18226# sg13cmos5l_o21ai_1_15.Y 0.27272f
C10379 bn2 code0 0.28721f
C10380 sg13cmos5l_nor2_1_12.Y sg13cmos5l_nand4_1_6.B 0.10854f
C10381 sg13cmos5l_o21ai_1_14.A1 a_9526_16742# 0.05546f
C10382 sg13cmos5l_a21oi_1_18.B1 sg13cmos5l_nand4_1_1.C 0.2434f
C10383 sg13cmos5l_nor2b_1_0.B_N sg13cmos5l_o21ai_1_3.A2 0.16999f
C10384 sg13cmos5l_nand4_1_7.B busy 0.02228f
C10385 sg13cmos5l_nand4_1_16.D sg13cmos5l_inv_1_16.Y 0.06865f
C10386 sg13cmos5l_buf_1_15.A sg13cmos5l_nand2_1_19.A 0.36957f
C10387 sg13cmos5l_nand2_1_0.B a_13198_9228# 0.04971f
C10388 sg13cmos5l_a21oi_1_4.A2 sg13cmos5l_nand2_1_13.Y 0.01969f
C10389 a_13974_6230# sg13cmos5l_dfrbpq_1_47.D 0.10722f
C10390 sg13cmos5l_nand3b_1_0.C sg13cmos5l_nand2_1_0.B 0.21681f
C10391 sg13cmos5l_buf_1_2.A a_20513_4166# 0.04458f
C10392 sg13cmos5l_a21oi_1_4.A1 sg13cmos5l_dfrbpq_1_18.Q 0.02188f
C10393 sg13cmos5l_a21oi_1_20.A2 sg13cmos5l_dlygate4sd3_1_81.X 0.03916f
C10394 sg13cmos5l_a21oi_1_25.Y sg13cmos5l_inv_1_15.Y 0.08312f
C10395 a_9350_12210# VDD 0.5226f
C10396 sg13cmos5l_dfrbpq_1_28.Q sg13cmos5l_a21oi_1_7.A2 0.09683f
C10397 sg13cmos5l_a21oi_1_0.A2 sg13cmos5l_buf_1_9.A 0.0223f
C10398 sg13cmos5l_nand4_1_7.B sg13cmos5l_nand4_1_3.B 0.01414f
C10399 sg13cmos5l_a21oi_1_0.A2 a_18948_10711# 0.01089f
C10400 sg13cmos5l_buf_1_43.X sg13cmos5l_a21oi_1_4.A1 0.01512f
C10401 a_9636_12528# a_9924_12223# 0.24435f
C10402 sg13cmos5l_buf_1_1.A a_21099_6935# 0.023f
C10403 sg13cmos5l_inv_1_4.Y sg13cmos5l_inv_1_11.Y 0.03937f
C10404 sg13cmos5l_a21oi_1_0.A2 a_17412_6928# 0.02366f
C10405 sg13cmos5l_nand4_1_8.B a_11180_15198# 0.01307f
C10406 VDD clk 2.68576f
C10407 sg13cmos5l_and4_1_0.D a_10896_8052# 0.15943f
C10408 sg13cmos5l_dfrbpq_1_24.RESET_B sg13cmos5l_o21ai_1_9.B1 0.02033f
C10409 sg13cmos5l_buf_8_2.A sg13cmos5l_a21oi_1_25.A2 0.02853f
C10410 sg13cmos5l_nand4_1_1.A a_16766_13730# 0.01764f
C10411 sg13cmos5l_buf_1_10.A bp5 0.08082f
C10412 sg13cmos5l_buf_1_1.A sg13cmos5l_nand3_1_8.Y 0.02139f
C10413 sg13cmos5l_or2_1_1.X sg13cmos5l_inv_1_18.Y 0.33984f
C10414 sg13cmos5l_nand3_1_0.Y a_17835_8447# 0.02305f
C10415 a_13400_15238# a_13670_15238# 0.18796f
C10416 sg13cmos5l_o21ai_1_17.B1 bn3 0.05265f
C10417 sg13cmos5l_buf_8_2.A a_14929_17869# 0.01813f
C10418 sg13cmos5l_nor4_1_2.Y sg13cmos5l_nor2_1_15.Y 1.05392f
C10419 sg13cmos5l_nand4_1_18.B sg13cmos5l_o21ai_1_14.A1 0.01459f
C10420 sg13cmos5l_dfrbpq_1_0.D a_20294_4650# 0.1637f
C10421 sg13cmos5l_dfrbpq_1_13.CLK a_9348_5416# 0.05713f
C10422 sg13cmos5l_o21ai_1_5.A2 sg13cmos5l_nand3_1_0.B 0.1654f
C10423 sg13cmos5l_a21oi_1_6.A2 sg13cmos5l_inv_1_12.A 0.0178f
C10424 a_17829_6935# a_17931_6935# 0.3643f
C10425 sg13cmos5l_o21ai_1_9.A2 a_4740_14488# 0.02427f
C10426 sg13cmos5l_dfrbpq_1_18.Q sg13cmos5l_mux2_1_1.A1 0.01091f
C10427 sg13cmos5l_a21oi_1_1.A2 a_18948_5416# 0.02059f
C10428 sg13cmos5l_buf_1_25.A sg13cmos5l_buf_1_20.A 0.02616f
C10429 a_1409_19960# VDD 0.20826f
C10430 sg13cmos5l_inv_1_15.A sg13cmos5l_inv_1_12.A 0.02062f
C10431 sg13cmos5l_o21ai_1_26.B1 sg13cmos5l_inv_1_32.Y 0.58873f
C10432 sg13cmos5l_nand2_1_15.Y a_15208_12972# 0.0311f
C10433 sg13cmos5l_nand2_1_6.A a_8061_7194# 0.02504f
C10434 sg13cmos5l_dfrbpq_1_37.D sg13cmos5l_a21oi_1_14.Y 0.09353f
C10435 sg13cmos5l_dfrbpq_1_28.RESET_B sg13cmos5l_buf_1_43.X 0.04184f
C10436 sg13cmos5l_dfrbpq_1_24.RESET_B sg13cmos5l_a21o_1_2.X 0.1208f
C10437 sg13cmos5l_a21oi_1_3.A2 sg13cmos5l_buf_1_0.A 0.01701f
C10438 sg13cmos5l_dfrbpq_1_19.CLK sg13cmos5l_o21ai_1_14.Y 0.0739f
C10439 a_13343_5383# a_14133_5459# 0.02241f
C10440 sg13cmos5l_buf_1_16.A sg13cmos5l_dlygate4sd3_1_29.X 0.15572f
C10441 sg13cmos5l_dfrbpq_1_39.D a_18470_17946# 0.16733f
C10442 sg13cmos5l_a21oi_1_9.A2 a_10607_5773# 0.01157f
C10443 sg13cmos5l_inv_1_7.Y a_19829_3900# 0.0304f
C10444 sg13cmos5l_nor2_1_10.Y sg13cmos5l_o21ai_1_10.A2 0.01863f
C10445 sg13cmos5l_o21ai_1_1.B1 sg13cmos5l_nor2b_1_0.B_N 0.43127f
C10446 bp0 bp1 0.03178f
C10447 a_11397_18237# a_11499_18380# 0.36168f
C10448 sg13cmos5l_nor3_1_6.Y a_12987_12214# 0.0141f
C10449 a_21099_12332# a_21839_12287# 0.17382f
C10450 sg13cmos5l_nor4_1_1.D a_9064_14570# 0.04265f
C10451 sg13cmos5l_inv_1_8.A a_15141_6141# 0.01069f
C10452 sg13cmos5l_buf_1_16.A a_19342_10215# 0.03365f
C10453 sg13cmos5l_a21oi_1_27.B1 sg13cmos5l_a21oi_1_12.A2 0.19448f
C10454 sg13cmos5l_nand4_1_3.B sg13cmos5l_buf_1_21.A 0.01475f
C10455 sg13cmos5l_a21oi_1_17.Y sg13cmos5l_inv_1_12.A 0.71322f
C10456 sg13cmos5l_dlygate4sd3_1_28.A bp2 0.67091f
C10457 sg13cmos5l_nor2b_1_2.Y a_12652_6924# 0.01306f
C10458 a_13015_13686# a_13596_13686# 0.01412f
C10459 sg13cmos5l_nand2_1_13.A sg13cmos5l_a21oi_1_6.A2 0.0199f
C10460 sg13cmos5l_nand2b_1_1.A_N sg13cmos5l_nand2_1_0.B 0.17173f
C10461 sg13cmos5l_a21oi_1_27.B1 code5 0.09296f
C10462 sg13cmos5l_buf_1_1.A a_21256_3176# 0.01905f
C10463 a_12420_19024# a_12837_19031# 0.28418f
C10464 a_12134_19458# a_12708_19445# 0.18486f
C10465 sg13cmos5l_inv_1_17.Y sg13cmos5l_dfrbpq_1_28.Q 0.01353f
C10466 sg13cmos5l_o21ai_1_13.B1 sg13cmos5l_o21ai_1_18.B1 0.04988f
C10467 sg13cmos5l_nor2b_1_2.Y a_12430_6980# 0.15152f
C10468 sg13cmos5l_inv_1_1.A sg13cmos5l_nand3_1_8.Y 0.24502f
C10469 sg13cmos5l_dlygate4sd3_1_15.X a_14446_9375# 0.10665f
C10470 sg13cmos5l_buf_1_53.A sg13cmos5l_and2_1_3.X 0.01642f
C10471 sg13cmos5l_inv_1_17.A sg13cmos5l_a21oi_1_7.A2 0.02461f
C10472 sg13cmos5l_o21ai_1_5.A1 a_10155_12332# 0.05661f
C10473 sg13cmos5l_buf_8_2.A bn2 0.21056f
C10474 sg13cmos5l_dfrbpq_1_13.CLK sg13cmos5l_buf_1_10.A 0.076f
C10475 a_10304_10830# VDD 0.08483f
C10476 sg13cmos5l_inv_1_1.A sg13cmos5l_nand4_1_1.C 0.04234f
C10477 sg13cmos5l_o21ai_1_5.A2 a_11656_15272# 0.01569f
C10478 sg13cmos5l_buf_1_26.A sg13cmos5l_dfrbpq_1_39.D 0.36166f
C10479 a_9096_15996# a_9292_15996# 0.03099f
C10480 sg13cmos5l_a21oi_1_4.A2 sg13cmos5l_nand2b_1_1.A_N 0.18169f
C10481 sg13cmos5l_a21oi_1_18.B1 sg13cmos5l_dlygate4sd3_1_81.X 0.36535f
C10482 sg13cmos5l_o21ai_1_0.A1 a_12957_7194# 0.14391f
C10483 sg13cmos5l_nand4_1_6.B sg13cmos5l_a21oi_1_4.A2 0.01653f
C10484 sg13cmos5l_a21oi_1_0.A2 a_18671_7285# 0.04583f
C10485 sg13cmos5l_inv_1_4.Y sg13cmos5l_buf_1_4.A 0.06322f
C10486 a_21358_5679# bp2 0.05813f
C10487 sg13cmos5l_a21oi_1_1.A2 sg13cmos5l_inv_1_12.A 0.09314f
C10488 sg13cmos5l_a21oi_1_4.A1 sg13cmos5l_a21o_1_2.A1 0.32752f
C10489 sg13cmos5l_dlygate4sd3_1_65.A a_9824_19106# 0.01341f
C10490 sg13cmos5l_nand4_1_18.B sg13cmos5l_o21ai_1_10.A2 0.02019f
C10491 a_10696_15272# VDD 0.21467f
C10492 sg13cmos5l_inv_1_4.Y sg13cmos5l_inv_1_3.Y 0.01787f
C10493 sg13cmos5l_o21ai_1_9.A2 sg13cmos5l_dlygate4sd3_1_45.X 0.02113f
C10494 sg13cmos5l_nand3_1_0.Y sg13cmos5l_inv_1_11.Y 0.11683f
C10495 sg13cmos5l_dfrbpq_1_20.Q a_5349_19031# 0.04816f
C10496 comp code9 0.15349f
C10497 sg13cmos5l_inv_1_17.Y sg13cmos5l_buf_1_0.A 0.09259f
C10498 a_7907_15532# VDD 0.0137f
C10499 sg13cmos5l_o21ai_1_6.Y a_9500_8416# 0.01087f
C10500 sg13cmos5l_a21oi_1_18.B1 a_16556_15960# 0.0244f
C10501 sg13cmos5l_a21oi_1_6.A2 a_19530_11460# 0.01166f
C10502 a_21370_19738# sg13cmos5l_dfrbpq_1_39.Q 0.30692f
C10503 a_4298_15532# sg13cmos5l_nor2_1_6.Y 0.0146f
C10504 sg13cmos5l_dfrbpq_1_13.CLK a_11274_5412# 0.02679f
C10505 sg13cmos5l_inv_1_1.Y sg13cmos5l_a21oi_1_2.Y 0.02416f
C10506 a_18928_7166# a_18671_7285# 0.23043f
C10507 sg13cmos5l_o21ai_1_5.A1 sg13cmos5l_nor4_1_1.D 0.06604f
C10508 sg13cmos5l_a21oi_1_1.A2 a_20207_5773# 0.01143f
C10509 a_20488_3176# bp7 0.06357f
C10510 sg13cmos5l_o21ai_1_22.B1 sg13cmos5l_inv_1_25.Y 0.02938f
C10511 sg13cmos5l_dlygate4sd3_1_29.A a_19246_6351# 0.02012f
C10512 sg13cmos5l_o21ai_1_23.A2 a_13670_15238# 0.01146f
C10513 sg13cmos5l_buf_8_2.A sg13cmos5l_buf_1_14.A 0.03798f
C10514 sg13cmos5l_nand4_1_0.C a_7362_8802# 0.01046f
C10515 sg13cmos5l_o21ai_1_5.A2 a_7378_16374# 0.06722f
C10516 sg13cmos5l_dfrbpq_1_5.CLK a_20997_12189# 0.226f
C10517 sg13cmos5l_o21ai_1_7.B1 sg13cmos5l_o21ai_1_10.A2 0.02508f
C10518 sg13cmos5l_nand3_1_0.B a_16454_8436# 0.03224f
C10519 a_15784_15272# bn5 0.02402f
C10520 sg13cmos5l_nor4_1_2.Y sg13cmos5l_buf_1_59.A 0.36568f
C10521 a_19745_15424# a_20026_15202# 0.18796f
C10522 sg13cmos5l_a21oi_1_2.A2 sg13cmos5l_dfrbpq_1_2.D 0.01005f
C10523 sg13cmos5l_dfrbpq_1_18.Q sg13cmos5l_nor3_1_4.A 0.35537f
C10524 sg13cmos5l_inv_1_15.A a_22005_18416# 0.01986f
C10525 sg13cmos5l_a21oi_1_3.A2 sg13cmos5l_dlygate4sd3_1_25.A 0.02168f
C10526 sg13cmos5l_buf_1_15.A bn5 0.10872f
C10527 sg13cmos5l_nor2_1_12.Y bn4 0.0163f
C10528 sg13cmos5l_dfrbpq_1_13.CLK sg13cmos5l_nand3_1_0.B 0.0268f
C10529 sg13cmos5l_buf_1_10.A sg13cmos5l_dlygate4sd3_1_24.A 0.11383f
C10530 sg13cmos5l_nand3b_1_1.C sg13cmos5l_nor2b_1_1.A 1.24504f
C10531 a_10980_18576# a_11268_18271# 0.24435f
C10532 sg13cmos5l_buf_1_5.A a_18660_11016# 0.02128f
C10533 sg13cmos5l_dfrbpq_1_15.CLK a_6123_12983# 0.05393f
C10534 sg13cmos5l_buf_1_16.A sg13cmos5l_a21oi_1_25.A2 0.25231f
C10535 sg13cmos5l_o21ai_1_21.A2 sg13cmos5l_o21ai_1_22.B1 0.01631f
C10536 sg13cmos5l_buf_1_5.A a_17240_10702# 0.01598f
C10537 a_18095_19847# a_18762_20068# 0.09257f
C10538 sg13cmos5l_nand4_1_6.B sg13cmos5l_buf_1_57.A 0.36417f
C10539 sg13cmos5l_inv_1_1.A sg13cmos5l_dlygate4sd3_1_3.A 0.06613f
C10540 sg13cmos5l_dfrbpq_1_29.Q bn8 0.01487f
C10541 sg13cmos5l_inv_1_20.Y VDD 0.38159f
C10542 sg13cmos5l_buf_1_13.A sg13cmos5l_o21ai_1_0.B1 0.02096f
C10543 sg13cmos5l_inv_1_1.Y sg13cmos5l_inv_1_6.Y 0.01375f
C10544 sg13cmos5l_dfrbpq_1_19.CLK a_4607_18528# 0.21325f
C10545 a_21254_10702# bn9 0.01008f
C10546 sg13cmos5l_inv_1_36.A a_7736_13726# 0.01237f
C10547 sg13cmos5l_inv_1_17.A sg13cmos5l_inv_1_17.Y 0.18086f
C10548 sg13cmos5l_dfrbpq_1_7.D bp2 0.14656f
C10549 sg13cmos5l_nand4_1_17.Y sg13cmos5l_buf_1_57.A 0.08079f
C10550 a_11274_20068# VDD 0.27593f
C10551 sg13cmos5l_nor3_1_6.Y sg13cmos5l_mux2_1_0.S 0.53257f
C10552 sg13cmos5l_buf_1_57.A a_13384_14484# 0.19413f
C10553 a_5157_14495# a_5905_14845# 0.01058f
C10554 sg13cmos5l_dfrbpq_1_15.CLK a_5259_14495# 0.02953f
C10555 sg13cmos5l_dlygate4sd3_1_33.X sg13cmos5l_dlygate4sd3_1_42.X 0.01801f
C10556 sg13cmos5l_nand3b_1_3.C sg13cmos5l_buf_1_53.A 0.01204f
C10557 sg13cmos5l_dfrbpq_1_27.Q a_22506_14020# 0.1112f
C10558 sg13cmos5l_buf_1_8.A bp7 0.06369f
C10559 a_19534_16263# sg13cmos5l_buf_1_53.A 0.10798f
C10560 sg13cmos5l_nor2_1_12.Y VDD 0.35859f
C10561 a_16742_15234# a_17028_15552# 0.26205f
C10562 sg13cmos5l_a21oi_1_2.B1 a_17872_5654# 0.03493f
C10563 sg13cmos5l_nor2_1_2.B sg13cmos5l_a21oi_1_8.A1 0.09318f
C10564 sg13cmos5l_dfrbpq_1_15.CLK sg13cmos5l_dlygate4sd3_1_42.X 0.12146f
C10565 sg13cmos5l_buf_1_13.A sg13cmos5l_a21oi_1_9.A1 0.0103f
C10566 a_10864_19990# a_11274_20068# 0.07015f
C10567 sg13cmos5l_and2_1_3.X sg13cmos5l_nand4_1_3.D 0.06758f
C10568 sg13cmos5l_a21oi_1_7.A2 bp0 0.04054f
C10569 sg13cmos5l_nand4_1_15.B sg13cmos5l_nand2_1_18.A 0.02523f
C10570 sg13cmos5l_a21o_1_2.X a_5999_14845# 0.02437f
C10571 sg13cmos5l_o21ai_1_4.A1 sg13cmos5l_o21ai_1_4.Y 1.17795f
C10572 a_20580_9952# bp2 0.02995f
C10573 sg13cmos5l_nand2b_1_0.B sg13cmos5l_nor4_1_0.Y 1.11747f
C10574 a_16356_5416# VDD 0.07219f
C10575 sg13cmos5l_buf_1_63.A sg13cmos5l_inv_1_24.Y 0.16171f
C10576 sg13cmos5l_buf_1_45.X a_13478_16434# 0.09715f
C10577 sg13cmos5l_a21oi_1_18.B1 sg13cmos5l_nand4_1_1.B 0.15064f
C10578 sg13cmos5l_a21oi_1_1.A2 a_19530_11460# 0.05626f
C10579 sg13cmos5l_nand2b_1_1.A_N sg13cmos5l_a21o_1_1.A2 0.20577f
C10580 sg13cmos5l_nand4_1_8.B sg13cmos5l_mux2_1_0.S 0.10774f
C10581 sg13cmos5l_inv_1_8.Y VDD 0.26324f
C10582 sg13cmos5l_buf_1_7.X a_20294_4650# 0.07699f
C10583 sg13cmos5l_a21oi_1_3.A2 bp0 0.02161f
C10584 sg13cmos5l_nand3b_1_0.C sg13cmos5l_inv_1_18.Y 0.01684f
C10585 sg13cmos5l_buf_1_7.X sg13cmos5l_dlygate4sd3_1_22.A 0.0177f
C10586 sg13cmos5l_buf_1_47.X sg13cmos5l_o21ai_1_17.Y 0.01783f
C10587 sg13cmos5l_inv_1_2.A sg13cmos5l_inv_1_4.Y 0.0167f
C10588 sg13cmos5l_buf_1_10.A a_11759_10309# 0.04083f
C10589 sg13cmos5l_nand3_1_8.Y a_16476_13338# 0.01753f
C10590 sg13cmos5l_inv_1_2.A a_19930_4618# 0.04962f
C10591 sg13cmos5l_inv_1_13.Y sg13cmos5l_dfrbpq_1_28.D 0.0923f
C10592 sg13cmos5l_dlygate4sd3_1_76.A sg13cmos5l_inv_1_12.A 0.06986f
C10593 sg13cmos5l_dfrbpq_1_24.RESET_B a_3996_16710# 0.3235f
C10594 sg13cmos5l_o21ai_1_5.A2 sg13cmos5l_nor4_1_1.D 0.01748f
C10595 sg13cmos5l_dfrbpq_1_13.RESET_B sg13cmos5l_a21oi_1_10.A1 0.01932f
C10596 sg13cmos5l_dfrbpq_1_13.CLK a_13212_5773# 0.04881f
C10597 a_16330_5380# a_16356_5416# 0.24169f
C10598 sg13cmos5l_inv_1_2.A a_18952_4688# 0.02945f
C10599 sg13cmos5l_nand3_1_0.Y sg13cmos5l_inv_1_3.Y 0.01454f
C10600 sg13cmos5l_buf_1_65.A sg13cmos5l_dfrbpq_1_45.Q 0.08852f
C10601 a_19338_6924# sg13cmos5l_dfrbpq_1_9.Q 0.07591f
C10602 sg13cmos5l_nand3_1_0.B a_16673_11726# 0.03087f
C10603 a_6760_15366# VDD 0.14123f
C10604 sg13cmos5l_a21oi_1_27.B1 sg13cmos5l_o21ai_1_19.Y 0.05087f
C10605 sg13cmos5l_a21oi_1_2.B1 a_20580_8440# 0.02773f
C10606 sg13cmos5l_dfrbpq_1_41.CLK sg13cmos5l_nand4_1_6.B 0.02267f
C10607 sg13cmos5l_buf_1_15.A sg13cmos5l_dfrbpq_1_18.Q 0.04f
C10608 sg13cmos5l_nand3_1_8.Y sg13cmos5l_nand4_1_18.D 1.03345f
C10609 a_7238_19458# a_8043_19031# 0.07916f
C10610 a_22522_6130# VDD 0.26092f
C10611 sg13cmos5l_nand2_1_12.Y bn4 0.07326f
C10612 sg13cmos5l_inv_1_16.A sg13cmos5l_dfrbpq_1_13.CLK 0.01891f
C10613 sg13cmos5l_nand4_1_6.B sg13cmos5l_nand4_1_1.A 0.12001f
C10614 a_19450_18226# a_19173_17519# 0.01139f
C10615 sg13cmos5l_buf_8_2.A sg13cmos5l_o21ai_1_10.A2 0.02408f
C10616 a_12239_18335# a_12145_18335# 0.16704f
C10617 sg13cmos5l_dfrbpq_1_45.D a_6280_11546# 0.04077f
C10618 sg13cmos5l_buf_1_5.A sg13cmos5l_buf_1_8.A 0.01348f
C10619 sg13cmos5l_dfrbpq_1_41.CLK sg13cmos5l_nand4_1_17.Y 0.01564f
C10620 sg13cmos5l_buf_1_15.A sg13cmos5l_buf_1_43.X 0.06085f
C10621 sg13cmos5l_a21oi_1_4.A1 sg13cmos5l_nand2b_1_0.B 0.28974f
C10622 sg13cmos5l_nand4_1_18.D sg13cmos5l_nand4_1_1.C 1.60016f
C10623 sg13cmos5l_buf_1_54.A a_14536_14484# 0.01662f
C10624 sg13cmos5l_nand4_1_12.Y sg13cmos5l_a21oi_1_24.A1 0.05952f
C10625 sg13cmos5l_a21oi_1_2.B1 sg13cmos5l_inv_1_5.A 0.06667f
C10626 sg13cmos5l_nand4_1_12.Y code1 0.05695f
C10627 sg13cmos5l_buf_1_24.A sg13cmos5l_dlygate4sd3_1_55.X 0.01159f
C10628 sg13cmos5l_a21oi_1_6.Y bp3 0.05204f
C10629 sg13cmos5l_and4_1_1.A a_7064_14525# 0.31992f
C10630 sg13cmos5l_inv_1_36.A a_8118_13790# 0.01041f
C10631 a_13679_19381# a_14346_19020# 0.09257f
C10632 sg13cmos5l_dlygate4sd3_1_71.X bn8 0.17007f
C10633 a_14646_10766# sg13cmos5l_a21oi_1_4.B1 0.10673f
C10634 sg13cmos5l_inv_1_1.Y sg13cmos5l_dlygate4sd3_1_98.A 0.33254f
C10635 sg13cmos5l_nand4_1_17.Y sg13cmos5l_dlygate4sd3_1_72.A 0.13224f
C10636 sg13cmos5l_nand2_1_18.A sg13cmos5l_nand2_1_0.A 0.08918f
C10637 sg13cmos5l_o21ai_1_5.A2 a_11562_12508# 0.01202f
C10638 sg13cmos5l_inv_1_17.Y bp0 0.0319f
C10639 sg13cmos5l_nand4_1_18.B sg13cmos5l_nand3_1_8.Y 0.0973f
C10640 sg13cmos5l_nand2_1_12.Y VDD 0.53255f
C10641 sg13cmos5l_o21ai_1_20.B1 sg13cmos5l_dfrbpq_1_23.Q 0.01951f
C10642 sg13cmos5l_nand2_1_0.B VDD 1.34199f
C10643 a_22522_6130# bp6 0.01021f
C10644 a_14698_6385# a_14724_6480# 0.24169f
C10645 sg13cmos5l_nand2b_1_1.A_N sg13cmos5l_inv_1_18.Y 0.01082f
C10646 a_18282_5412# VDD 0.27916f
C10647 sg13cmos5l_o21ai_1_11.B1 a_6286_16263# 0.0505f
C10648 sg13cmos5l_inv_1_5.A sg13cmos5l_inv_1_5.Y 0.06411f
C10649 sg13cmos5l_nand4_1_18.B sg13cmos5l_nand4_1_1.C 0.04329f
C10650 a_12597_11722# a_13208_11501# 0.031f
C10651 sg13cmos5l_a21oi_1_4.A1 a_7334_14484# 0.02486f
C10652 a_9348_20088# a_9636_19783# 0.24435f
C10653 a_18470_19458# a_19173_19031# 0.02431f
C10654 a_20503_15960# a_21084_16357# 0.01412f
C10655 sg13cmos5l_dlygate4sd3_1_82.X bn3 0.01935f
C10656 sg13cmos5l_inv_1_31.A a_19173_17519# 0.23206f
C10657 a_18470_17946# bn5 0.01665f
C10658 sg13cmos5l_dfrbpq_1_13.CLK a_10155_12332# 0.01615f
C10659 sg13cmos5l_buf_1_7.X a_22096_4870# 0.09969f
C10660 sg13cmos5l_nor2_1_12.Y a_12118_17886# 0.04796f
C10661 sg13cmos5l_inv_1_18.A sg13cmos5l_a22oi_1_0.B2 0.55101f
C10662 sg13cmos5l_buf_1_4.A a_21745_4727# 0.01323f
C10663 sg13cmos5l_buf_1_10.A sg13cmos5l_o21ai_1_3.A2 0.02494f
C10664 sg13cmos5l_buf_1_54.A bn5 0.06061f
C10665 sg13cmos5l_buf_1_47.X sg13cmos5l_nand4_1_7.B 0.0178f
C10666 sg13cmos5l_a21oi_1_6.Y a_22506_9948# 0.05414f
C10667 sg13cmos5l_nand4_1_3.B sg13cmos5l_a21oi_1_5.A2 0.04732f
C10668 sg13cmos5l_dlygate4sd3_1_69.A sg13cmos5l_nor2_1_12.Y 0.03403f
C10669 a_18021_11471# a_18769_11821# 0.01058f
C10670 sg13cmos5l_buf_1_15.A a_20503_15960# 0.11905f
C10671 sg13cmos5l_nand4_1_1.B sg13cmos5l_inv_1_1.A 0.02322f
C10672 a_6272_10830# VDD 0.10445f
C10673 sg13cmos5l_a21oi_1_4.A2 VDD 1.02373f
C10674 sg13cmos5l_nor2_1_10.Y sg13cmos5l_o21ai_1_15.B1 0.17097f
C10675 a_16356_5416# a_17615_5773# 0.01412f
C10676 sg13cmos5l_nor3_1_6.Y a_4740_14488# 0.01644f
C10677 a_22241_6352# a_22522_6130# 0.18796f
C10678 sg13cmos5l_nand4_1_18.C sg13cmos5l_a21oi_1_2.A2 0.07149f
C10679 sg13cmos5l_a21oi_1_16.A2 a_17224_12972# 0.049f
C10680 sg13cmos5l_a21oi_1_10.A1 sg13cmos5l_dfrbpq_1_13.D 0.01914f
C10681 sg13cmos5l_a21oi_1_2.A2 a_18374_10698# 0.01379f
C10682 sg13cmos5l_buf_1_65.A a_9636_12528# 0.01389f
C10683 sg13cmos5l_inv_1_32.Y sg13cmos5l_a21oi_1_4.A1 0.0218f
C10684 sg13cmos5l_dlygate4sd3_1_54.A sg13cmos5l_o21ai_1_17.Y 0.08308f
C10685 sg13cmos5l_a21oi_1_2.B1 a_21839_8797# 0.01414f
C10686 a_16078_19287# sg13cmos5l_a21oi_1_18.B1 0.03715f
C10687 sg13cmos5l_nand3_1_0.B a_16631_8065# 0.04777f
C10688 sg13cmos5l_o21ai_1_1.B1 a_15226_12214# 0.01851f
C10689 a_7524_19024# a_8689_19381# 0.25046f
C10690 sg13cmos5l_o21ai_1_5.A2 sg13cmos5l_nand2_1_1.Y 0.0457f
C10691 sg13cmos5l_a21oi_1_2.A2 sg13cmos5l_buf_1_0.A 0.02352f
C10692 a_7812_19445# a_8043_19031# 0.07823f
C10693 sg13cmos5l_dfrbpq_1_24.Q sg13cmos5l_mux2_1_0.S 0.33603f
C10694 sg13cmos5l_inv_1_15.A sg13cmos5l_nand4_1_18.C 0.01743f
C10695 sg13cmos5l_a21oi_1_9.B1 sg13cmos5l_a21oi_1_10.Y 0.01554f
C10696 sg13cmos5l_a21oi_1_26.Y a_16942_19287# 0.01679f
C10697 a_19829_8436# VDD 0.16785f
C10698 sg13cmos5l_dfrbpq_1_28.RESET_B a_22096_14726# 0.09637f
C10699 sg13cmos5l_dfrbpq_1_13.RESET_B a_8061_7194# 0.01709f
C10700 a_18660_7992# VDD 0.0726f
C10701 sg13cmos5l_a21oi_1_2.B1 sg13cmos5l_dlygate4sd3_1_29.X 0.1278f
C10702 sg13cmos5l_buf_1_66.X sg13cmos5l_buf_1_57.A 0.2592f
C10703 a_6470_11898# a_6730_11428# 0.45119f
C10704 sg13cmos5l_nand2_1_6.A clk 0.10586f
C10705 sg13cmos5l_inv_1_1.Y sg13cmos5l_buf_1_4.A 0.02228f
C10706 a_17710_17775# VDD 0.15905f
C10707 sg13cmos5l_inv_1_15.A sg13cmos5l_buf_1_0.A 0.04418f
C10708 sg13cmos5l_o21ai_1_5.A1 sg13cmos5l_o21ai_1_5.A2 0.17655f
C10709 sg13cmos5l_o21ai_1_7.B1 sg13cmos5l_o21ai_1_10.Y 0.14498f
C10710 sg13cmos5l_inv_1_9.Y sg13cmos5l_nand3_1_0.C 0.01121f
C10711 sg13cmos5l_inv_1_36.A sg13cmos5l_a21oi_1_27.A1 0.03374f
C10712 a_17290_8404# VDD 0.09586f
C10713 sg13cmos5l_buf_1_24.A a_9070_18447# 0.0277f
C10714 sg13cmos5l_nand4_1_18.D a_15968_14570# 0.01537f
C10715 sg13cmos5l_a21oi_1_24.A1 a_14218_18226# 0.03078f
C10716 sg13cmos5l_o21ai_1_1.B1 a_12224_9318# 0.02583f
C10717 sg13cmos5l_nand4_1_1.B sg13cmos5l_dlygate4sd3_1_77.A 0.01101f
C10718 sg13cmos5l_o21ai_1_25.B1 busy 0.03179f
C10719 sg13cmos5l_inv_1_7.A a_20794_3864# 0.01158f
C10720 sg13cmos5l_dfrbpq_1_13.RESET_B a_9062_5850# 0.08217f
C10721 a_15488_9361# a_15607_9150# 0.09257f
C10722 sg13cmos5l_a21oi_1_17.Y sg13cmos5l_nand4_1_18.C 0.11857f
C10723 a_13566_8412# VDD 0.2037f
C10724 a_20294_4650# bp4 0.01928f
C10725 sg13cmos5l_buf_1_57.A VDD 0.82557f
C10726 sg13cmos5l_buf_1_13.A a_14698_6385# 0.17997f
C10727 a_13478_17946# VDD 0.52332f
C10728 sg13cmos5l_inv_1_31.A bn7 0.07175f
C10729 a_17028_15552# a_17316_15247# 0.24435f
C10730 sg13cmos5l_buf_1_20.A valid 0.02098f
C10731 sg13cmos5l_nor4_1_0.Y a_14230_7670# 0.04796f
C10732 sg13cmos5l_o21ai_1_1.B1 sg13cmos5l_buf_1_10.A 0.26145f
C10733 sg13cmos5l_dlygate4sd3_1_50.X a_3628_16746# 0.02839f
C10734 a_14724_6480# a_15983_6239# 0.01412f
C10735 sg13cmos5l_inv_1_5.A a_16773_5423# 0.19609f
C10736 sg13cmos5l_dfrbpq_1_13.CLK sg13cmos5l_inv_1_36.Y 0.61941f
C10737 a_18756_19024# a_19275_19031# 0.20754f
C10738 a_19173_19031# a_19044_19445# 0.01562f
C10739 a_12632_17549# a_12902_17508# 0.18796f
C10740 sg13cmos5l_nand2_1_1.A VDD 0.87926f
C10741 sg13cmos5l_o21ai_1_7.B1 sg13cmos5l_dfrbpq_1_23.D 0.07643f
C10742 a_12632_8477# sg13cmos5l_a22oi_1_2.Y 0.01007f
C10743 sg13cmos5l_inv_1_16.A bn6 0.01351f
C10744 sg13cmos5l_nand4_1_8.B sg13cmos5l_inv_1_24.Y 0.01779f
C10745 sg13cmos5l_dfrbpq_1_39.Q sg13cmos5l_dfrbpq_1_35.Q 0.12012f
C10746 sg13cmos5l_nor3_1_6.Y sg13cmos5l_dlygate4sd3_1_45.X 0.0219f
C10747 sg13cmos5l_buf_1_13.X bp2 0.01642f
C10748 sg13cmos5l_nor2_1_10.Y sg13cmos5l_o21ai_1_15.Y 0.03969f
C10749 sg13cmos5l_dlygate4sd3_1_69.A sg13cmos5l_nand2_1_12.Y 0.08023f
C10750 a_10474_9916# VDD 0.09703f
C10751 a_18863_11821# a_18769_11821# 0.16704f
C10752 sg13cmos5l_dlygate4sd3_1_58.X sg13cmos5l_dfrbpq_1_24.RESET_B 0.04179f
C10753 sg13cmos5l_nand2b_1_1.A_N sg13cmos5l_nand3_1_4.Y 0.03853f
C10754 sg13cmos5l_inv_1_17.A sg13cmos5l_a21oi_1_6.A2 0.07381f
C10755 sg13cmos5l_dfrbpq_1_47.Q a_12224_6294# 0.0383f
C10756 sg13cmos5l_a21o_1_1.A2 VDD 0.53882f
C10757 sg13cmos5l_dfrbpq_1_20.Q a_3584_18390# 0.01525f
C10758 sg13cmos5l_nand4_1_18.C sg13cmos5l_a21oi_1_1.A2 0.04813f
C10759 sg13cmos5l_buf_1_1.A a_22241_9376# 0.05008f
C10760 sg13cmos5l_buf_1_54.A sg13cmos5l_buf_1_43.X 0.3119f
C10761 sg13cmos5l_inv_1_12.A a_20580_11464# 0.03643f
C10762 sg13cmos5l_nand3_1_8.Y sg13cmos5l_a21oi_1_13.A2 0.01396f
C10763 a_17615_5773# a_18282_5412# 0.09257f
C10764 sg13cmos5l_dfrbpq_1_41.CLK bn4 0.03035f
C10765 sg13cmos5l_inv_1_15.A sg13cmos5l_inv_1_17.A 0.90959f
C10766 sg13cmos5l_buf_8_2.A sg13cmos5l_nand3_1_8.Y 0.01829f
C10767 sg13cmos5l_buf_1_45.X a_12394_18988# 0.18861f
C10768 sg13cmos5l_dfrbpq_1_24.RESET_B a_4778_16904# 0.0105f
C10769 sg13cmos5l_buf_1_45.X code1 0.24719f
C10770 sg13cmos5l_buf_1_42.A sg13cmos5l_a21oi_1_16.A2 0.01927f
C10771 sg13cmos5l_buf_1_45.X sg13cmos5l_a21oi_1_24.A1 1.52069f
C10772 sg13cmos5l_nand4_1_1.C sg13cmos5l_a21oi_1_13.A2 0.06613f
C10773 sg13cmos5l_a21oi_1_0.A2 sg13cmos5l_dfrbpq_1_1.D 0.08287f
C10774 sg13cmos5l_buf_1_65.A sg13cmos5l_o21ai_1_22.B1 0.13864f
C10775 sg13cmos5l_buf_8_2.A sg13cmos5l_nand4_1_1.C 0.02414f
C10776 sg13cmos5l_a21oi_1_1.A2 sg13cmos5l_buf_1_0.A 0.03927f
C10777 sg13cmos5l_buf_1_4.A sg13cmos5l_inv_1_0.Y 0.02393f
C10778 a_5032_9948# VDD 0.22913f
C10779 sg13cmos5l_dfrbpq_1_35.D a_18470_19458# 0.17763f
C10780 sg13cmos5l_buf_1_42.A sg13cmos5l_inv_1_16.Y 0.09305f
C10781 sg13cmos5l_dlygate4sd3_1_72.A bn4 0.06539f
C10782 sg13cmos5l_dlygate4sd3_1_43.X VDD 0.35534f
C10783 sg13cmos5l_nand4_1_15.B sg13cmos5l_buf_1_20.A 0.03211f
C10784 sg13cmos5l_a21oi_1_10.A2 a_9077_6460# 0.07577f
C10785 sg13cmos5l_inv_1_3.Y sg13cmos5l_inv_1_0.Y 0.04495f
C10786 a_8783_19381# a_8689_19381# 0.16704f
C10787 sg13cmos5l_a21oi_1_4.A1 sg13cmos5l_inv_1_12.A 0.07297f
C10788 sg13cmos5l_nand4_1_1.C a_15986_13730# 0.01014f
C10789 sg13cmos5l_a21oi_1_13.Y sg13cmos5l_inv_1_31.Y 0.03303f
C10790 a_4714_14452# VDD 0.09464f
C10791 sg13cmos5l_inv_1_14.Y sg13cmos5l_dfrbpq_1_1.D 0.32292f
C10792 sg13cmos5l_dfrbpq_1_9.Q a_19361_6352# 0.04697f
C10793 sg13cmos5l_a21oi_1_2.A2 sg13cmos5l_dlygate4sd3_1_25.A 0.61396f
C10794 a_19919_7751# VDD 0.17303f
C10795 sg13cmos5l_o21ai_1_7.Y sg13cmos5l_o21ai_1_11.B1 0.02158f
C10796 a_3776_18433# a_4108_18258# 0.07015f
C10797 sg13cmos5l_o21ai_1_25.B1 sg13cmos5l_dfrbpq_1_33.D 0.35948f
C10798 a_18756_17512# VDD 0.07273f
C10799 sg13cmos5l_dfrbpq_1_24.RESET_B sg13cmos5l_dfrbpq_1_23.Q 0.03089f
C10800 sg13cmos5l_nor2_1_10.Y sg13cmos5l_nand4_1_1.B 0.17603f
C10801 sg13cmos5l_dfrbpq_1_41.CLK VDD 1.8436f
C10802 sg13cmos5l_buf_1_24.A a_11397_18237# 0.01381f
C10803 sg13cmos5l_nor2_1_2.B a_10365_7194# 0.09088f
C10804 sg13cmos5l_dfrbpq_1_24.RESET_B sg13cmos5l_inv_1_36.A 0.03056f
C10805 sg13cmos5l_inv_1_15.A sg13cmos5l_a21oi_1_20.Y 0.01456f
C10806 a_10607_19847# code5 0.01686f
C10807 sg13cmos5l_nand4_1_1.A VDD 0.79932f
C10808 sg13cmos5l_dfrbpq_1_13.CLK sg13cmos5l_nand2_1_1.Y 0.02618f
C10809 sg13cmos5l_dfrbpq_1_28.RESET_B a_20015_17869# 0.11735f
C10810 sg13cmos5l_nand4_1_6.B sg13cmos5l_nor4_1_2.Y 0.88737f
C10811 a_6442_10666# sg13cmos5l_dfrbpq_1_14.D 0.11597f
C10812 sg13cmos5l_inv_1_1.Y sg13cmos5l_inv_1_2.A 0.05554f
C10813 sg13cmos5l_a21oi_1_24.A1 a_16299_18380# 0.01422f
C10814 a_18832_8678# VDD 0.13577f
C10815 a_8206_9375# a_8321_9376# 0.3854f
C10816 sg13cmos5l_o21ai_1_7.A2 a_7090_15230# 0.04791f
C10817 sg13cmos5l_inv_1_17.A a_21745_13799# 0.01765f
C10818 sg13cmos5l_dfrbpq_1_19.CLK sg13cmos5l_inv_1_29.Y 0.07366f
C10819 sg13cmos5l_inv_1_7.A a_22126_4167# 0.10964f
C10820 sg13cmos5l_dfrbpq_1_13.RESET_B a_9867_5423# 0.27969f
C10821 sg13cmos5l_dfrbpq_1_13.RESET_B sg13cmos5l_dlygate4sd3_1_42.X 0.15472f
C10822 sg13cmos5l_dfrbpq_1_11.Q VDD 0.32812f
C10823 sg13cmos5l_dlygate4sd3_1_72.A VDD 0.36676f
C10824 sg13cmos5l_nand4_1_15.B sg13cmos5l_inv_1_13.Y 0.01639f
C10825 sg13cmos5l_nand4_1_17.Y sg13cmos5l_nor4_1_2.Y 0.04893f
C10826 sg13cmos5l_buf_1_13.A a_15983_6239# 0.11853f
C10827 sg13cmos5l_dlygate4sd3_1_64.X sg13cmos5l_o21ai_1_7.A2 0.01949f
C10828 sg13cmos5l_nand4_1_1.B sg13cmos5l_nand4_1_18.D 0.03692f
C10829 sg13cmos5l_dfrbpq_1_13.D a_9062_5850# 0.17282f
C10830 sg13cmos5l_a21oi_1_4.A1 sg13cmos5l_nand2_1_13.A 0.02541f
C10831 a_22241_17774# bn5 0.01324f
C10832 sg13cmos5l_dfrbpq_1_28.RESET_B sg13cmos5l_inv_1_12.A 0.03973f
C10833 sg13cmos5l_o21ai_1_5.A1 sg13cmos5l_dfrbpq_1_13.CLK 0.54157f
C10834 sg13cmos5l_nand4_1_18.B a_9096_15996# 0.01139f
C10835 sg13cmos5l_buf_8_2.A a_19035_16750# 0.33432f
C10836 sg13cmos5l_nand2_1_18.A a_13210_12936# 0.28298f
C10837 sg13cmos5l_nand3b_1_1.C a_10389_16258# 0.0601f
C10838 a_15983_6239# a_16650_6460# 0.09257f
C10839 a_16568_9989# VDD 0.2646f
C10840 a_15141_6141# a_15012_6175# 0.01562f
C10841 sg13cmos5l_a21oi_1_20.A2 sg13cmos5l_inv_1_24.A 0.01837f
C10842 sg13cmos5l_buf_1_15.A sg13cmos5l_o21ai_1_23.B1 0.1328f
C10843 a_19275_19031# a_20015_19381# 0.17382f
C10844 sg13cmos5l_buf_1_47.X a_12145_18335# 0.01362f
C10845 sg13cmos5l_a21oi_1_17.Y sg13cmos5l_a21oi_1_20.Y 0.02021f
C10846 sg13cmos5l_inv_1_31.A a_21462_17532# 0.0524f
C10847 sg13cmos5l_dfrbpq_1_28.RESET_B a_21215_18528# 0.04367f
C10848 sg13cmos5l_buf_1_1.A bp7 0.01511f
C10849 sg13cmos5l_dfrbpq_1_28.RESET_B a_20503_18222# 0.10908f
C10850 sg13cmos5l_dfrbpq_1_39.Q a_21350_19020# 0.01685f
C10851 sg13cmos5l_nand2_1_11.B sg13cmos5l_o21ai_1_9.A2 0.0768f
C10852 sg13cmos5l_buf_1_42.A code1 0.04829f
C10853 sg13cmos5l_o21ai_1_0.Y sg13cmos5l_o21ai_1_4.Y 0.26486f
C10854 sg13cmos5l_inv_1_18.Y VDD 0.53888f
C10855 sg13cmos5l_or4_1_1.X VDD 0.5697f
C10856 sg13cmos5l_nand3_1_0.A sg13cmos5l_dlygate4sd3_1_8.X 0.26752f
C10857 sg13cmos5l_dfrbpq_1_20.Q a_5397_18416# 0.02933f
C10858 sg13cmos5l_buf_1_15.A sg13cmos5l_nand2b_1_0.B 0.05098f
C10859 sg13cmos5l_nand4_1_18.B sg13cmos5l_nand4_1_1.B 0.02639f
C10860 sg13cmos5l_inv_1_1.A sg13cmos5l_buf_1_13.A 0.03117f
C10861 sg13cmos5l_a21oi_1_6.A2 bp0 0.0145f
C10862 sg13cmos5l_buf_1_45.X a_13936_19262# 0.10847f
C10863 sg13cmos5l_o21ai_1_15.B1 sg13cmos5l_buf_8_2.A 0.01663f
C10864 sg13cmos5l_nand4_1_3.B sg13cmos5l_nand4_1_18.A 0.17382f
C10865 sg13cmos5l_nand3_1_3.Y sg13cmos5l_nand2_1_5.Y 0.11557f
C10866 sg13cmos5l_inv_1_15.A bp0 0.01019f
C10867 sg13cmos5l_inv_1_15.Y bn5 0.02524f
C10868 sg13cmos5l_mux2_1_1.A1 sg13cmos5l_nand2_1_13.A 0.19819f
C10869 sg13cmos5l_inv_1_13.Y sg13cmos5l_a21oi_1_15.A2 0.35629f
C10870 sg13cmos5l_nand4_1_18.C sg13cmos5l_dlygate4sd3_1_76.A 0.02095f
C10871 a_7446_14508# VDD 0.16153f
C10872 sg13cmos5l_buf_1_21.A sg13cmos5l_nor2_1_3.Y 0.16691f
C10873 sg13cmos5l_buf_1_8.A a_20580_4968# 0.02555f
C10874 a_7144_10034# VDD 0.15464f
C10875 sg13cmos5l_nand2_1_15.B sg13cmos5l_nand2_1_18.A 0.06173f
C10876 sg13cmos5l_dfrbpq_1_35.D a_19044_19445# 0.0173f
C10877 a_18374_7674# a_18660_7992# 0.26205f
C10878 sg13cmos5l_o21ai_1_17.B1 a_12420_19024# 0.03712f
C10879 sg13cmos5l_nand4_1_1.B code0 0.02317f
C10880 a_21215_17016# a_22005_16904# 0.02241f
C10881 sg13cmos5l_o21ai_1_11.Y sg13cmos5l_o21ai_1_12.Y 0.44521f
C10882 sg13cmos5l_buf_1_8.A sg13cmos5l_buf_1_6.A 0.01501f
C10883 sg13cmos5l_a21oi_1_27.B1 sg13cmos5l_nand2_1_11.B 0.53445f
C10884 sg13cmos5l_inv_1_2.A sg13cmos5l_inv_1_0.Y 0.12667f
C10885 sg13cmos5l_dfrbpq_1_13.RESET_B a_10771_9380# 0.01171f
C10886 sg13cmos5l_buf_1_10.A a_22126_4167# 0.01438f
C10887 sg13cmos5l_dfrbpq_1_45.Q a_8734_12214# 0.0213f
C10888 sg13cmos5l_nand3_1_5.Y a_7378_16374# 0.0345f
C10889 sg13cmos5l_buf_1_17.X VDD 0.87951f
C10890 sg13cmos5l_inv_1_24.Y sg13cmos5l_dfrbpq_1_24.Q 0.17133f
C10891 a_4607_18528# a_5303_18649# 0.02431f
C10892 sg13cmos5l_nand4_1_1.C sg13cmos5l_a21oi_1_15.Y 0.02377f
C10893 sg13cmos5l_a21oi_1_27.A1 sg13cmos5l_mux2_1_1.A0 0.20599f
C10894 a_7173_11471# a_7921_11821# 0.01058f
C10895 a_19275_17519# VDD 0.20558f
C10896 sg13cmos5l_a21oi_1_4.A1 a_14548_12508# 0.01719f
C10897 bp4 bp3 0.06571f
C10898 bp7 bn9 0.07373f
C10899 sg13cmos5l_o21ai_1_21.B1 a_4646_19458# 0.01435f
C10900 sg13cmos5l_o21ai_1_12.Y sg13cmos5l_nand4_1_3.B 0.02372f
C10901 sg13cmos5l_nand4_1_3.B a_14517_13880# 0.01173f
C10902 sg13cmos5l_a21oi_1_2.B1 a_17892_11885# 0.01718f
C10903 sg13cmos5l_a21oi_1_17.Y bp0 0.04448f
C10904 a_20294_6166# a_20406_6230# 0.3854f
C10905 sg13cmos5l_dfrbpq_1_5.CLK a_20580_14040# 0.07577f
C10906 sg13cmos5l_dfrbpq_1_24.RESET_B sg13cmos5l_o21ai_1_17.Y 0.15367f
C10907 sg13cmos5l_dfrbpq_1_28.RESET_B a_21350_17508# 0.01178f
C10908 sg13cmos5l_a21oi_1_2.B1 a_22126_6351# 0.03762f
C10909 sg13cmos5l_inv_1_1.A bp7 0.54838f
C10910 a_17604_11464# VDD 0.07285f
C10911 sg13cmos5l_a21oi_1_18.B1 a_20580_14040# 0.02995f
C10912 sg13cmos5l_or4_1_0.D sg13cmos5l_nor3_1_2.C 0.06353f
C10913 sg13cmos5l_buf_1_1.A sg13cmos5l_buf_1_5.A 0.01457f
C10914 sg13cmos5l_inv_1_5.A a_17316_8440# 0.04071f
C10915 sg13cmos5l_buf_1_16.A sg13cmos5l_nand3_1_8.Y 0.10863f
C10916 a_15607_9150# a_15820_9186# 0.23043f
C10917 a_22426_18984# a_22145_19286# 0.18796f
C10918 a_17030_8874# a_17316_8440# 0.26205f
C10919 a_22522_7642# bp5 0.0141f
C10920 sg13cmos5l_dlygate4sd3_1_50.A sg13cmos5l_nor2_1_6.Y 0.06227f
C10921 sg13cmos5l_buf_1_16.A a_19179_10820# 0.039f
C10922 sg13cmos5l_nor3_1_6.Y sg13cmos5l_nand2_1_18.A 0.02406f
C10923 sg13cmos5l_buf_1_16.A sg13cmos5l_nand4_1_1.C 0.11547f
C10924 sg13cmos5l_o21ai_1_5.A2 sg13cmos5l_dfrbpq_1_13.CLK 0.06294f
C10925 sg13cmos5l_buf_1_25.A code2 0.02168f
C10926 sg13cmos5l_a21oi_1_18.B1 sg13cmos5l_inv_1_12.Y 0.05373f
C10927 sg13cmos5l_nand4_1_3.B sg13cmos5l_a21oi_1_27.A1 0.01046f
C10928 sg13cmos5l_nor2_1_2.B a_6671_7751# 0.01557f
C10929 sg13cmos5l_inv_1_25.Y bn7 0.06259f
C10930 sg13cmos5l_dfrbpq_1_3.D VDD 0.23987f
C10931 sg13cmos5l_and2_1_5.X VDD 0.28639f
C10932 a_13208_11501# a_13478_11460# 0.18796f
C10933 sg13cmos5l_inv_1_20.Y sg13cmos5l_o21ai_1_3.Y 0.03126f
C10934 sg13cmos5l_a21o_1_2.A1 sg13cmos5l_o21ai_1_9.B1 0.03378f
C10935 sg13cmos5l_dfrbpq_1_28.RESET_B a_22005_18416# 0.17276f
C10936 a_6682_8400# a_6401_8702# 0.18796f
C10937 sg13cmos5l_a21oi_1_1.A2 a_19649_13238# 0.04725f
C10938 a_19467_5423# VDD 0.20693f
C10939 a_22126_7863# a_21832_7806# 0.01555f
C10940 sg13cmos5l_dlygate4sd3_1_20.A sg13cmos5l_a21oi_1_6.Y 0.72852f
C10941 sg13cmos5l_a21oi_1_1.A2 bp0 0.02744f
C10942 sg13cmos5l_buf_1_15.A sg13cmos5l_inv_1_32.Y 0.01939f
C10943 sg13cmos5l_dfrbpq_1_24.RESET_B a_5349_19031# 0.06137f
C10944 sg13cmos5l_inv_1_18.A sg13cmos5l_nand2_1_0.A 0.72781f
C10945 sg13cmos5l_buf_1_9.A bp2 0.57132f
C10946 a_10812_14020# VDD 0.01158f
C10947 sg13cmos5l_inv_1_15.A sg13cmos5l_nand4_1_16.D 0.06189f
C10948 sg13cmos5l_buf_8_2.A a_20997_12189# 0.01272f
C10949 a_20294_14922# a_20997_14495# 0.02431f
C10950 sg13cmos5l_a21oi_1_2.A2 sg13cmos5l_inv_1_0.A 0.03631f
C10951 sg13cmos5l_buf_1_2.A bp7 0.14337f
C10952 sg13cmos5l_a21oi_1_18.B1 sg13cmos5l_inv_1_24.A 0.01309f
C10953 sg13cmos5l_inv_1_17.Y sg13cmos5l_dfrbpq_1_6.D 0.12512f
C10954 sg13cmos5l_buf_1_7.X a_21099_11471# 0.28119f
C10955 sg13cmos5l_buf_1_21.A a_14517_13880# 0.01802f
C10956 sg13cmos5l_buf_8_2.A sg13cmos5l_o21ai_1_15.Y 0.01913f
C10957 a_13690_16714# a_14038_16742# 0.02803f
C10958 sg13cmos5l_buf_1_45.X a_16474_18984# 0.01138f
C10959 sg13cmos5l_dfrbpq_1_19.CLK a_3879_16083# 0.0177f
C10960 sg13cmos5l_a21oi_1_18.B1 sg13cmos5l_a21oi_1_19.Y 0.608f
C10961 bn3 bn4 0.03339f
C10962 a_7498_18226# sg13cmos5l_a21oi_1_24.A1 0.08017f
C10963 sg13cmos5l_inv_1_1.A sg13cmos5l_a21oi_1_0.Y 0.02003f
C10964 sg13cmos5l_dlygate4sd3_1_82.A sg13cmos5l_a21oi_1_19.Y 0.14648f
C10965 sg13cmos5l_buf_1_9.A a_21099_4772# 0.04798f
C10966 sg13cmos5l_buf_1_0.A bp8 0.02947f
C10967 a_19930_15960# sg13cmos5l_nand2_1_1.A 0.29461f
C10968 sg13cmos5l_dfrbpq_1_13.CLK a_10878_7180# 0.03638f
C10969 sg13cmos5l_buf_1_8.A sg13cmos5l_inv_1_7.A 1.60805f
C10970 sg13cmos5l_nand2b_1_0.B sg13cmos5l_a21oi_1_9.A2 0.02434f
C10971 a_20997_8447# a_21745_8797# 0.01058f
C10972 sg13cmos5l_o21ai_1_25.Y a_14346_19020# 0.02801f
C10973 sg13cmos5l_o21ai_1_25.Y a_14038_16742# 0.06016f
C10974 sg13cmos5l_a21oi_1_14.Y bn5 0.02468f
C10975 sg13cmos5l_nand3_1_4.Y VDD 0.7218f
C10976 sg13cmos5l_a21oi_1_26.A1 a_16197_18237# 0.01657f
C10977 sg13cmos5l_inv_1_1.A sg13cmos5l_buf_1_5.A 0.05034f
C10978 sg13cmos5l_nand4_1_16.D sg13cmos5l_a21oi_1_17.Y 0.18864f
C10979 sg13cmos5l_o21ai_1_5.A1 sg13cmos5l_mux2_1_0.A1 0.02415f
C10980 sg13cmos5l_a21oi_1_4.A1 a_16179_12236# 0.01237f
C10981 a_4127_17016# VDD 0.24001f
C10982 sg13cmos5l_o21ai_1_14.A1 sg13cmos5l_o21ai_1_22.B1 0.40676f
C10983 sg13cmos5l_inv_1_15.Y sg13cmos5l_buf_1_43.X 0.08021f
C10984 sg13cmos5l_dlygate4sd3_1_64.X sg13cmos5l_nand3_1_5.Y 0.11139f
C10985 sg13cmos5l_buf_1_20.A a_10787_12972# 0.02982f
C10986 sg13cmos5l_a22oi_1_0.B2 sg13cmos5l_o21ai_1_0.A1 0.10239f
C10987 sg13cmos5l_buf_1_63.A sg13cmos5l_buf_1_20.A 0.01229f
C10988 a_19467_5423# bp6 0.01956f
C10989 sg13cmos5l_nor3_1_4.A sg13cmos5l_nand2_1_13.A 0.01292f
C10990 sg13cmos5l_dfrbpq_1_13.RESET_B a_9350_12210# 0.08974f
C10991 a_9610_12433# a_9636_12528# 0.24169f
C10992 sg13cmos5l_buf_1_15.A sg13cmos5l_nand2b_1_3.B 0.03189f
C10993 a_21080_17549# VDD 0.25972f
C10994 sg13cmos5l_dfrbpq_1_24.RESET_B a_10954_18481# 0.18833f
C10995 sg13cmos5l_inv_1_36.A sg13cmos5l_nand2_1_19.A 0.20349f
C10996 sg13cmos5l_buf_1_13.X a_17804_4614# 0.15432f
C10997 sg13cmos5l_o21ai_1_23.B1 sg13cmos5l_buf_1_54.A 0.02615f
C10998 sg13cmos5l_buf_1_66.X sg13cmos5l_nor4_1_2.Y 0.03341f
C10999 sg13cmos5l_buf_1_65.A sg13cmos5l_mux2_1_0.S 0.12886f
C11000 VDD bn3 0.42613f
C11001 a_10214_10386# a_10500_9952# 0.26205f
C11002 a_13574_18262# a_13686_18326# 0.3854f
C11003 a_8520_8436# a_8716_8436# 0.03099f
C11004 sg13cmos5l_buf_8_2.A sg13cmos5l_nand4_1_1.B 0.1692f
C11005 a_20104_3176# bp8 0.06515f
C11006 sg13cmos5l_a21oi_1_24.A2 a_17710_17775# 0.04371f
C11007 a_19120_11702# VDD 0.13545f
C11008 sg13cmos5l_buf_1_15.A a_5036_13686# 0.19876f
C11009 sg13cmos5l_buf_1_13.A a_16188_9150# 0.27921f
C11010 a_17316_8440# a_17604_8861# 0.24435f
C11011 sg13cmos5l_inv_1_15.A a_20494_15423# 0.01158f
C11012 sg13cmos5l_nand4_1_5.D sg13cmos5l_nand4_1_16.D 0.11768f
C11013 sg13cmos5l_dfrbpq_1_13.RESET_B clk 0.14919f
C11014 a_19642_6130# sg13cmos5l_a21oi_1_0.Y 0.27411f
C11015 sg13cmos5l_dfrbpq_1_40.Q sg13cmos5l_a21oi_1_25.Y 0.01557f
C11016 sg13cmos5l_buf_1_5.A sg13cmos5l_buf_1_2.A 0.02358f
C11017 sg13cmos5l_a21oi_1_8.A2 a_7989_6320# 0.03206f
C11018 sg13cmos5l_nand3_1_2.Y sg13cmos5l_o21ai_1_28.B1 0.02971f
C11019 a_20554_9916# VDD 0.09615f
C11020 a_14240_12342# VDD 0.07787f
C11021 sg13cmos5l_dfrbpq_1_14.D a_7620_9952# 0.01034f
C11022 sg13cmos5l_nor4_1_2.Y VDD 0.62965f
C11023 sg13cmos5l_dfrbpq_1_34.Q a_21370_19738# 0.01925f
C11024 a_10042_6130# a_9765_5423# 0.01139f
C11025 sg13cmos5l_inv_1_8.A sg13cmos5l_a22oi_1_0.A2 0.06295f
C11026 sg13cmos5l_dlygate4sd3_1_24.A bp5 0.55405f
C11027 sg13cmos5l_inv_1_36.Y sg13cmos5l_o21ai_1_1.B1 0.2349f
C11028 sg13cmos5l_nor2b_1_0.B_N a_15208_11546# 0.04609f
C11029 a_16942_19287# valid 0.0204f
C11030 sg13cmos5l_buf_1_25.A sg13cmos5l_nor2_1_15.Y 0.01964f
C11031 sg13cmos5l_dfrbpq_1_20.Q sg13cmos5l_o21ai_1_20.B1 0.14296f
C11032 sg13cmos5l_buf_8_2.A sg13cmos5l_o21ai_1_28.Y 0.01504f
C11033 sg13cmos5l_inv_1_12.Y bn9 0.03034f
C11034 sg13cmos5l_dlygate4sd3_1_4.A VDD 0.31586f
C11035 sg13cmos5l_buf_1_26.A sg13cmos5l_o21ai_1_23.B1 0.02302f
C11036 a_19275_19031# sg13cmos5l_a21oi_1_19.Y 0.0229f
C11037 a_13738_17476# a_14181_17519# 0.02241f
C11038 sg13cmos5l_a21oi_1_9.Y a_9348_5416# 0.04149f
C11039 a_17124_19783# valid 0.0183f
C11040 sg13cmos5l_a22oi_1_0.A2 sg13cmos5l_a22oi_1_2.Y 0.05218f
C11041 a_13015_13686# VDD 0.18323f
C11042 sg13cmos5l_buf_1_15.A sg13cmos5l_inv_1_12.A 0.22956f
C11043 sg13cmos5l_dlygate4sd3_1_3.A sg13cmos5l_dlygate4sd3_1_0.A 0.20832f
C11044 a_20997_14495# a_21099_14495# 0.3643f
C11045 sg13cmos5l_dlygate4sd3_1_24.A a_22522_7642# 0.06466f
C11046 sg13cmos5l_nand4_1_18.B a_8689_19381# 0.01509f
C11047 sg13cmos5l_dfrbpq_1_34.Q a_18095_19847# 0.01208f
C11048 sg13cmos5l_inv_1_20.Y sg13cmos5l_dlygate4sd3_1_14.A 0.01078f
C11049 a_4936_7806# sg13cmos5l_dlygate4sd3_1_43.X 0.04119f
C11050 a_7498_18226# sg13cmos5l_o21ai_1_19.B1 0.01487f
C11051 sg13cmos5l_o21ai_1_17.B1 sg13cmos5l_buf_1_25.A 0.0526f
C11052 sg13cmos5l_inv_1_18.A a_12826_9154# 0.01229f
C11053 sg13cmos5l_buf_1_66.X sg13cmos5l_o21ai_1_18.A2 0.38224f
C11054 a_21070_7863# a_21185_7864# 0.3854f
C11055 sg13cmos5l_nand4_1_15.B a_17028_15552# 0.02059f
C11056 a_12597_11722# sg13cmos5l_nand3b_1_0.C 0.05559f
C11057 sg13cmos5l_nand3_1_0.A a_11977_9232# 0.01006f
C11058 sg13cmos5l_buf_8_2.A sg13cmos5l_o21ai_1_14.Y 0.04629f
C11059 sg13cmos5l_a21oi_1_27.A2 a_9557_11460# 0.05559f
C11060 sg13cmos5l_a21oi_1_13.Y bn8 0.49411f
C11061 a_4454_14922# a_4740_14488# 0.26205f
C11062 sg13cmos5l_buf_1_16.A a_16556_15960# 0.02965f
C11063 sg13cmos5l_inv_1_1.A sg13cmos5l_inv_1_24.A 0.31041f
C11064 sg13cmos5l_nand2b_1_1.A_N sg13cmos5l_o21ai_1_6.B1 0.10319f
C11065 a_19077_7653# a_18948_7687# 0.01562f
C11066 a_21911_18649# sg13cmos5l_inv_1_25.Y 0.03753f
C11067 sg13cmos5l_buf_1_10.A a_11840_9389# 0.03963f
C11068 sg13cmos5l_a21oi_1_1.A2 a_19338_6924# 0.02181f
C11069 sg13cmos5l_o21ai_1_0.A1 a_14061_8784# 0.0855f
C11070 sg13cmos5l_nand3b_1_3.C sg13cmos5l_inv_1_24.Y 0.01087f
C11071 sg13cmos5l_inv_1_1.Y a_20384_16921# 0.06121f
C11072 a_18730_17476# a_18756_17512# 0.24169f
C11073 sg13cmos5l_a21oi_1_4.A2 a_16448_10034# 0.02164f
C11074 sg13cmos5l_nand3b_1_1.C sg13cmos5l_o21ai_1_5.A1 0.02687f
C11075 VDD bp9 0.22128f
C11076 sg13cmos5l_buf_1_15.A sg13cmos5l_nand2_1_13.A 0.03357f
C11077 sg13cmos5l_o21ai_1_0.A1 a_13014_8460# 0.04385f
C11078 sg13cmos5l_buf_1_42.A sg13cmos5l_a21oi_1_3.A2 0.01435f
C11079 sg13cmos5l_o21ai_1_18.A2 VDD 0.32515f
C11080 sg13cmos5l_nand4_1_12.Y a_17296_18478# 0.011f
C11081 sg13cmos5l_inv_1_11.Y a_19829_8436# 0.0512f
C11082 sg13cmos5l_a21oi_1_4.A2 sg13cmos5l_o21ai_1_3.Y 0.02318f
C11083 sg13cmos5l_dfrbpq_1_24.RESET_B a_12239_18335# 0.10868f
C11084 sg13cmos5l_nand2b_1_4.B sg13cmos5l_a21oi_1_10.A2 0.158f
C11085 sg13cmos5l_inv_1_11.Y a_18660_7992# 0.0393f
C11086 a_14763_19892# sg13cmos5l_dfrbpq_1_41.CLK 0.01578f
C11087 a_4607_18528# a_4366_18258# 0.01058f
C11088 a_4455_18476# a_5258_18416# 0.07823f
C11089 a_10214_10386# a_11019_9959# 0.07916f
C11090 a_14218_18226# a_15494_18258# 0.01379f
C11091 sg13cmos5l_nand2b_1_3.B sg13cmos5l_a21oi_1_9.A2 1.4566f
C11092 sg13cmos5l_a21oi_1_2.B1 a_20580_6928# 0.03756f
C11093 sg13cmos5l_dlygate4sd3_1_72.A a_18730_17476# 0.01087f
C11094 a_19448_12214# VDD 0.26001f
C11095 a_6835_13916# a_7078_14044# 0.08536f
C11096 a_15820_9186# a_16167_9404# 0.03546f
C11097 a_17835_8447# a_18832_8678# 0.03546f
C11098 a_15783_7892# a_16586_7832# 0.07823f
C11099 a_15935_7944# a_15694_7674# 0.01058f
C11100 sg13cmos5l_dlygate4sd3_1_38.X sg13cmos5l_a21o_1_1.A2 0.09136f
C11101 sg13cmos5l_dfrbpq_1_28.RESET_B sg13cmos5l_dfrbpq_1_28.Q 0.04151f
C11102 sg13cmos5l_nand4_1_1.B sg13cmos5l_a21oi_1_15.Y 0.05365f
C11103 sg13cmos5l_inv_1_5.A a_15804_7638# 0.07211f
C11104 sg13cmos5l_inv_1_9.Y sg13cmos5l_buf_1_13.X 0.23077f
C11105 a_7726_8703# a_7841_8702# 0.3854f
C11106 sg13cmos5l_dfrbpq_1_13.D clk 0.04354f
C11107 sg13cmos5l_o21ai_1_9.A2 sg13cmos5l_nor2_1_6.Y 0.02292f
C11108 sg13cmos5l_a21o_1_1.A2 a_8037_9959# 0.02267f
C11109 a_19738_9912# sg13cmos5l_dfrbpq_1_11.Q 0.28302f
C11110 sg13cmos5l_dfrbpq_1_13.CLK a_16673_11726# 0.01592f
C11111 sg13cmos5l_dfrbpq_1_34.Q sg13cmos5l_dfrbpq_1_5.CLK 0.0646f
C11112 sg13cmos5l_dlygate4sd3_1_77.A sg13cmos5l_inv_1_24.A 0.05788f
C11113 a_19246_6351# sg13cmos5l_dfrbpq_1_1.D 0.1068f
C11114 sg13cmos5l_buf_1_53.A sg13cmos5l_nand4_1_1.C 0.0161f
C11115 sg13cmos5l_buf_1_42.A a_17718_16754# 0.01811f
C11116 a_17057_19286# valid 0.06056f
C11117 a_21462_19044# a_22030_19287# 0.01641f
C11118 sg13cmos5l_inv_1_15.A a_18287_15311# 0.01311f
C11119 sg13cmos5l_dfrbpq_1_15.CLK sg13cmos5l_a21o_1_1.A2 0.07637f
C11120 sg13cmos5l_dfrbpq_1_24.RESET_B a_7941_19031# 0.04862f
C11121 sg13cmos5l_dfrbpq_1_35.Q sg13cmos5l_a21oi_1_19.Y 0.20214f
C11122 a_13764_17512# a_15023_17869# 0.01412f
C11123 sg13cmos5l_o21ai_1_10.B1 a_5686_16374# 0.03105f
C11124 a_7334_10386# a_7594_9916# 0.45119f
C11125 sg13cmos5l_o21ai_1_20.Y a_3776_18433# 0.04826f
C11126 sg13cmos5l_nand2b_1_1.A_N a_12957_7194# 0.02775f
C11127 sg13cmos5l_dlygate4sd3_1_7.X VDD 0.3658f
C11128 sg13cmos5l_inv_1_32.Y sg13cmos5l_buf_1_26.A 0.01711f
C11129 a_22096_14726# a_22506_14484# 0.07015f
C11130 sg13cmos5l_buf_1_16.A sg13cmos5l_nand4_1_1.B 0.18386f
C11131 a_20997_14495# bn7 0.04489f
C11132 sg13cmos5l_dlygate4sd3_1_33.X a_5032_9948# 0.02829f
C11133 sg13cmos5l_inv_1_17.A a_20580_11464# 0.01935f
C11134 sg13cmos5l_and2_1_6.A a_12045_11808# 0.07968f
C11135 sg13cmos5l_o21ai_1_10.Y a_5784_15976# 0.01087f
C11136 sg13cmos5l_buf_1_45.X a_15494_18258# 0.08008f
C11137 sg13cmos5l_dfrbpq_1_28.D bn8 0.11643f
C11138 sg13cmos5l_a21oi_1_27.B1 sg13cmos5l_nor2_1_6.Y 0.27227f
C11139 sg13cmos5l_dfrbpq_1_15.CLK sg13cmos5l_dlygate4sd3_1_43.X 0.13237f
C11140 sg13cmos5l_buf_1_26.A a_15280_17750# 0.01042f
C11141 sg13cmos5l_nand3_1_0.A sg13cmos5l_nor2_1_0.Y 0.01332f
C11142 sg13cmos5l_inv_1_15.A a_21084_16710# 0.0108f
C11143 sg13cmos5l_o21ai_1_21.B1 a_4168_19902# 0.03744f
C11144 sg13cmos5l_a21oi_1_21.A1 sg13cmos5l_nand4_1_12.Y 0.12102f
C11145 a_4740_14488# a_5028_14909# 0.24435f
C11146 sg13cmos5l_nor4_1_0.Y sg13cmos5l_a22oi_1_2.Y 0.32492f
C11147 sg13cmos5l_nand4_1_18.A sg13cmos5l_a21oi_1_5.A2 0.25909f
C11148 sg13cmos5l_o21ai_1_0.Y sg13cmos5l_o21ai_1_4.A1 0.02158f
C11149 sg13cmos5l_dfrbpq_1_13.CLK a_11759_10309# 0.01612f
C11150 sg13cmos5l_buf_1_20.A sg13cmos5l_nor3_1_6.Y 0.03193f
C11151 sg13cmos5l_a21o_1_2.X a_5157_14495# 0.0166f
C11152 sg13cmos5l_buf_1_15.A sg13cmos5l_dfrbpq_1_2.D 0.03051f
C11153 sg13cmos5l_nand3b_1_1.C sg13cmos5l_o21ai_1_5.A2 0.16271f
C11154 sg13cmos5l_a21oi_1_7.A2 sg13cmos5l_inv_1_4.Y 0.11983f
C11155 sg13cmos5l_dlygate4sd3_1_15.X a_12987_10318# 0.04476f
C11156 a_18756_17512# a_19044_17933# 0.24435f
C11157 sg13cmos5l_o21ai_1_26.B1 a_13585_19381# 0.01808f
C11158 a_21640_3900# VDD 0.17926f
C11159 sg13cmos5l_inv_1_17.A a_21911_16043# 0.03509f
C11160 sg13cmos5l_nand4_1_12.Y sg13cmos5l_dfrbpq_1_33.Q 0.03752f
C11161 sg13cmos5l_buf_1_1.A a_20580_4968# 0.04231f
C11162 sg13cmos5l_inv_1_11.Y a_19919_7751# 0.01587f
C11163 sg13cmos5l_nand4_1_8.B sg13cmos5l_buf_1_20.A 0.07481f
C11164 sg13cmos5l_a21oi_1_3.A2 sg13cmos5l_inv_1_4.Y 0.20395f
C11165 sg13cmos5l_a21oi_1_6.A2 sg13cmos5l_dfrbpq_1_6.D 0.22899f
C11166 sg13cmos5l_buf_1_47.X sg13cmos5l_o21ai_1_24.Y 0.16664f
C11167 sg13cmos5l_buf_1_21.A a_11372_10662# 0.01304f
C11168 sg13cmos5l_dfrbpq_1_29.Q VDD 0.40637f
C11169 a_10500_9952# a_11665_10309# 0.25046f
C11170 a_15780_18576# a_16197_18237# 0.28324f
C11171 a_15494_18258# a_16299_18380# 0.07916f
C11172 sg13cmos5l_o21ai_1_0.B1 a_13212_5773# 0.04399f
C11173 sg13cmos5l_o21ai_1_18.B1 sg13cmos5l_dlygate4sd3_1_56.X 0.01288f
C11174 sg13cmos5l_buf_1_29.A sg13cmos5l_inv_1_36.A 0.01102f
C11175 a_19534_13239# VDD 0.16063f
C11176 sg13cmos5l_a21oi_1_2.B1 a_21099_6935# 0.02279f
C11177 sg13cmos5l_dlygate4sd3_1_72.A a_19044_17933# 0.02644f
C11178 sg13cmos5l_dfrbpq_1_20.Q sg13cmos5l_dfrbpq_1_24.RESET_B 0.38067f
C11179 sg13cmos5l_a21oi_1_2.Y a_19467_5423# 0.01273f
C11180 a_12045_11808# clk 0.01191f
C11181 sg13cmos5l_nor3_1_6.Y sg13cmos5l_inv_1_13.Y 0.02128f
C11182 a_16188_9150# a_17109_9344# 0.24169f
C11183 sg13cmos5l_nand3b_1_3.C a_7238_17508# 0.01057f
C11184 sg13cmos5l_inv_1_4.Y a_17098_6130# 0.0327f
C11185 a_20974_19959# sg13cmos5l_buf_1_24.A 0.10731f
C11186 sg13cmos5l_a21oi_1_20.Y a_16469_14484# 0.1071f
C11187 a_8955_9228# sg13cmos5l_o21ai_1_6.Y 0.01278f
C11188 sg13cmos5l_nand4_1_18.D sg13cmos5l_inv_1_12.Y 0.10223f
C11189 sg13cmos5l_dlygate4sd3_1_98.A a_18756_17512# 0.01716f
C11190 sg13cmos5l_nand3_1_5.Y sg13cmos5l_o21ai_1_5.A2 0.03561f
C11191 sg13cmos5l_dfrbpq_1_28.RESET_B sg13cmos5l_inv_1_17.A 0.07863f
C11192 sg13cmos5l_a21oi_1_4.A1 sg13cmos5l_inv_1_8.A 0.0103f
C11193 sg13cmos5l_or4_1_0.C a_9934_9375# 0.0202f
C11194 sg13cmos5l_inv_1_15.Y sg13cmos5l_o21ai_1_23.B1 0.02231f
C11195 a_20110_19959# a_20225_19960# 0.3854f
C11196 sg13cmos5l_dfrbpq_1_15.Q sg13cmos5l_a21oi_1_10.A1 0.02332f
C11197 sg13cmos5l_o21ai_1_25.Y a_14218_19993# 0.01161f
C11198 sg13cmos5l_nand3_1_8.Y sg13cmos5l_nand4_1_3.D 0.04282f
C11199 sg13cmos5l_nand2b_1_4.B a_8878_7191# 0.01775f
C11200 sg13cmos5l_nand4_1_12.Y sg13cmos5l_nand4_1_5.D 0.01309f
C11201 sg13cmos5l_inv_1_0.A bp8 0.0134f
C11202 sg13cmos5l_nor4_1_4.C a_10833_14874# 0.01859f
C11203 a_18478_10215# a_18593_10214# 0.3854f
C11204 sg13cmos5l_buf_1_45.X a_13575_13940# 0.28795f
C11205 sg13cmos5l_nand4_1_3.D sg13cmos5l_nand4_1_1.C 0.11628f
C11206 sg13cmos5l_dlygate4sd3_1_98.A sg13cmos5l_dlygate4sd3_1_72.A 0.06866f
C11207 a_15280_17750# a_15690_17508# 0.07015f
C11208 a_21358_5679# a_21473_5678# 0.3854f
C11209 sg13cmos5l_nand4_1_5.D a_18286_16935# 0.01804f
C11210 a_14144_7806# VDD 0.0753f
C11211 sg13cmos5l_inv_1_17.A a_21839_11821# 0.06101f
C11212 sg13cmos5l_nand2_1_12.Y sg13cmos5l_nand2_1_12.A 0.15617f
C11213 sg13cmos5l_nand4_1_18.B sg13cmos5l_inv_1_12.Y 0.04519f
C11214 a_21839_14845# bn6 0.01608f
C11215 sg13cmos5l_buf_1_45.X a_17296_18478# 0.10001f
C11216 sg13cmos5l_o21ai_1_3.Y a_16568_9989# 0.28282f
C11217 sg13cmos5l_buf_1_53.A sg13cmos5l_dlygate4sd3_1_81.X 0.0118f
C11218 sg13cmos5l_o21ai_1_3.A2 a_14902_8814# 0.07051f
C11219 sg13cmos5l_inv_1_15.A a_21911_17137# 0.0403f
C11220 a_3900_16357# a_4682_16276# 0.24435f
C11221 sg13cmos5l_dfrbpq_1_18.Q sg13cmos5l_inv_1_36.A 0.03296f
C11222 a_22096_10190# bp1 0.03085f
C11223 sg13cmos5l_inv_1_1.A sg13cmos5l_dlygate4sd3_1_18.A 0.04213f
C11224 sg13cmos5l_buf_8_2.A sg13cmos5l_dlygate4sd3_1_80.X 0.02701f
C11225 a_8444_17064# VDD 0.01784f
C11226 sg13cmos5l_buf_1_21.A sg13cmos5l_nand2_1_19.A 0.61761f
C11227 a_14926_16935# code0 0.04542f
C11228 sg13cmos5l_inv_1_17.Y sg13cmos5l_inv_1_4.Y 0.02227f
C11229 a_18662_5850# a_19467_5423# 0.07916f
C11230 sg13cmos5l_o21ai_1_25.Y sg13cmos5l_buf_1_24.A 0.01574f
C11231 sg13cmos5l_inv_1_25.Y a_22523_15532# 0.05988f
C11232 sg13cmos5l_nand2_1_0.A sg13cmos5l_o21ai_1_0.A1 0.21856f
C11233 sg13cmos5l_nand4_1_18.B sg13cmos5l_inv_1_24.A 0.02088f
C11234 a_3200_16283# a_3532_16434# 0.07015f
C11235 sg13cmos5l_a21oi_1_4.A1 bp0 0.02248f
C11236 sg13cmos5l_nor4_1_0.Y sg13cmos5l_nand2_1_5.Y 0.02386f
C11237 a_19044_17933# a_19275_17519# 0.07823f
C11238 a_15041_16936# a_15322_16714# 0.18796f
C11239 sg13cmos5l_nand2b_1_0.B sg13cmos5l_and4_1_0.D 0.51939f
C11240 sg13cmos5l_buf_1_1.A sg13cmos5l_inv_1_7.A 0.02653f
C11241 sg13cmos5l_nor3_1_6.Y a_19240_13058# 0.01029f
C11242 a_19336_3176# VDD 0.17871f
C11243 sg13cmos5l_buf_1_7.X a_19179_7796# 0.29293f
C11244 sg13cmos5l_inv_1_11.Y a_19825_7751# 0.01783f
C11245 sg13cmos5l_o21ai_1_6.B1 VDD 0.25507f
C11246 sg13cmos5l_dlygate4sd3_1_50.X sg13cmos5l_nor2_1_6.Y 0.86253f
C11247 sg13cmos5l_inv_1_24.A code0 0.01322f
C11248 a_2156_19734# code9 0.16246f
C11249 sg13cmos5l_a21o_1_0.A2 a_11014_9508# 0.04799f
C11250 sg13cmos5l_o21ai_1_21.B1 a_4455_18476# 0.03598f
C11251 sg13cmos5l_inv_1_18.A sg13cmos5l_nor4_1_0.C 0.08422f
C11252 a_12016_10190# a_12426_9948# 0.07015f
C11253 sg13cmos5l_inv_1_1.Y bp1 0.01489f
C11254 a_16299_18380# a_17296_18478# 0.03412f
C11255 sg13cmos5l_buf_1_2.A a_20580_4968# 0.04457f
C11256 sg13cmos5l_a21oi_1_1.A2 a_19361_6352# 0.03058f
C11257 a_10118_18262# VDD 0.20915f
C11258 sg13cmos5l_inv_1_14.Y a_18188_4614# 0.04797f
C11259 a_6368_6337# VDD 0.29333f
C11260 sg13cmos5l_inv_1_2.A a_18660_7992# 0.06554f
C11261 sg13cmos5l_a21oi_1_3.A2 sg13cmos5l_nand3_1_0.Y 0.01662f
C11262 sg13cmos5l_buf_1_45.X a_15760_19990# 0.09972f
C11263 a_17578_11428# a_17604_11464# 0.24169f
C11264 sg13cmos5l_dlygate4sd3_1_71.X VDD 0.24199f
C11265 sg13cmos5l_buf_1_2.A sg13cmos5l_buf_1_6.A 0.02327f
C11266 a_14283_17519# bn2 0.01508f
C11267 a_18094_9375# sg13cmos5l_dfrbpq_1_11.D 0.10673f
C11268 sg13cmos5l_o21ai_1_25.Y sg13cmos5l_nor2_1_15.Y 0.01622f
C11269 a_21839_7285# VDD 0.17225f
C11270 sg13cmos5l_dlygate4sd3_1_98.A a_19275_17519# 0.01985f
C11271 sg13cmos5l_a21oi_1_3.A2 a_16949_12508# 0.02384f
C11272 sg13cmos5l_inv_1_9.Y sg13cmos5l_buf_1_9.A 0.07819f
C11273 sg13cmos5l_dlygate4sd3_1_55.X VDD 0.25528f
C11274 VDD start 0.26303f
C11275 sg13cmos5l_buf_8_2.A sg13cmos5l_buf_1_5.A 0.05642f
C11276 sg13cmos5l_a21oi_1_24.Y a_16763_17508# 0.03936f
C11277 a_8830_17874# a_9156_17874# 0.01251f
C11278 sg13cmos5l_mux2_1_0.S a_8734_12214# 0.04963f
C11279 a_9824_19106# VDD 0.08016f
C11280 sg13cmos5l_buf_1_5.A a_19160_9190# 0.04793f
C11281 a_3872_17594# VDD 0.08572f
C11282 sg13cmos5l_dfrbpq_1_28.RESET_B bp0 0.04143f
C11283 sg13cmos5l_nand3_1_4.Y sg13cmos5l_nand2_1_6.A 0.04607f
C11284 sg13cmos5l_nand2_1_1.Y a_17240_10702# 0.02141f
C11285 sg13cmos5l_nor3_1_1.Y a_12029_5412# 0.02677f
C11286 sg13cmos5l_dfrbpq_1_28.RESET_B a_20554_12433# 0.19992f
C11287 sg13cmos5l_nor4_1_4.C a_10428_14484# 0.01709f
C11288 sg13cmos5l_buf_1_45.X sg13cmos5l_inv_1_15.A 0.02815f
C11289 a_11656_15272# a_11464_15366# 0.01225f
C11290 sg13cmos5l_inv_1_36.A sg13cmos5l_nand2_1_19.Y 0.02136f
C11291 sg13cmos5l_inv_1_24.Y bn2 0.19605f
C11292 a_17608_13760# VDD 0.20204f
C11293 sg13cmos5l_inv_1_7.A bn9 0.03323f
C11294 sg13cmos5l_a21oi_1_21.A1 sg13cmos5l_buf_1_45.X 0.03514f
C11295 sg13cmos5l_dfrbpq_1_24.RESET_B sg13cmos5l_buf_1_47.X 0.07153f
C11296 sg13cmos5l_buf_1_20.A sg13cmos5l_dfrbpq_1_24.Q 0.46714f
C11297 sg13cmos5l_dlygate4sd3_1_64.X sg13cmos5l_dfrbpq_1_19.CLK 0.02055f
C11298 a_6682_15960# a_6401_16262# 0.18796f
C11299 sg13cmos5l_dfrbpq_1_24.RESET_B a_5397_18416# 0.20722f
C11300 a_8037_9959# a_8785_10309# 0.01058f
C11301 sg13cmos5l_dlygate4sd3_1_82.X sg13cmos5l_buf_1_25.A 0.01773f
C11302 sg13cmos5l_o21ai_1_1.B1 a_14902_8814# 0.01366f
C11303 a_16197_18237# valid 0.01011f
C11304 sg13cmos5l_o21ai_1_15.B1 sg13cmos5l_o21ai_1_22.B1 0.03397f
C11305 sg13cmos5l_a21oi_1_2.B1 a_17126_7362# 0.04318f
C11306 sg13cmos5l_dfrbpq_1_13.CLK sg13cmos5l_o21ai_1_1.B1 0.05777f
C11307 a_12814_19959# sg13cmos5l_o21ai_1_17.B1 0.10701f
C11308 a_18634_10921# VDD 0.0961f
C11309 sg13cmos5l_dlygate4sd3_1_64.X sg13cmos5l_nor2_1_7.Y 0.14107f
C11310 sg13cmos5l_a21oi_1_17.Y a_17224_12972# 0.01053f
C11311 a_17038_14751# VDD 0.16027f
C11312 sg13cmos5l_nor2_1_2.B a_7989_6320# 0.01779f
C11313 a_20294_13722# a_20868_13735# 0.18486f
C11314 a_21099_13844# a_22096_13942# 0.03412f
C11315 sg13cmos5l_dfrbpq_1_25.Q a_7073_19960# 0.02753f
C11316 sg13cmos5l_buf_1_24.A valid 0.04568f
C11317 sg13cmos5l_dlygate4sd3_1_4.A sg13cmos5l_inv_1_6.Y 0.02075f
C11318 sg13cmos5l_buf_8_2.A a_15392_18390# 0.02112f
C11319 sg13cmos5l_nand4_1_3.D a_15968_14570# 0.01364f
C11320 a_13460_6924# VDD 0.14014f
C11321 a_15299_10996# VDD 0.01222f
C11322 sg13cmos5l_dlygate4sd3_1_82.X sg13cmos5l_a21oi_1_26.Y 0.04346f
C11323 sg13cmos5l_buf_1_16.A sg13cmos5l_buf_1_13.A 0.02372f
C11324 sg13cmos5l_dfrbpq_1_2.D sg13cmos5l_dfrbpq_1_9.D 0.01002f
C11325 sg13cmos5l_nand4_1_1.B sg13cmos5l_buf_1_53.A 0.02745f
C11326 a_20207_5773# sg13cmos5l_dfrbpq_1_0.D 0.01358f
C11327 sg13cmos5l_nand2_1_1.A sg13cmos5l_dlygate4sd3_1_13.X 0.16413f
C11328 sg13cmos5l_buf_1_1.A sg13cmos5l_buf_1_10.A 0.57309f
C11329 sg13cmos5l_nand3b_1_0.C a_13478_11460# 0.01153f
C11330 a_4646_19458# VDD 0.52297f
C11331 a_14446_9375# a_14561_9376# 0.3854f
C11332 sg13cmos5l_a21o_1_2.B1 a_7078_14044# 0.05104f
C11333 sg13cmos5l_nand4_1_18.A a_19550_13730# 0.01888f
C11334 a_12957_7194# VDD 0.20206f
C11335 bn0 code0 0.03406f
C11336 a_5126_7674# a_5829_7653# 0.02453f
C11337 sg13cmos5l_nor4_1_4.C sg13cmos5l_and4_1_1.A 0.09897f
C11338 sg13cmos5l_nand4_1_7.B bn5 0.33643f
C11339 a_12597_11722# VDD 0.1852f
C11340 a_18948_5416# a_20113_5773# 0.25046f
C11341 a_19236_5837# a_19467_5423# 0.07823f
C11342 sg13cmos5l_nor2_1_10.Y sg13cmos5l_nor2b_1_1.A 0.03606f
C11343 sg13cmos5l_nand2_1_0.B a_13390_7863# 0.05349f
C11344 sg13cmos5l_dlygate4sd3_1_76.A sg13cmos5l_dlygate4sd3_1_76.X 0.02532f
C11345 a_9348_20088# VDD 0.0726f
C11346 sg13cmos5l_buf_1_15.A sg13cmos5l_buf_1_0.A 0.03633f
C11347 a_20015_17869# a_19921_17869# 0.16704f
C11348 a_22126_3327# VDD 0.15872f
C11349 sg13cmos5l_buf_1_7.X sg13cmos5l_dfrbpq_1_8.D 0.15862f
C11350 sg13cmos5l_nand4_1_8.B a_13670_15238# 0.01338f
C11351 sg13cmos5l_buf_1_42.A a_20012_14448# 0.18774f
C11352 sg13cmos5l_buf_1_7.X a_20586_7972# 0.06565f
C11353 a_14283_16007# VDD 0.20526f
C11354 a_13014_8460# a_12902_8436# 0.3854f
C11355 sg13cmos5l_a21oi_1_10.A2 a_10522_7678# 0.01829f
C11356 sg13cmos5l_buf_8_2.A sg13cmos5l_inv_1_12.Y 0.12196f
C11357 sg13cmos5l_a21o_1_2.A1 sg13cmos5l_inv_1_36.A 0.0202f
C11358 sg13cmos5l_buf_1_2.A sg13cmos5l_inv_1_7.A 0.03398f
C11359 a_20503_16710# VDD 0.17225f
C11360 sg13cmos5l_inv_1_15.A sg13cmos5l_nand3_1_2.Y 0.10033f
C11361 sg13cmos5l_inv_1_1.Y a_20716_16746# 0.01277f
C11362 sg13cmos5l_dfrbpq_1_28.RESET_B sg13cmos5l_nand4_1_16.D 0.09073f
C11363 VDD rst_n 0.22884f
C11364 sg13cmos5l_nand4_1_3.B sg13cmos5l_a21oi_1_23.A2 0.08775f
C11365 a_7895_6553# VDD 0.52434f
C11366 a_17604_11464# a_18123_11471# 0.20754f
C11367 a_18021_11471# a_17892_11885# 0.01562f
C11368 sg13cmos5l_buf_1_42.A sg13cmos5l_a21oi_1_6.A2 0.02758f
C11369 a_17621_12972# VDD 0.16182f
C11370 sg13cmos5l_buf_1_59.A a_15041_16936# 0.01718f
C11371 sg13cmos5l_buf_1_10.A bn9 0.04114f
C11372 sg13cmos5l_nor3_1_2.B a_10774_10694# 0.04195f
C11373 sg13cmos5l_inv_1_15.A sg13cmos5l_buf_1_42.A 0.16032f
C11374 sg13cmos5l_dlygate4sd3_1_98.A a_21080_17549# 0.27728f
C11375 a_16188_9150# a_16078_9186# 0.25046f
C11376 sg13cmos5l_nand4_1_18.D a_19136_13854# 0.05414f
C11377 sg13cmos5l_buf_8_2.A sg13cmos5l_inv_1_24.A 0.0458f
C11378 sg13cmos5l_and4_1_0.D sg13cmos5l_nand2b_1_3.B 0.0782f
C11379 a_9070_18447# VDD 0.1601f
C11380 sg13cmos5l_nor3_1_6.Y sg13cmos5l_nor2_1_6.Y 0.1171f
C11381 sg13cmos5l_inv_1_17.A a_21084_16357# 0.0169f
C11382 sg13cmos5l_dfrbpq_1_13.RESET_B a_10474_9916# 0.175f
C11383 a_5334_17532# VDD 0.15879f
C11384 sg13cmos5l_a21oi_1_19.Y sg13cmos5l_buf_8_2.A 0.02522f
C11385 sg13cmos5l_inv_1_1.A sg13cmos5l_buf_1_10.A 0.02219f
C11386 sg13cmos5l_dfrbpq_1_13.RESET_B sg13cmos5l_a21o_1_1.A2 0.09692f
C11387 sg13cmos5l_buf_8_2.A a_13228_13722# 0.01386f
C11388 sg13cmos5l_dfrbpq_1_28.RESET_B a_21839_12287# 0.10868f
C11389 a_22126_4167# bp5 0.01386f
C11390 a_21934_10887# VDD 0.1601f
C11391 sg13cmos5l_inv_1_20.Y sg13cmos5l_nor3_1_7.Y 0.01417f
C11392 sg13cmos5l_inv_1_15.Y sg13cmos5l_inv_1_12.A 0.02199f
C11393 sg13cmos5l_o21ai_1_15.Y sg13cmos5l_o21ai_1_22.B1 0.0187f
C11394 sg13cmos5l_nand4_1_18.D sg13cmos5l_dlygate4sd3_1_18.A 0.0203f
C11395 sg13cmos5l_nor3_1_2.B sg13cmos5l_or4_1_0.D 0.04707f
C11396 sg13cmos5l_buf_1_13.X sg13cmos5l_inv_1_5.A 0.16268f
C11397 sg13cmos5l_o21ai_1_26.B1 sg13cmos5l_buf_1_45.X 0.19889f
C11398 sg13cmos5l_buf_1_0.A sg13cmos5l_buf_1_3.A 0.10361f
C11399 sg13cmos5l_buf_1_13.X a_17030_8874# 0.09318f
C11400 sg13cmos5l_inv_1_1.Y sg13cmos5l_a21oi_1_7.A2 0.04623f
C11401 sg13cmos5l_buf_1_15.A sg13cmos5l_inv_1_17.A 0.01979f
C11402 sg13cmos5l_buf_1_7.X a_18948_5416# 0.28983f
C11403 sg13cmos5l_buf_1_21.A bn5 0.01202f
C11404 sg13cmos5l_a21oi_1_2.B1 a_17700_7349# 0.013f
C11405 a_6671_7751# sg13cmos5l_dlygate4sd3_1_43.A 0.01264f
C11406 a_8006_7678# sg13cmos5l_nand2b_1_4.Y 0.05474f
C11407 sg13cmos5l_a21oi_1_4.A2 a_13478_16434# 0.03742f
C11408 sg13cmos5l_dfrbpq_1_13.RESET_B a_5032_9948# 0.17403f
C11409 sg13cmos5l_buf_1_42.A sg13cmos5l_a21oi_1_17.Y 0.4538f
C11410 a_21215_18528# a_21063_18476# 0.3643f
C11411 a_21839_13799# a_22096_13942# 0.23043f
C11412 sg13cmos5l_dfrbpq_1_13.RESET_B sg13cmos5l_dlygate4sd3_1_43.X 0.1773f
C11413 a_17386_6892# VDD 0.09571f
C11414 sg13cmos5l_inv_1_1.Y a_20890_15202# 0.01059f
C11415 a_3296_16921# a_3628_16746# 0.07015f
C11416 a_20503_18222# a_21063_18476# 0.17382f
C11417 sg13cmos5l_buf_1_16.A sg13cmos5l_a21oi_1_0.Y 0.16676f
C11418 sg13cmos5l_dfrbpq_1_5.CLK sg13cmos5l_inv_1_16.A 0.02277f
C11419 a_5124_9504# sg13cmos5l_nor3_1_2.C 0.01825f
C11420 sg13cmos5l_a21oi_1_18.B1 sg13cmos5l_inv_1_16.A 0.40239f
C11421 a_5451_19031# VDD 0.20503f
C11422 a_21839_12287# a_21839_11821# 0.01715f
C11423 sg13cmos5l_buf_1_15.A code4 0.021f
C11424 sg13cmos5l_buf_1_16.A a_18497_6352# 0.01528f
C11425 sg13cmos5l_o21ai_1_21.A2 a_7073_16936# 0.01036f
C11426 a_17253_19749# a_18001_19847# 0.01058f
C11427 a_5931_7796# a_6671_7751# 0.17382f
C11428 sg13cmos5l_dfrbpq_1_30.D a_21920_17594# 0.01243f
C11429 a_13208_11501# sg13cmos5l_nand2_1_0.A 0.02301f
C11430 sg13cmos5l_nand4_1_7.B sg13cmos5l_dfrbpq_1_18.Q 0.43336f
C11431 sg13cmos5l_buf_1_16.A sg13cmos5l_buf_1_5.A 1.03527f
C11432 sg13cmos5l_o21ai_1_1.B1 a_11759_10309# 0.02594f
C11433 a_4031_15967# a_4682_16276# 0.01562f
C11434 sg13cmos5l_dlygate4sd3_1_54.A sg13cmos5l_dfrbpq_1_24.RESET_B 0.02347f
C11435 sg13cmos5l_o21ai_1_7.A2 sg13cmos5l_nand3_1_5.Y 0.02498f
C11436 a_20207_5773# a_20113_5773# 0.16704f
C11437 sg13cmos5l_dfrbpq_1_30.D bn6 0.32861f
C11438 sg13cmos5l_dfrbpq_1_24.RESET_B a_4821_16043# 0.21999f
C11439 sg13cmos5l_nand4_1_15.B a_13596_13686# 0.01437f
C11440 a_13974_6230# VDD 0.1607f
C11441 sg13cmos5l_dfrbpq_1_5.CLK a_22005_16043# 0.01768f
C11442 a_14624_15366# VDD 0.07779f
C11443 sg13cmos5l_o21ai_1_22.B1 sg13cmos5l_nand4_1_1.B 0.02919f
C11444 sg13cmos5l_nand4_1_7.B sg13cmos5l_buf_1_43.X 0.29021f
C11445 sg13cmos5l_buf_1_42.A sg13cmos5l_nand4_1_5.D 0.3145f
C11446 sg13cmos5l_buf_1_15.A sg13cmos5l_inv_1_8.A 0.18523f
C11447 sg13cmos5l_nand4_1_3.B sg13cmos5l_dfrbpq_1_18.Q 0.01813f
C11448 a_3319_15960# a_3790_16434# 0.16704f
C11449 sg13cmos5l_buf_8_2.A bn0 0.06168f
C11450 sg13cmos5l_buf_1_66.X sg13cmos5l_nand3b_1_1.Y 0.04205f
C11451 sg13cmos5l_dfrbpq_1_24.RESET_B a_3319_15960# 0.10928f
C11452 a_14746_9912# sg13cmos5l_o21ai_1_3.A2 0.04794f
C11453 sg13cmos5l_dfrbpq_1_28.RESET_B a_17445_15213# 0.04962f
C11454 sg13cmos5l_a21oi_1_9.A2 a_14657_7190# 0.01806f
C11455 a_13400_15238# VDD 0.27328f
C11456 sg13cmos5l_buf_1_43.X sg13cmos5l_nand4_1_3.B 0.05003f
C11457 sg13cmos5l_buf_1_15.A sg13cmos5l_a22oi_1_2.Y 0.03135f
C11458 sg13cmos5l_dfrbpq_1_28.RESET_B a_18470_19458# 0.10297f
C11459 sg13cmos5l_nand3b_1_3.C sg13cmos5l_nand2_1_11.B 0.03035f
C11460 sg13cmos5l_nor2b_1_0.B_N sg13cmos5l_nor3_1_2.B 0.0392f
C11461 sg13cmos5l_a21oi_1_2.A2 sg13cmos5l_inv_1_4.Y 0.2715f
C11462 a_6785_18448# a_7066_18226# 0.18796f
C11463 sg13cmos5l_inv_1_31.A sg13cmos5l_inv_1_31.Y 0.06617f
C11464 a_18123_11471# a_19120_11702# 0.03546f
C11465 sg13cmos5l_dfrbpq_1_45.D VDD 0.46391f
C11466 sg13cmos5l_buf_1_13.A a_12631_5376# 0.10878f
C11467 sg13cmos5l_inv_1_12.Y sg13cmos5l_a21oi_1_15.Y 0.02208f
C11468 a_11397_18237# VDD 0.2464f
C11469 sg13cmos5l_buf_1_15.A a_9867_19892# 0.28125f
C11470 a_17704_3986# VDD 0.16448f
C11471 sg13cmos5l_inv_1_12.A sg13cmos5l_buf_1_7.X 0.0161f
C11472 sg13cmos5l_nand3b_1_1.Y VDD 0.60582f
C11473 sg13cmos5l_buf_1_0.A a_21466_7642# 0.03397f
C11474 sg13cmos5l_buf_1_21.A sg13cmos5l_a21o_1_0.A2 0.02026f
C11475 sg13cmos5l_dfrbpq_1_7.D a_20294_10386# 0.18112f
C11476 sg13cmos5l_inv_1_15.A sg13cmos5l_inv_1_4.Y 0.02512f
C11477 sg13cmos5l_o21ai_1_20.B1 sg13cmos5l_dfrbpq_1_24.RESET_B 0.07898f
C11478 a_12420_19024# VDD 0.07797f
C11479 a_4220_17488# VDD 0.01784f
C11480 sg13cmos5l_o21ai_1_18.A2 sg13cmos5l_o21ai_1_8.B1 0.01435f
C11481 sg13cmos5l_a21oi_1_0.A2 VDD 1.0901f
C11482 sg13cmos5l_dfrbpq_1_13.Q a_11656_5498# 0.02677f
C11483 sg13cmos5l_inv_1_1.Y sg13cmos5l_inv_1_17.Y 0.21041f
C11484 sg13cmos5l_nand3_1_2.A a_15488_12342# 0.0268f
C11485 a_19720_3176# sample 0.0635f
C11486 sg13cmos5l_a21oi_1_27.B1 sg13cmos5l_buf_1_24.A 0.02266f
C11487 sg13cmos5l_dfrbpq_1_18.Q sg13cmos5l_buf_1_21.A 0.01435f
C11488 sg13cmos5l_or4_1_0.C sg13cmos5l_nand2b_1_5.Y 0.01141f
C11489 sg13cmos5l_buf_1_13.X a_17604_8861# 0.02233f
C11490 a_20294_10386# a_20580_9952# 0.26205f
C11491 sg13cmos5l_buf_1_63.A code2 0.02359f
C11492 a_21911_18649# a_21866_18416# 0.18486f
C11493 a_21084_18222# a_20974_18258# 0.25046f
C11494 sg13cmos5l_buf_1_7.X a_20207_5773# 0.12909f
C11495 sg13cmos5l_nand2_1_1.A a_19830_12278# 0.03177f
C11496 sg13cmos5l_buf_1_0.A a_18634_7897# 0.01456f
C11497 sg13cmos5l_buf_1_16.A sg13cmos5l_inv_1_12.Y 0.02767f
C11498 sg13cmos5l_inv_1_14.Y VDD 0.43012f
C11499 sg13cmos5l_dfrbpq_1_13.RESET_B a_7144_10034# 0.01304f
C11500 sg13cmos5l_buf_1_15.A bp0 0.02585f
C11501 sg13cmos5l_buf_1_4.A sg13cmos5l_dlygate4sd3_1_4.A 0.02525f
C11502 a_18928_7166# VDD 0.13552f
C11503 a_3975_16964# a_3996_16710# 0.20754f
C11504 a_4127_17016# a_4917_16904# 0.02241f
C11505 sg13cmos5l_buf_1_15.A a_9185_18448# 0.05937f
C11506 sg13cmos5l_inv_1_2.A a_19467_5423# 0.08319f
C11507 a_7050_9484# sg13cmos5l_nor3_1_2.C 0.01147f
C11508 a_19745_15424# VDD 0.2093f
C11509 sg13cmos5l_dfrbpq_1_9.D sg13cmos5l_buf_1_0.A 0.01703f
C11510 a_7238_19458# VDD 0.52277f
C11511 sg13cmos5l_inv_1_9.Y a_15607_9150# 0.04559f
C11512 sg13cmos5l_dfrbpq_1_8.D bp4 0.21626f
C11513 sg13cmos5l_o21ai_1_1.B1 sg13cmos5l_o21ai_1_3.A2 0.16816f
C11514 sg13cmos5l_a21oi_1_3.Y sg13cmos5l_buf_1_0.A 0.01013f
C11515 sg13cmos5l_buf_1_16.A sg13cmos5l_inv_1_24.A 0.01905f
C11516 sg13cmos5l_buf_1_53.A a_19630_15423# 0.01105f
C11517 sg13cmos5l_o21ai_1_9.A2 a_5686_16374# 0.06185f
C11518 sg13cmos5l_o21ai_1_1.B1 a_14746_9912# 0.04979f
C11519 sg13cmos5l_inv_1_9.Y a_15480_8752# 0.08679f
C11520 sg13cmos5l_a21oi_1_19.Y sg13cmos5l_buf_1_16.A 0.66147f
C11521 sg13cmos5l_nand2_1_12.Y sg13cmos5l_nand2_1_9.Y 0.07608f
C11522 sg13cmos5l_nand2_1_18.A sg13cmos5l_buf_1_14.A 0.01005f
C11523 sg13cmos5l_nor4_1_4.C a_10696_15272# 0.0261f
C11524 a_16742_15234# VDD 0.52281f
C11525 sg13cmos5l_buf_1_66.X sg13cmos5l_o21ai_1_23.A2 0.13873f
C11526 sg13cmos5l_nor2_1_7.Y sg13cmos5l_o21ai_1_5.A2 0.08162f
C11527 sg13cmos5l_inv_1_1.A sg13cmos5l_inv_1_16.A 0.03637f
C11528 sg13cmos5l_nand2_1_0.A a_12902_8436# 0.05828f
C11529 sg13cmos5l_a21oi_1_4.A2 sg13cmos5l_nor3_1_7.Y 0.02484f
C11530 sg13cmos5l_buf_1_8.A bp5 0.03546f
C11531 sg13cmos5l_nor2b_1_0.B_N a_12430_9375# 0.01553f
C11532 a_12381_13912# sg13cmos5l_nand2_1_18.A 0.07125f
C11533 a_12896_13897# a_13015_13686# 0.09257f
C11534 sg13cmos5l_inv_1_17.A a_22096_8678# 0.04079f
C11535 sg13cmos5l_inv_1_14.Y bp6 0.03203f
C11536 sg13cmos5l_inv_1_8.A sg13cmos5l_a21oi_1_9.A2 0.03287f
C11537 sg13cmos5l_a21oi_1_9.A2 a_15905_7190# 0.01785f
C11538 sg13cmos5l_buf_1_4.A bp9 0.01856f
C11539 sg13cmos5l_dfrbpq_1_28.RESET_B a_18287_15311# 0.12532f
C11540 sg13cmos5l_dfrbpq_1_8.D a_20868_7349# 0.01486f
C11541 sg13cmos5l_a21oi_1_1.A2 sg13cmos5l_inv_1_4.Y 0.02452f
C11542 sg13cmos5l_nand3_1_5.Y sg13cmos5l_nand3b_1_1.C 0.22735f
C11543 sg13cmos5l_a22oi_1_0.B2 a_13198_9228# 0.05497f
C11544 sg13cmos5l_dlygate4sd3_1_28.A a_20580_6928# 0.01882f
C11545 sg13cmos5l_inv_1_18.A sg13cmos5l_dlygate4sd3_1_15.X 0.09153f
C11546 sg13cmos5l_nand3b_1_0.C sg13cmos5l_a22oi_1_0.B2 0.01198f
C11547 sg13cmos5l_o21ai_1_21.A2 a_4700_17488# 0.01037f
C11548 sg13cmos5l_buf_1_1.A a_22096_11702# 0.02421f
C11549 a_20554_4873# a_20580_4968# 0.24169f
C11550 sg13cmos5l_a21oi_1_9.A2 a_13434_6887# 0.22993f
C11551 sg13cmos5l_buf_1_63.A sg13cmos5l_buf_1_24.A 0.54692f
C11552 sg13cmos5l_buf_1_21.A sg13cmos5l_nand2_1_19.Y 0.68406f
C11553 sg13cmos5l_o21ai_1_23.A2 VDD 0.28439f
C11554 sg13cmos5l_nand4_1_18.B a_11674_12936# 0.01201f
C11555 a_13304_18262# VDD 0.26678f
C11556 a_7750_9508# VDD 0.19593f
C11557 sg13cmos5l_nand4_1_3.B sg13cmos5l_a21o_1_2.A1 0.02203f
C11558 sg13cmos5l_buf_1_9.A a_20580_8440# 0.01916f
C11559 sg13cmos5l_nand3b_1_3.C a_7073_16936# 0.0292f
C11560 sg13cmos5l_buf_1_63.A a_19361_19960# 0.01221f
C11561 sg13cmos5l_o21ai_1_20.A1 sg13cmos5l_o21ai_1_21.Y 0.06686f
C11562 sg13cmos5l_nor2_1_6.Y a_5782_15230# 0.04803f
C11563 a_2156_19734# comp 0.01953f
C11564 a_19534_4839# sg13cmos5l_buf_1_6.A 0.10673f
C11565 sg13cmos5l_dfrbpq_1_28.RESET_B a_21084_16710# 0.26304f
C11566 a_13679_19381# VDD 0.17199f
C11567 sg13cmos5l_buf_1_21.A a_14761_15238# 0.18023f
C11568 sg13cmos5l_buf_1_15.A sg13cmos5l_nand4_1_16.D 0.026f
C11569 sg13cmos5l_inv_1_32.Y sg13cmos5l_inv_1_36.A 0.05834f
C11570 sg13cmos5l_dlygate4sd3_1_13.A sg13cmos5l_nand2_1_13.Y 0.01916f
C11571 sg13cmos5l_dfrbpq_1_30.Q a_19534_16263# 0.01207f
C11572 sg13cmos5l_a21o_1_1.A2 a_9562_9190# 0.01924f
C11573 a_10878_7180# sg13cmos5l_a21oi_1_9.A1 0.14846f
C11574 a_4168_19902# VDD 0.16023f
C11575 sg13cmos5l_buf_1_9.A sg13cmos5l_inv_1_5.A 0.03629f
C11576 sg13cmos5l_nand3_1_0.B a_16188_9150# 0.0177f
C11577 sg13cmos5l_buf_1_9.A a_17030_8874# 0.01353f
C11578 sg13cmos5l_inv_1_15.A sg13cmos5l_nand3_1_0.Y 0.16946f
C11579 a_20580_9952# a_20868_10373# 0.24435f
C11580 sg13cmos5l_buf_1_9.A a_16184_8477# 0.01159f
C11581 sg13cmos5l_dfrbpq_1_13.RESET_B a_8785_10309# 0.01094f
C11582 sg13cmos5l_dlygate4sd3_1_77.A a_18970_14448# 0.28816f
C11583 sg13cmos5l_nor2_1_16.Y sg13cmos5l_buf_1_59.A 0.18863f
C11584 sg13cmos5l_dfrbpq_1_28.RESET_B sg13cmos5l_dlygate4sd3_1_76.X 0.06246f
C11585 sg13cmos5l_buf_1_63.A sg13cmos5l_nor2_1_15.Y 0.05768f
C11586 sg13cmos5l_inv_1_5.A a_17412_6928# 0.06547f
C11587 sg13cmos5l_a21oi_1_26.A1 bn4 0.02275f
C11588 sg13cmos5l_inv_1_2.A sg13cmos5l_dlygate4sd3_1_4.A 0.02389f
C11589 sg13cmos5l_nand2_1_12.A sg13cmos5l_nor4_1_2.Y 0.10325f
C11590 sg13cmos5l_buf_1_0.A a_15935_7944# 0.01417f
C11591 a_7073_19960# sg13cmos5l_o21ai_1_7.Y 0.02304f
C11592 sg13cmos5l_buf_1_25.A bn4 0.03511f
C11593 a_7736_7678# a_8006_7678# 0.18796f
C11594 sg13cmos5l_a21oi_1_9.B1 a_11274_5412# 0.01209f
C11595 sg13cmos5l_buf_1_0.A sg13cmos5l_dfrbpq_1_0.D 0.3527f
C11596 sg13cmos5l_a21oi_1_2.B1 sg13cmos5l_buf_1_13.A 0.33711f
C11597 a_13478_11460# VDD 0.20784f
C11598 sg13cmos5l_inv_1_14.Y a_17615_5773# 0.01117f
C11599 sg13cmos5l_buf_1_63.A sg13cmos5l_o21ai_1_17.B1 0.12786f
C11600 a_15488_9361# VDD 0.27673f
C11601 sg13cmos5l_a21oi_1_26.Y bn4 0.01865f
C11602 sg13cmos5l_dfrbpq_1_15.Q clk 0.08777f
C11603 sg13cmos5l_inv_1_36.Y a_15208_11546# 0.02509f
C11604 a_5541_9165# a_5412_9199# 0.01562f
C11605 sg13cmos5l_buf_1_43.X a_16002_16754# 0.01056f
C11606 a_15243_6284# VDD 0.20559f
C11607 a_19173_17519# a_19035_16750# 0.01569f
C11608 a_17717_19020# VDD 0.17001f
C11609 sg13cmos5l_dfrbpq_1_13.CLK sg13cmos5l_o21ai_1_0.B1 0.09755f
C11610 sg13cmos5l_nand2_1_1.A sg13cmos5l_inv_1_16.Y 0.01944f
C11611 sg13cmos5l_nand4_1_18.B sg13cmos5l_nand3_1_0.B 0.02414f
C11612 sg13cmos5l_nand2b_1_1.A_N sg13cmos5l_a22oi_1_0.B2 0.02409f
C11613 sg13cmos5l_a21oi_1_26.A1 VDD 0.32102f
C11614 sg13cmos5l_inv_1_36.A a_5036_13686# 0.01169f
C11615 sg13cmos5l_nand2b_1_0.B sg13cmos5l_nand3_1_0.A 0.09378f
C11616 sg13cmos5l_dfrbpq_1_13.CLK a_11840_9389# 0.01419f
C11617 sg13cmos5l_dlygate4sd3_1_28.A a_21099_6935# 0.01469f
C11618 sg13cmos5l_buf_1_13.A sg13cmos5l_inv_1_5.Y 0.0119f
C11619 sg13cmos5l_nand3_1_8.Y bn7 0.03515f
C11620 sg13cmos5l_buf_1_25.A VDD 0.38126f
C11621 sg13cmos5l_buf_1_3.A sg13cmos5l_inv_1_0.A 0.03164f
C11622 sg13cmos5l_dfrbpq_1_13.CLK sg13cmos5l_a21oi_1_11.Y 0.04617f
C11623 a_20580_4968# a_21839_4727# 0.01412f
C11624 sg13cmos5l_nand2_1_0.A sg13cmos5l_or2_1_1.X 0.02952f
C11625 sg13cmos5l_nand2b_1_3.B a_16186_6888# 0.30722f
C11626 sg13cmos5l_nand4_1_1.B sg13cmos5l_mux2_1_0.S 0.02298f
C11627 a_16170_20068# sg13cmos5l_dlygate4sd3_1_82.X 0.01976f
C11628 a_16193_19286# VDD 0.20207f
C11629 sg13cmos5l_nor2b_1_0.B_N sg13cmos5l_o21ai_1_0.A2 0.02832f
C11630 a_21063_16964# VDD 0.20459f
C11631 sg13cmos5l_dfrbpq_1_13.CLK sg13cmos5l_a21oi_1_9.A1 0.57103f
C11632 a_21761_15424# bn6 0.04845f
C11633 sg13cmos5l_buf_1_13.A a_14133_5459# 0.19735f
C11634 sg13cmos5l_a21oi_1_2.B1 bp7 0.02026f
C11635 sg13cmos5l_a21oi_1_0.A2 a_18374_7674# 0.05724f
C11636 sg13cmos5l_dfrbpq_1_13.CLK sg13cmos5l_nor3_1_1.Y 0.10008f
C11637 a_7173_11471# VDD 0.24657f
C11638 sg13cmos5l_a21oi_1_26.Y VDD 0.21713f
C11639 sg13cmos5l_buf_1_7.X a_20294_7362# 0.07758f
C11640 sg13cmos5l_o21ai_1_23.B1 busy 0.02196f
C11641 a_20207_5773# bp4 0.01171f
C11642 sg13cmos5l_nand2_1_6.A a_12957_7194# 0.18657f
C11643 sg13cmos5l_dlygate4sd3_1_4.A a_21256_3900# 0.01418f
C11644 sg13cmos5l_dfrbpq_1_28.RESET_B a_21911_17137# 0.08976f
C11645 sg13cmos5l_dfrbpq_1_24.RESET_B a_5604_12976# 0.26514f
C11646 sg13cmos5l_o21ai_1_23.B1 sg13cmos5l_nand4_1_7.B 0.18317f
C11647 sg13cmos5l_buf_1_45.X a_17355_19892# 0.27963f
C11648 sg13cmos5l_nand3_1_2.Y a_12814_13239# 0.02531f
C11649 a_18209_9376# a_18490_9154# 0.18796f
C11650 sg13cmos5l_nand4_1_18.B sg13cmos5l_a21oi_1_27.A2 0.01917f
C11651 sg13cmos5l_dfrbpq_1_13.CLK sg13cmos5l_a21oi_1_9.Y 0.06582f
C11652 sg13cmos5l_nand4_1_1.A sg13cmos5l_nor3_1_7.Y 0.01783f
C11653 a_19829_14020# VDD 0.18247f
C11654 sg13cmos5l_buf_1_57.A code1 0.37468f
C11655 sg13cmos5l_dlygate4sd3_1_29.X a_17412_6928# 0.02033f
C11656 sg13cmos5l_a21oi_1_4.A1 sg13cmos5l_nand3_1_2.A 0.17285f
C11657 sg13cmos5l_nand4_1_1.A sg13cmos5l_a21oi_1_16.A2 0.22017f
C11658 sg13cmos5l_buf_1_45.X sg13cmos5l_a21oi_1_4.A1 0.02294f
C11659 a_5578_12940# a_6021_12983# 0.02241f
C11660 sg13cmos5l_nand4_1_18.D sg13cmos5l_inv_1_16.A 0.03374f
C11661 sg13cmos5l_buf_1_13.X a_20294_10386# 0.079f
C11662 sg13cmos5l_dfrbpq_1_47.Q a_12512_5699# 0.07596f
C11663 a_16172_14448# a_16469_14484# 0.03494f
C11664 sg13cmos5l_inv_1_16.Y sg13cmos5l_nand4_1_1.A 0.01738f
C11665 a_4127_17016# a_3886_16746# 0.01058f
C11666 sg13cmos5l_buf_1_66.X sg13cmos5l_o21ai_1_10.B1 0.01307f
C11667 a_3975_16964# a_4778_16904# 0.07823f
C11668 sg13cmos5l_buf_1_16.A sg13cmos5l_dlygate4sd3_1_18.A 0.13917f
C11669 sg13cmos5l_inv_1_9.Y a_16167_9404# 0.01194f
C11670 sg13cmos5l_nand4_1_3.B a_13727_13992# 0.01416f
C11671 sg13cmos5l_o21ai_1_22.Y sg13cmos5l_or4_1_1.X 0.01772f
C11672 sg13cmos5l_buf_1_0.A a_16725_7832# 0.01044f
C11673 a_4455_18476# VDD 0.20656f
C11674 sg13cmos5l_inv_1_31.A a_16197_18237# 0.20571f
C11675 sg13cmos5l_a21oi_1_13.Y VDD 0.30448f
C11676 sg13cmos5l_inv_1_15.Y sg13cmos5l_buf_1_0.A 0.03149f
C11677 sg13cmos5l_a21oi_1_3.A2 sg13cmos5l_inv_1_20.Y 0.25156f
C11678 sg13cmos5l_a21oi_1_2.B1 sg13cmos5l_a21oi_1_0.Y 0.13363f
C11679 a_20294_6166# VDD 0.2068f
C11680 sg13cmos5l_inv_1_31.A sg13cmos5l_buf_1_24.A 0.02086f
C11681 sg13cmos5l_buf_8_2.A sg13cmos5l_buf_1_10.A 0.61612f
C11682 sg13cmos5l_inv_1_36.A sg13cmos5l_nand2_1_13.A 0.04198f
C11683 sg13cmos5l_o21ai_1_18.B1 sg13cmos5l_buf_1_45.X 0.01059f
C11684 sg13cmos5l_buf_1_53.A sg13cmos5l_inv_1_24.A 3.06376f
C11685 sg13cmos5l_dlygate4sd3_1_25.A a_16838_9948# 0.01808f
C11686 sg13cmos5l_inv_1_15.A sg13cmos5l_inv_1_1.Y 0.03161f
C11687 sg13cmos5l_buf_1_0.A a_20113_5773# 0.01487f
C11688 sg13cmos5l_a21oi_1_2.B1 sg13cmos5l_buf_1_5.A 0.03985f
C11689 a_18382_6351# VDD 0.15966f
C11690 sg13cmos5l_inv_1_24.A a_14152_14484# 0.02493f
C11691 sg13cmos5l_o21ai_1_10.B1 VDD 0.21789f
C11692 sg13cmos5l_nand4_1_18.B sg13cmos5l_inv_1_16.A 0.01072f
C11693 sg13cmos5l_buf_1_54.A sg13cmos5l_nand4_1_16.D 0.24304f
C11694 sg13cmos5l_buf_1_45.X sg13cmos5l_dfrbpq_1_28.RESET_B 0.03383f
C11695 sg13cmos5l_buf_1_15.A a_9040_19262# 0.02403f
C11696 sg13cmos5l_inv_1_8.A a_12426_9948# 0.05151f
C11697 sg13cmos5l_inv_1_17.A sg13cmos5l_a21oi_1_6.Y 0.03132f
C11698 a_21099_9959# bp2 0.02935f
C11699 sg13cmos5l_or4_1_1.X sg13cmos5l_nand2_1_9.Y 0.08039f
C11700 sg13cmos5l_nor2_1_0.Y sg13cmos5l_dlygate4sd3_1_8.X 0.17134f
C11701 sg13cmos5l_buf_1_13.A a_16773_5423# 0.01421f
C11702 a_21839_4727# a_22506_4948# 0.09257f
C11703 a_20997_4629# a_21745_4727# 0.01058f
C11704 sg13cmos5l_dfrbpq_1_41.CLK a_10980_18576# 0.05059f
C11705 sg13cmos5l_a21oi_1_4.A1 sg13cmos5l_nand3_1_2.Y 0.02081f
C11706 a_9062_5850# a_9765_5423# 0.02431f
C11707 sg13cmos5l_a21oi_1_2.Y sg13cmos5l_inv_1_14.Y 0.0128f
C11708 a_8682_11460# VDD 0.27769f
C11709 a_13574_18262# VDD 0.20908f
C11710 sg13cmos5l_buf_1_15.A sg13cmos5l_nor2b_1_2.Y 0.16565f
C11711 sg13cmos5l_buf_1_24.A sg13cmos5l_nand4_1_8.B 0.02142f
C11712 sg13cmos5l_dfrbpq_1_24.RESET_B a_6863_13333# 0.10886f
C11713 sg13cmos5l_inv_1_12.A a_20398_13239# 0.01059f
C11714 sg13cmos5l_dfrbpq_1_41.CLK code1 0.01368f
C11715 sg13cmos5l_inv_1_32.Y busy 0.17466f
C11716 sg13cmos5l_dfrbpq_1_41.CLK sg13cmos5l_a21oi_1_24.A1 1.36522f
C11717 sg13cmos5l_buf_8_2.A a_21745_10309# 0.01581f
C11718 sg13cmos5l_nand2_1_15.B a_13596_13686# 0.05878f
C11719 a_20294_7362# a_20554_6892# 0.45119f
C11720 sg13cmos5l_dfrbpq_1_5.CLK sg13cmos5l_inv_1_33.Y 0.05825f
C11721 sg13cmos5l_inv_1_32.Y sg13cmos5l_nand4_1_7.B 0.01417f
C11722 sg13cmos5l_buf_1_45.X bn1 0.02396f
C11723 a_14744_19061# VDD 0.2601f
C11724 sg13cmos5l_dfrbpq_1_37.D bn5 0.07461f
C11725 sg13cmos5l_mux2_1_1.A1 a_10461_11730# 0.11549f
C11726 sg13cmos5l_nand3_1_0.A sg13cmos5l_nand2b_1_3.B 0.15797f
C11727 sg13cmos5l_o21ai_1_14.A1 sg13cmos5l_nand2_1_11.B 0.01327f
C11728 sg13cmos5l_nor3_1_7.Y a_17604_11464# 0.01647f
C11729 a_8206_9375# VDD 0.15782f
C11730 sg13cmos5l_o21ai_1_7.A2 sg13cmos5l_dfrbpq_1_19.CLK 0.35369f
C11731 sg13cmos5l_inv_1_0.Y a_18689_4676# 0.01158f
C11732 sg13cmos5l_a21oi_1_2.A2 sg13cmos5l_inv_1_0.Y 0.01524f
C11733 sg13cmos5l_inv_1_7.Y VDD 0.25084f
C11734 sg13cmos5l_o21ai_1_5.A1 a_12812_15960# 0.04219f
C11735 a_6490_19738# VDD 0.25703f
C11736 sg13cmos5l_o21ai_1_7.A2 sg13cmos5l_nor2_1_7.Y 0.0473f
C11737 sg13cmos5l_a21oi_1_0.A2 sg13cmos5l_inv_1_6.Y 0.01807f
C11738 sg13cmos5l_nor3_1_2.B sg13cmos5l_buf_1_10.A 0.04817f
C11739 sg13cmos5l_buf_1_15.A a_21084_16710# 0.01498f
C11740 sg13cmos5l_buf_1_53.A bn0 0.04575f
C11741 sg13cmos5l_nand4_1_6.B valid 0.05184f
C11742 sg13cmos5l_inv_1_32.Y sg13cmos5l_nand4_1_3.B 0.02137f
C11743 a_14920_14484# code0 0.1544f
C11744 a_5604_12976# a_6863_13333# 0.01412f
C11745 sg13cmos5l_buf_1_7.X sg13cmos5l_buf_1_0.A 0.59548f
C11746 sg13cmos5l_dfrbpq_1_24.RESET_B a_5999_14845# 0.10879f
C11747 sg13cmos5l_nor4_1_4.C sg13cmos5l_buf_1_57.A 1.16269f
C11748 sg13cmos5l_inv_1_1.Y sg13cmos5l_a21oi_1_1.A2 1.15402f
C11749 sg13cmos5l_inv_1_12.Y sg13cmos5l_a21oi_1_2.B1 0.03189f
C11750 sg13cmos5l_dfrbpq_1_28.D VDD 0.24389f
C11751 sg13cmos5l_inv_1_14.Y sg13cmos5l_inv_1_6.Y 0.01715f
C11752 a_8602_9154# sg13cmos5l_o21ai_1_6.Y 0.27645f
C11753 sg13cmos5l_inv_1_16.Y a_17604_11464# 0.01512f
C11754 sg13cmos5l_nand4_1_3.D sg13cmos5l_inv_1_12.Y 0.0126f
C11755 sg13cmos5l_and2_1_5.X sg13cmos5l_nor3_1_7.Y 0.33599f
C11756 sg13cmos5l_buf_1_15.A a_5312_13854# 0.03281f
C11757 sg13cmos5l_a21oi_1_0.A2 a_18662_5850# 0.04914f
C11758 sg13cmos5l_o21ai_1_12.Y a_7048_16082# 0.04865f
C11759 a_8411_12252# a_8637_12508# 0.02749f
C11760 sg13cmos5l_inv_1_31.A a_18104_18262# 0.01841f
C11761 sg13cmos5l_inv_1_15.Y sg13cmos5l_a21oi_1_20.Y 0.0205f
C11762 sg13cmos5l_nand2_1_3.Y a_8061_7194# 0.0112f
C11763 sg13cmos5l_o21ai_1_13.B1 sg13cmos5l_buf_1_47.X 0.041f
C11764 sg13cmos5l_inv_1_15.Y sg13cmos5l_dlygate4sd3_1_25.A 0.03307f
C11765 sg13cmos5l_dfrbpq_1_28.RESET_B sg13cmos5l_buf_1_42.A 0.15045f
C11766 a_15820_9186# VDD 0.13606f
C11767 sg13cmos5l_buf_1_8.A a_20874_5412# 0.06109f
C11768 sg13cmos5l_o21ai_1_1.B1 sg13cmos5l_dlygate4sd3_1_9.A 0.03988f
C11769 sg13cmos5l_buf_1_54.A a_17445_15213# 0.04779f
C11770 a_14253_13320# VDD 0.29405f
C11771 a_15780_18576# bn4 0.01081f
C11772 sg13cmos5l_a21oi_1_4.A1 sg13cmos5l_nand3_1_1.Y 0.01331f
C11773 sg13cmos5l_inv_1_7.Y bp6 0.0255f
C11774 a_19246_6351# VDD 0.16085f
C11775 a_21462_19044# VDD 0.16118f
C11776 sg13cmos5l_nand4_1_18.B sg13cmos5l_nor4_1_1.D 0.09361f
C11777 a_14542_7191# a_14657_7190# 0.3854f
C11778 sg13cmos5l_nand2_1_0.A a_13198_9228# 0.02157f
C11779 sg13cmos5l_dfrbpq_1_15.CLK sg13cmos5l_dfrbpq_1_45.D 0.46211f
C11780 a_22522_17472# sg13cmos5l_dfrbpq_1_29.Q 0.2754f
C11781 sg13cmos5l_nand3_1_2.Y bn1 0.21147f
C11782 a_20294_7362# bp4 0.05381f
C11783 sg13cmos5l_nand3b_1_0.C sg13cmos5l_nand2_1_0.A 0.63715f
C11784 sg13cmos5l_o21ai_1_21.Y a_3996_16710# 0.01856f
C11785 sg13cmos5l_buf_1_1.A bp5 0.02971f
C11786 sg13cmos5l_inv_1_18.A sg13cmos5l_buf_1_14.A 0.04536f
C11787 a_22506_4948# sg13cmos5l_dlygate4sd3_1_0.A 0.08328f
C11788 sg13cmos5l_inv_1_36.Y a_14446_11727# 0.02109f
C11789 sg13cmos5l_dfrbpq_1_41.CLK a_12906_18556# 0.01005f
C11790 sg13cmos5l_inv_1_17.A sg13cmos5l_buf_1_7.X 0.05537f
C11791 sg13cmos5l_o21ai_1_7.B1 a_7090_15230# 0.0302f
C11792 sg13cmos5l_inv_1_20.Y a_11648_10830# 0.01054f
C11793 sg13cmos5l_a22oi_1_0.B2 VDD 0.92745f
C11794 a_9765_5423# a_9867_5423# 0.3643f
C11795 a_12430_9375# a_12224_9318# 0.01604f
C11796 a_10124_11424# VDD 0.18857f
C11797 sg13cmos5l_nand2b_1_1.A_N a_9394_8814# 0.01107f
C11798 sg13cmos5l_dfrbpq_1_34.Q a_16550_19770# 0.05053f
C11799 a_15780_18576# VDD 0.07315f
C11800 sg13cmos5l_a21oi_1_4.A2 sg13cmos5l_a21oi_1_3.A2 0.09166f
C11801 sg13cmos5l_buf_1_16.A sg13cmos5l_buf_1_10.A 0.12594f
C11802 sg13cmos5l_dlygate4sd3_1_64.X sg13cmos5l_o21ai_1_7.B1 0.03171f
C11803 sg13cmos5l_inv_1_12.A a_21531_13342# 0.01315f
C11804 sg13cmos5l_dlygate4sd3_1_50.X sg13cmos5l_o21ai_1_21.B1 0.02527f
C11805 sg13cmos5l_nand2_1_11.B sg13cmos5l_o21ai_1_10.A2 0.01782f
C11806 a_1294_9375# a_1409_9376# 0.3854f
C11807 sg13cmos5l_a22oi_1_2.Y sg13cmos5l_and4_1_0.D 0.0463f
C11808 sg13cmos5l_inv_1_12.A a_20580_12528# 0.03621f
C11809 a_20974_19959# VDD 0.15963f
C11810 a_20294_7362# a_20868_7349# 0.18486f
C11811 sg13cmos5l_inv_1_16.A sg13cmos5l_a21oi_1_13.A2 0.03156f
C11812 sg13cmos5l_nor2b_1_2.Y sg13cmos5l_a21oi_1_9.A2 0.11019f
C11813 sg13cmos5l_a21oi_1_14.Y sg13cmos5l_inv_1_17.A 0.02313f
C11814 sg13cmos5l_a21oi_1_0.A2 sg13cmos5l_inv_1_11.Y 0.0412f
C11815 sg13cmos5l_inv_1_15.Y bp0 0.02308f
C11816 sg13cmos5l_buf_1_57.A sg13cmos5l_o21ai_1_28.B1 0.09306f
C11817 a_22030_19287# sg13cmos5l_inv_1_25.Y 0.01171f
C11818 sg13cmos5l_nand4_1_18.B sg13cmos5l_inv_1_36.Y 0.01416f
C11819 sg13cmos5l_nor4_1_0.C sg13cmos5l_nand2b_1_3.Y 0.20457f
C11820 sg13cmos5l_buf_1_1.A a_21099_8447# 0.018f
C11821 sg13cmos5l_nor3_1_6.Y a_19544_14850# 0.01127f
C11822 a_21099_13844# VDD 0.20451f
C11823 sg13cmos5l_o21ai_1_25.Y bn4 0.02152f
C11824 a_7120_13214# a_7530_12972# 0.07015f
C11825 sg13cmos5l_nand4_1_5.D a_18785_16262# 0.02042f
C11826 sg13cmos5l_buf_1_9.A a_20294_10386# 0.0317f
C11827 sg13cmos5l_nand4_1_3.B sg13cmos5l_inv_1_12.A 0.06128f
C11828 sg13cmos5l_nand2_1_9.Y bn3 0.01678f
C11829 sg13cmos5l_nor2_1_2.B sg13cmos5l_nand2b_1_3.Y 0.01949f
C11830 sg13cmos5l_nand3b_1_1.Y sg13cmos5l_o21ai_1_8.B1 0.42588f
C11831 bp5 bn9 0.28143f
C11832 sg13cmos5l_buf_1_63.A sg13cmos5l_dlygate4sd3_1_82.X 0.03633f
C11833 a_15041_16936# VDD 0.20619f
C11834 sg13cmos5l_a21oi_1_20.A2 bn6 0.01684f
C11835 sg13cmos5l_inv_1_3.Y a_17386_6892# 0.03293f
C11836 sg13cmos5l_inv_1_1.Y sg13cmos5l_dlygate4sd3_1_76.A 0.02115f
C11837 sg13cmos5l_nor2_1_10.Y sg13cmos5l_o21ai_1_5.A1 0.06232f
C11838 a_13690_16714# VDD 0.28763f
C11839 sg13cmos5l_inv_1_1.A bp5 0.24455f
C11840 sg13cmos5l_dlygate4sd3_1_13.A VDD 0.39374f
C11841 sg13cmos5l_a21oi_1_3.A2 a_17290_8404# 0.02698f
C11842 sg13cmos5l_dlygate4sd3_1_38.X a_7750_9508# 0.04622f
C11843 sg13cmos5l_buf_1_10.A sg13cmos5l_dlygate4sd3_1_0.A 0.04177f
C11844 sg13cmos5l_a21oi_1_18.B1 a_21839_14845# 0.01378f
C11845 a_18094_9375# VDD 0.16018f
C11846 a_11368_16878# VDD 0.15073f
C11847 sg13cmos5l_buf_1_24.A sg13cmos5l_inv_1_25.Y 0.06891f
C11848 sg13cmos5l_buf_1_13.A a_17316_8440# 0.05693f
C11849 sg13cmos5l_nand2_1_1.A sg13cmos5l_a21oi_1_7.A2 0.02213f
C11850 sg13cmos5l_o21ai_1_25.Y VDD 0.5295f
C11851 sg13cmos5l_nand2b_1_1.A_N sg13cmos5l_nand2_1_0.A 0.03902f
C11852 sg13cmos5l_nor3_1_2.B a_5124_9504# 0.01932f
C11853 sg13cmos5l_dfrbpq_1_38.Q sg13cmos5l_nand4_1_1.B 0.02655f
C11854 sg13cmos5l_a21oi_1_18.B1 a_16763_17508# 0.02645f
C11855 sg13cmos5l_nand4_1_3.B sg13cmos5l_nand2_1_13.A 0.01387f
C11856 sg13cmos5l_and2_1_3.X a_16840_12972# 0.22123f
C11857 a_12814_19959# VDD 0.16554f
C11858 sg13cmos5l_dfrbpq_1_19.CLK sg13cmos5l_nand3_1_5.Y 0.03412f
C11859 sg13cmos5l_nor2_1_10.Y a_10774_17886# 0.01616f
C11860 sg13cmos5l_o21ai_1_1.B1 a_11840_9389# 0.11823f
C11861 sg13cmos5l_nand2_1_1.A sg13cmos5l_a21oi_1_3.A2 0.21943f
C11862 sg13cmos5l_nand3_1_5.Y sg13cmos5l_nor2_1_7.Y 0.13607f
C11863 sg13cmos5l_buf_1_16.A a_17051_15996# 0.01542f
C11864 sg13cmos5l_o21ai_1_11.Y a_6760_17594# 0.04475f
C11865 sg13cmos5l_o21ai_1_13.B1 sg13cmos5l_dlygate4sd3_1_54.A 0.05057f
C11866 sg13cmos5l_nand4_1_12.Y sg13cmos5l_buf_1_54.A 0.02895f
C11867 a_6256_14726# a_6666_14484# 0.07015f
C11868 sg13cmos5l_buf_1_45.X a_15784_15272# 0.19356f
C11869 a_14061_8784# VDD 0.29248f
C11870 sg13cmos5l_dlygate4sd3_1_50.A VDD 0.6565f
C11871 sg13cmos5l_inv_1_15.Y sg13cmos5l_nand4_1_16.D 0.03027f
C11872 a_3800_19061# VDD 0.28364f
C11873 sg13cmos5l_buf_1_15.A sg13cmos5l_buf_1_45.X 0.70445f
C11874 sg13cmos5l_nand4_1_18.B sg13cmos5l_nand2_1_1.Y 0.01494f
C11875 sg13cmos5l_buf_1_15.A sg13cmos5l_nand3_1_2.A 0.98579f
C11876 a_10864_5654# a_11274_5412# 0.07015f
C11877 a_12826_9154# a_13198_9228# 0.03903f
C11878 a_10990_8052# VDD 0.01276f
C11879 a_13014_8460# VDD 0.16949f
C11880 sg13cmos5l_o21ai_1_7.A2 a_7524_19024# 0.04803f
C11881 sg13cmos5l_nand2b_1_0.B sg13cmos5l_o21ai_1_4.A1 0.02204f
C11882 a_10316_12936# a_10112_13058# 0.01689f
C11883 sg13cmos5l_nand3_1_0.A sg13cmos5l_dfrbpq_1_2.D 0.01881f
C11884 a_17706_18556# VDD 0.27679f
C11885 sg13cmos5l_buf_1_8.A a_20794_3864# 0.0521f
C11886 sg13cmos5l_a21oi_1_24.A1 bn3 0.01442f
C11887 bn4 valid 0.48248f
C11888 bn3 code1 0.02124f
C11889 a_8796_14020# VDD 0.01156f
C11890 sg13cmos5l_inv_1_17.Y a_19829_8436# 0.01946f
C11891 sg13cmos5l_buf_1_0.A bp4 0.12097f
C11892 sg13cmos5l_nand2_1_19.Y sg13cmos5l_nor2_1_3.Y 0.29792f
C11893 sg13cmos5l_a21oi_1_0.A2 a_18123_11471# 0.02357f
C11894 sg13cmos5l_inv_1_17.Y a_18660_7992# 0.0165f
C11895 sg13cmos5l_nand4_1_18.B sg13cmos5l_o21ai_1_5.A1 0.1346f
C11896 sg13cmos5l_buf_1_1.A a_21839_14845# 0.02332f
C11897 sg13cmos5l_dlygate4sd3_1_64.X sg13cmos5l_buf_8_2.A 0.02505f
C11898 sg13cmos5l_o21ai_1_0.A2 a_12224_9318# 0.01314f
C11899 sg13cmos5l_buf_1_66.X valid 0.01312f
C11900 sg13cmos5l_and4_1_0.D sg13cmos5l_nand2_1_5.Y 0.24728f
C11901 sg13cmos5l_a21o_1_2.B1 sg13cmos5l_nor4_1_1.D 0.01933f
C11902 sg13cmos5l_nand3_1_5.Y a_6394_17472# 0.01855f
C11903 sg13cmos5l_dfrbpq_1_29.D bn6 0.02871f
C11904 sg13cmos5l_a21oi_1_2.Y a_20294_6166# 0.01184f
C11905 sg13cmos5l_o21ai_1_17.B1 sg13cmos5l_inv_1_25.Y 0.43488f
C11906 a_21839_13799# VDD 0.17136f
C11907 sg13cmos5l_inv_1_1.A sg13cmos5l_dfrbpq_1_13.CLK 0.02487f
C11908 sg13cmos5l_buf_1_21.A sg13cmos5l_nand2_1_13.A 0.01758f
C11909 a_21839_10309# a_21745_10309# 0.16704f
C11910 sg13cmos5l_buf_1_24.A a_11489_17774# 0.04177f
C11911 sg13cmos5l_inv_1_16.A sg13cmos5l_a21oi_1_15.Y 0.01624f
C11912 a_7530_12972# sg13cmos5l_dfrbpq_1_45.Q 0.01687f
C11913 sg13cmos5l_buf_1_9.A a_20868_10373# 0.02692f
C11914 sg13cmos5l_buf_1_10.A sg13cmos5l_o21ai_1_0.A2 0.2408f
C11915 sg13cmos5l_nand4_1_12.Y sg13cmos5l_buf_1_26.A 0.06073f
C11916 sg13cmos5l_nand3_1_8.Y a_22523_15532# 0.05586f
C11917 sg13cmos5l_nor4_1_2.Y code1 0.01605f
C11918 sg13cmos5l_inv_1_14.Y sg13cmos5l_buf_1_4.A 0.02598f
C11919 sg13cmos5l_buf_1_7.X a_17829_6935# 0.04978f
C11920 sg13cmos5l_nand4_1_1.A sg13cmos5l_a21oi_1_7.A2 0.2416f
C11921 a_10049_9376# a_10330_9154# 0.18796f
C11922 sg13cmos5l_nor2b_1_1.A sg13cmos5l_o21ai_1_22.B1 0.09785f
C11923 sg13cmos5l_inv_1_3.Y sg13cmos5l_inv_1_14.Y 0.09732f
C11924 sg13cmos5l_o21ai_1_7.B1 sg13cmos5l_o21ai_1_5.A1 0.02647f
C11925 VDD valid 0.43035f
C11926 sg13cmos5l_dfrbpq_1_24.Q a_8898_14020# 0.02242f
C11927 sg13cmos5l_nor4_1_0.C sg13cmos5l_or2_1_1.X 0.34288f
C11928 a_19542_9254# VDD 0.1585f
C11929 sg13cmos5l_nand4_1_1.A sg13cmos5l_a21oi_1_3.A2 0.25133f
C11930 a_16170_20068# VDD 0.27709f
C11931 a_6785_18448# VDD 0.2076f
C11932 sg13cmos5l_buf_1_13.X a_19179_10820# 0.3017f
C11933 a_19328_4782# VDD 0.07878f
C11934 sg13cmos5l_a21oi_1_2.B1 sg13cmos5l_dlygate4sd3_1_18.A 0.34319f
C11935 a_18374_10698# a_19077_10677# 0.02453f
C11936 sg13cmos5l_inv_1_5.A a_16167_9404# 0.0172f
C11937 sg13cmos5l_buf_1_15.A sg13cmos5l_nand3_1_2.Y 0.04811f
C11938 sg13cmos5l_nand2_1_1.A sg13cmos5l_inv_1_17.Y 0.12721f
C11939 sg13cmos5l_and4_1_1.A a_7912_12972# 0.0172f
C11940 sg13cmos5l_buf_1_16.A sg13cmos5l_inv_1_16.A 0.10138f
C11941 sg13cmos5l_dfrbpq_1_5.CLK bn6 0.34399f
C11942 sg13cmos5l_buf_1_13.X a_17510_10702# 0.04307f
C11943 sg13cmos5l_dfrbpq_1_13.RESET_B a_7895_6553# 0.10809f
C11944 sg13cmos5l_a21oi_1_18.B1 bn6 0.01898f
C11945 sg13cmos5l_buf_1_16.A a_18970_14448# 0.02228f
C11946 sg13cmos5l_o21ai_1_9.B1 a_5312_13854# 0.02034f
C11947 sg13cmos5l_inv_1_17.A bp4 0.02498f
C11948 a_8520_8436# sg13cmos5l_o21ai_1_6.B1 0.01765f
C11949 sg13cmos5l_a21oi_1_6.A2 sg13cmos5l_inv_1_20.Y 0.01419f
C11950 sg13cmos5l_nor2b_1_1.A a_11180_15198# 0.16651f
C11951 sg13cmos5l_buf_1_66.X sg13cmos5l_nand4_1_15.B 0.05698f
C11952 sg13cmos5l_nand3_1_0.C sg13cmos5l_buf_1_13.A 0.09278f
C11953 sg13cmos5l_buf_1_15.A sg13cmos5l_buf_1_42.A 0.27396f
C11954 sg13cmos5l_nand2_1_15.Y VDD 0.31705f
C11955 sg13cmos5l_o21ai_1_19.Y sg13cmos5l_o21ai_1_14.Y 0.08505f
C11956 sg13cmos5l_dfrbpq_1_15.CLK a_7173_11471# 0.22465f
C11957 sg13cmos5l_a21oi_1_2.A2 a_16356_5416# 0.01436f
C11958 sg13cmos5l_buf_1_63.A sg13cmos5l_nand4_1_6.B 0.03264f
C11959 a_12428_12936# a_12224_13058# 0.01689f
C11960 a_7350_17532# a_7238_17508# 0.3854f
C11961 sg13cmos5l_a21oi_1_2.Y sg13cmos5l_inv_1_7.Y 0.0715f
C11962 sg13cmos5l_o21ai_1_3.Y a_15488_9361# 0.01542f
C11963 sg13cmos5l_nand2b_1_0.B a_15592_10736# 0.05807f
C11964 sg13cmos5l_o21ai_1_14.Y a_7238_17508# 0.05613f
C11965 sg13cmos5l_dfrbpq_1_28.Q a_20398_13239# 0.01806f
C11966 a_9765_5423# clk 0.01298f
C11967 sg13cmos5l_dfrbpq_1_15.Q sg13cmos5l_dlygate4sd3_1_43.X 0.0564f
C11968 a_19830_12278# sg13cmos5l_dlygate4sd3_1_71.X 0.10695f
C11969 sg13cmos5l_nor3_1_0.Y sg13cmos5l_nand2b_1_0.B 0.08215f
C11970 sg13cmos5l_nand3_1_3.Y a_11292_4658# 0.01437f
C11971 sg13cmos5l_nand4_1_15.B VDD 0.73432f
C11972 a_22096_7166# a_21839_7285# 0.23043f
C11973 sg13cmos5l_nand4_1_18.B sg13cmos5l_o21ai_1_5.A2 0.09273f
C11974 sg13cmos5l_buf_1_0.A a_20872_3176# 0.05462f
C11975 a_11670_19044# sg13cmos5l_dlygate4sd3_1_55.X 0.13601f
C11976 sg13cmos5l_inv_1_17.Y a_19919_7751# 0.04258f
C11977 sg13cmos5l_nor4_1_4.C bn3 0.19914f
C11978 sg13cmos5l_a21oi_1_0.A2 a_19048_12248# 0.0234f
C11979 sg13cmos5l_inv_1_17.A a_22042_15202# 0.05999f
C11980 sg13cmos5l_a21oi_1_25.A2 a_16840_16878# 0.02125f
C11981 a_14218_18226# a_14181_17519# 0.03558f
C11982 sg13cmos5l_o21ai_1_21.Y sg13cmos5l_dfrbpq_1_23.Q 0.01309f
C11983 sg13cmos5l_dfrbpq_1_28.RESET_B a_18486_18326# 0.02126f
C11984 sg13cmos5l_nand3_1_5.Y a_6113_17774# 0.01155f
C11985 sg13cmos5l_buf_1_1.A bn6 0.05314f
C11986 sg13cmos5l_a21oi_1_0.A2 sg13cmos5l_inv_1_2.A 0.34118f
C11987 sg13cmos5l_buf_1_15.A sg13cmos5l_nand3_1_1.Y 0.02779f
C11988 sg13cmos5l_inv_1_12.A a_22126_9375# 0.01686f
C11989 VDD bp2 0.39948f
C11990 sg13cmos5l_buf_1_1.A a_22330_10666# 0.04463f
C11991 a_7354_19738# VDD 0.25613f
C11992 sg13cmos5l_mux2_1_1.A1 a_10833_14874# 0.0719f
C11993 sg13cmos5l_inv_1_17.Y sg13cmos5l_dfrbpq_1_11.Q 0.07815f
C11994 sg13cmos5l_buf_1_24.A sg13cmos5l_nand3b_1_3.C 0.02206f
C11995 sg13cmos5l_buf_1_15.A a_9446_13726# 0.06007f
C11996 sg13cmos5l_inv_1_2.A sg13cmos5l_inv_1_14.Y 0.74129f
C11997 sg13cmos5l_inv_1_32.Y sg13cmos5l_buf_1_47.X 0.1235f
C11998 sg13cmos5l_mux2_1_0.S a_9176_13726# 0.02052f
C11999 sg13cmos5l_nor3_1_6.Y sg13cmos5l_nand2_1_13.Y 0.33477f
C12000 a_22522_3864# a_22522_3106# 0.01143f
C12001 a_22241_4166# a_22241_3328# 0.01098f
C12002 sg13cmos5l_inv_1_1.Y a_20580_11464# 0.05346f
C12003 sg13cmos5l_buf_1_13.X a_20586_10996# 0.0304f
C12004 a_21099_4772# VDD 0.20662f
C12005 sg13cmos5l_a21oi_1_15.A2 VDD 0.6467f
C12006 sg13cmos5l_buf_8_2.A sg13cmos5l_o21ai_1_5.A1 0.04066f
C12007 sg13cmos5l_buf_1_45.X a_14244_20088# 0.28137f
C12008 sg13cmos5l_a21oi_1_9.B1 a_10878_7180# 0.07197f
C12009 a_14218_19993# a_14661_19749# 0.02241f
C12010 a_18660_11016# a_19919_10775# 0.01412f
C12011 sg13cmos5l_buf_1_45.X sg13cmos5l_buf_1_54.A 0.22651f
C12012 a_8480_5498# VDD 0.07687f
C12013 sg13cmos5l_nand4_1_1.C sg13cmos5l_inv_1_13.Y 0.1445f
C12014 sg13cmos5l_dfrbpq_1_11.D a_17030_8874# 0.16823f
C12015 sg13cmos5l_nor3_1_2.C sg13cmos5l_nand2b_1_5.Y 0.03873f
C12016 sg13cmos5l_o21ai_1_5.A1 sg13cmos5l_a21o_1_2.B1 0.02283f
C12017 a_13478_16434# a_14283_16007# 0.07916f
C12018 sg13cmos5l_dlygate4sd3_1_80.X sg13cmos5l_inv_1_24.Y 0.01622f
C12019 a_18209_9376# VDD 0.20833f
C12020 sg13cmos5l_or4_1_0.C sg13cmos5l_nor3_1_2.C 0.02115f
C12021 sg13cmos5l_buf_1_13.X a_17126_7362# 0.02885f
C12022 sg13cmos5l_buf_8_2.A sg13cmos5l_dlygate4sd3_1_97.X 0.01949f
C12023 sg13cmos5l_dfrbpq_1_45.D sg13cmos5l_dfrbpq_1_13.RESET_B 0.06482f
C12024 sg13cmos5l_o21ai_1_5.A2 a_13486_13722# 0.01849f
C12025 sg13cmos5l_a21oi_1_20.Y a_17153_14750# 0.0124f
C12026 sg13cmos5l_dfrbpq_1_5.CLK sg13cmos5l_dfrbpq_1_30.D 0.49354f
C12027 sg13cmos5l_buf_1_66.X sg13cmos5l_o21ai_1_9.A2 0.02724f
C12028 sg13cmos5l_dlygate4sd3_1_69.A valid 0.0292f
C12029 a_7310_12400# a_7804_12214# 0.01637f
C12030 sg13cmos5l_buf_1_13.A a_15804_7638# 0.27143f
C12031 sg13cmos5l_a21oi_1_3.A2 sg13cmos5l_dfrbpq_1_3.D 0.38831f
C12032 sg13cmos5l_dlygate4sd3_1_38.X a_8206_9375# 0.10798f
C12033 bp6 bp2 0.03241f
C12034 a_7068_6126# a_7850_6320# 0.24435f
C12035 sg13cmos5l_inv_1_4.Y a_16875_5423# 0.01452f
C12036 sg13cmos5l_buf_1_45.X a_14181_17519# 0.03894f
C12037 sg13cmos5l_nor2_1_16.Y VDD 0.22463f
C12038 sg13cmos5l_mux2_1_0.A1 sg13cmos5l_o21ai_1_9.Y 0.24536f
C12039 sg13cmos5l_nand3b_1_3.C sg13cmos5l_nor2_1_15.Y 1.04354f
C12040 sg13cmos5l_o21ai_1_21.Y sg13cmos5l_dlygate4sd3_1_62.A 0.03097f
C12041 sg13cmos5l_dfrbpq_1_23.D a_5800_16878# 0.05286f
C12042 sg13cmos5l_dfrbpq_1_15.CLK a_8682_11460# 0.03157f
C12043 a_16186_6888# a_15905_7190# 0.18796f
C12044 sg13cmos5l_nor3_1_6.Y a_9879_12972# 0.03025f
C12045 a_12814_13239# sg13cmos5l_and2_1_6.A 0.11133f
C12046 sg13cmos5l_inv_1_1.A bn6 0.03857f
C12047 sg13cmos5l_nand2_1_0.A VDD 0.90052f
C12048 sg13cmos5l_o21ai_1_0.Y a_12712_4782# 0.03313f
C12049 sg13cmos5l_o21ai_1_19.B1 sg13cmos5l_o21ai_1_18.A2 0.026f
C12050 a_7199_6432# a_7047_6380# 0.3643f
C12051 a_12631_5376# a_13212_5773# 0.01412f
C12052 a_19642_6130# a_19365_5423# 0.01139f
C12053 a_20997_14495# bn8 0.01048f
C12054 sg13cmos5l_nand4_1_6.B a_12128_14570# 0.01669f
C12055 sg13cmos5l_a21o_1_2.X a_6394_13690# 0.04927f
C12056 sg13cmos5l_o21ai_1_9.A2 VDD 0.79058f
C12057 sg13cmos5l_dfrbpq_1_28.Q a_20580_12528# 0.01778f
C12058 sg13cmos5l_buf_1_45.X sg13cmos5l_buf_1_26.A 0.38592f
C12059 sg13cmos5l_o21ai_1_26.B1 sg13cmos5l_nor2_1_12.Y 0.1738f
C12060 sg13cmos5l_dfrbpq_1_13.CLK a_14446_11727# 0.0169f
C12061 sg13cmos5l_nand3_1_0.A sg13cmos5l_buf_1_0.A 0.02229f
C12062 sg13cmos5l_o21ai_1_4.Y a_14657_7190# 0.01802f
C12063 sg13cmos5l_a21oi_1_27.B1 sg13cmos5l_buf_1_66.X 0.17701f
C12064 sg13cmos5l_buf_1_8.A a_20488_3176# 0.01953f
C12065 sg13cmos5l_buf_1_5.A a_18922_5380# 0.03415f
C12066 a_22506_6924# sg13cmos5l_dlygate4sd3_1_3.A 0.07585f
C12067 sg13cmos5l_a21oi_1_18.B1 sg13cmos5l_a21oi_1_26.A2 0.15907f
C12068 sg13cmos5l_nand4_1_12.Y sg13cmos5l_inv_1_15.Y 0.0262f
C12069 a_19450_18226# sg13cmos5l_nand4_1_17.Y 0.01332f
C12070 a_20294_11898# a_20554_11428# 0.45119f
C12071 sg13cmos5l_inv_1_17.Y a_19825_7751# 0.01291f
C12072 sg13cmos5l_o21ai_1_13.B1 sg13cmos5l_dfrbpq_1_24.RESET_B 0.09318f
C12073 a_16550_19770# a_17253_19749# 0.02453f
C12074 sg13cmos5l_a21oi_1_2.B1 sg13cmos5l_buf_1_10.A 0.27155f
C12075 sg13cmos5l_a21oi_1_6.Y sg13cmos5l_dfrbpq_1_6.D 0.02957f
C12076 sg13cmos5l_dfrbpq_1_28.RESET_B sg13cmos5l_inv_1_1.Y 0.8672f
C12077 a_12045_11808# a_12597_11722# 0.01425f
C12078 sg13cmos5l_nand3b_1_3.C a_4182_19044# 0.01165f
C12079 sg13cmos5l_a21oi_1_4.A2 sg13cmos5l_a21oi_1_6.A2 0.27383f
C12080 sg13cmos5l_a21oi_1_4.A1 sg13cmos5l_and4_1_1.A 0.02691f
C12081 sg13cmos5l_o21ai_1_5.A1 sg13cmos5l_nor3_1_2.B 0.01769f
C12082 sg13cmos5l_mux2_1_1.A1 a_10112_13058# 0.01136f
C12083 sg13cmos5l_inv_1_15.A sg13cmos5l_a21oi_1_4.A2 0.03354f
C12084 sg13cmos5l_nand4_1_6.B sg13cmos5l_nand2_1_15.B 0.02432f
C12085 sg13cmos5l_o21ai_1_25.B1 a_15280_17750# 0.03404f
C12086 sg13cmos5l_a21oi_1_27.A2 a_9636_12528# 0.05196f
C12087 sg13cmos5l_nand4_1_18.B sg13cmos5l_dfrbpq_1_13.CLK 0.02343f
C12088 sg13cmos5l_a21oi_1_27.B1 VDD 1.48045f
C12089 sg13cmos5l_o21ai_1_15.B1 a_10066_19398# 0.06016f
C12090 sg13cmos5l_o21ai_1_21.B1 sg13cmos5l_o21ai_1_21.A2 0.13713f
C12091 sg13cmos5l_dfrbpq_1_13.CLK sg13cmos5l_a21oi_1_9.B1 0.05219f
C12092 sg13cmos5l_a21oi_1_8.A2 VDD 0.44892f
C12093 a_9062_19770# a_9348_20088# 0.26205f
C12094 sg13cmos5l_a21oi_1_8.A1 a_8637_5682# 0.19847f
C12095 sg13cmos5l_buf_1_54.A sg13cmos5l_buf_1_42.A 0.27502f
C12096 sg13cmos5l_inv_1_12.A sg13cmos5l_a21oi_1_5.A2 0.13037f
C12097 a_7354_16714# sg13cmos5l_dlygate4sd3_1_62.A 0.30305f
C12098 sg13cmos5l_inv_1_4.Y sg13cmos5l_buf_1_3.A 0.02062f
C12099 sg13cmos5l_dlygate4sd3_1_77.A bn6 0.01527f
C12100 sg13cmos5l_nor3_1_2.A VDD 0.42946f
C12101 sg13cmos5l_nand2_1_15.B a_13384_14484# 0.01936f
C12102 sg13cmos5l_inv_1_31.A a_21063_16083# 0.02474f
C12103 a_21640_3176# a_22126_3327# 0.01642f
C12104 sg13cmos5l_nor3_1_4.A a_10833_14874# 0.0186f
C12105 sg13cmos5l_nand4_1_3.B sg13cmos5l_nand4_1_18.C 0.25883f
C12106 sg13cmos5l_buf_8_2.A sg13cmos5l_o21ai_1_5.A2 0.28517f
C12107 sg13cmos5l_a21oi_1_6.A2 a_19829_8436# 0.05791f
C12108 sg13cmos5l_a21oi_1_10.Y a_10408_6294# 0.04848f
C12109 a_19179_10820# a_18948_10711# 0.07823f
C12110 a_18660_11016# a_19825_10775# 0.25046f
C12111 sg13cmos5l_o21ai_1_5.A2 sg13cmos5l_a21o_1_2.B1 0.51538f
C12112 a_16810_19993# VDD 0.09391f
C12113 sg13cmos5l_inv_1_31.A sg13cmos5l_nand4_1_17.Y 0.40411f
C12114 sg13cmos5l_a21oi_1_4.A2 sg13cmos5l_a21oi_1_17.Y 0.10073f
C12115 a_5098_9409# VDD 0.09521f
C12116 sg13cmos5l_a21oi_1_16.A2 a_17608_13760# 0.04033f
C12117 a_14052_16421# a_14283_16007# 0.07823f
C12118 sg13cmos5l_a21oi_1_10.Y a_9761_6352# 0.02173f
C12119 sg13cmos5l_buf_1_63.A bn4 0.01566f
C12120 a_20384_16921# a_20503_16710# 0.09257f
C12121 a_19035_16750# sg13cmos5l_dfrbpq_1_30.Q 0.01505f
C12122 sg13cmos5l_and4_1_1.A sg13cmos5l_mux2_1_1.A1 0.21655f
C12123 sg13cmos5l_o21ai_1_1.B1 a_15208_11546# 0.01363f
C12124 sg13cmos5l_buf_1_63.A sg13cmos5l_buf_1_66.X 0.19291f
C12125 sg13cmos5l_nor4_1_1.D a_10530_14484# 0.02447f
C12126 sg13cmos5l_dlygate4sd3_1_20.A bp3 0.03742f
C12127 sg13cmos5l_nand3_1_0.C a_17109_9344# 0.02343f
C12128 a_21640_3900# bp1 0.15839f
C12129 a_16085_12508# VDD 0.15859f
C12130 sg13cmos5l_mux2_1_0.A1 a_6835_13916# 0.01218f
C12131 sg13cmos5l_dlygate4sd3_1_1.A a_19930_4618# 0.27783f
C12132 sg13cmos5l_nand2_1_1.A a_20012_14448# 0.04212f
C12133 a_21215_15967# a_21911_16043# 0.02453f
C12134 sg13cmos5l_nand2_1_11.B a_9096_15996# 0.10591f
C12135 a_7895_6553# sg13cmos5l_a21oi_1_8.Y 0.17114f
C12136 sg13cmos5l_nand2_1_1.A sg13cmos5l_a21oi_1_2.A2 0.02183f
C12137 sg13cmos5l_o21ai_1_11.Y a_6209_16936# 0.05332f
C12138 sg13cmos5l_dfrbpq_1_15.Q sg13cmos5l_nand3_1_4.Y 0.40569f
C12139 sg13cmos5l_o21ai_1_3.Y a_15820_9186# 0.01176f
C12140 sg13cmos5l_inv_1_15.A sg13cmos5l_buf_1_57.A 0.18954f
C12141 a_7068_6126# a_7895_6553# 0.26205f
C12142 a_11656_5498# a_11840_5498# 0.05762f
C12143 a_13212_5773# a_13102_5850# 0.25046f
C12144 a_12844_5850# a_13191_5499# 0.03412f
C12145 sg13cmos5l_nand4_1_8.B sg13cmos5l_nand4_1_6.B 0.23731f
C12146 sg13cmos5l_nand4_1_7.B a_13764_16000# 0.01087f
C12147 sg13cmos5l_inv_1_17.A a_21531_13342# 0.03477f
C12148 a_13727_13992# a_14517_13880# 0.02241f
C12149 sg13cmos5l_dfrbpq_1_28.Q a_22506_12508# 0.0916f
C12150 a_20580_14040# bn7 0.01489f
C12151 sg13cmos5l_inv_1_8.A sg13cmos5l_o21ai_1_4.Y 0.07406f
C12152 sg13cmos5l_nand2_1_1.A sg13cmos5l_a21oi_1_6.A2 0.20857f
C12153 a_4646_19458# a_5220_19445# 0.18486f
C12154 a_4906_18988# a_5349_19031# 0.02241f
C12155 sg13cmos5l_o21ai_1_26.B1 sg13cmos5l_nand2_1_12.Y 0.12043f
C12156 sg13cmos5l_nand3b_1_3.C sg13cmos5l_buf_1_59.A 0.23962f
C12157 a_10787_12972# VDD 0.0122f
C12158 sg13cmos5l_inv_1_8.A sg13cmos5l_nand3_1_0.A 0.97556f
C12159 sg13cmos5l_buf_1_63.A VDD 0.88661f
C12160 sg13cmos5l_dfrbpq_1_35.D bn3 0.02345f
C12161 sg13cmos5l_a21oi_1_25.Y a_16283_17508# 0.03936f
C12162 sg13cmos5l_dlygate4sd3_1_65.A sg13cmos5l_o21ai_1_14.A1 0.03869f
C12163 sg13cmos5l_inv_1_15.A sg13cmos5l_nand2_1_1.A 0.04358f
C12164 a_12826_9154# VDD 0.26981f
C12165 a_9765_12972# VDD 0.01364f
C12166 sg13cmos5l_inv_1_18.A sg13cmos5l_a21oi_1_4.B1 0.06632f
C12167 a_20997_8447# bp2 0.04372f
C12168 a_5124_9504# a_6383_9263# 0.01412f
C12169 sg13cmos5l_a21oi_1_14.Y a_21084_16710# 0.01474f
C12170 sg13cmos5l_inv_1_24.Y sg13cmos5l_inv_1_24.A 0.20875f
C12171 a_12616_14484# VDD 0.18182f
C12172 sg13cmos5l_buf_1_25.A sg13cmos5l_nand2_1_12.A 0.02247f
C12173 sg13cmos5l_dfrbpq_1_19.CLK a_4932_19024# 0.04168f
C12174 sg13cmos5l_o21ai_1_4.Y a_13434_6887# 0.01324f
C12175 sg13cmos5l_nand2b_1_0.B sg13cmos5l_dlygate4sd3_1_8.X 0.08742f
C12176 sg13cmos5l_dlygate4sd3_1_20.A a_22506_9948# 0.02604f
C12177 sg13cmos5l_o21ai_1_5.A2 sg13cmos5l_nor3_1_2.B 0.15327f
C12178 sg13cmos5l_nand3_1_0.A sg13cmos5l_a22oi_1_2.Y 0.34767f
C12179 sg13cmos5l_a21oi_1_19.Y sg13cmos5l_inv_1_24.Y 0.07428f
C12180 sg13cmos5l_buf_1_4.A sg13cmos5l_inv_1_7.Y 0.35661f
C12181 code2 bn2 0.03069f
C12182 sg13cmos5l_nand2b_1_1.A_N sg13cmos5l_nor4_1_0.C 0.15662f
C12183 code3 bn1 0.07152f
C12184 sg13cmos5l_o21ai_1_21.Y sg13cmos5l_o21ai_1_11.Y 0.0158f
C12185 sg13cmos5l_nand2_1_13.A sg13cmos5l_nor3_1_0.Y 0.12941f
C12186 sg13cmos5l_o21ai_1_0.B1 sg13cmos5l_a21oi_1_11.Y 0.13264f
C12187 sg13cmos5l_buf_1_7.X sg13cmos5l_dfrbpq_1_6.D 0.06731f
C12188 a_10049_9376# VDD 0.21875f
C12189 sg13cmos5l_a21oi_1_9.A1 sg13cmos5l_o21ai_1_0.B1 0.07075f
C12190 sg13cmos5l_a21oi_1_1.A2 a_18660_7992# 0.0137f
C12191 sg13cmos5l_inv_1_18.Y a_13814_8828# 0.01786f
C12192 sg13cmos5l_a21oi_1_11.Y a_12614_6166# 0.01211f
C12193 sg13cmos5l_a21oi_1_7.A2 a_19448_12214# 0.01582f
C12194 sg13cmos5l_dlygate4sd3_1_50.X sg13cmos5l_buf_1_66.X 0.05067f
C12195 a_21254_10702# sg13cmos5l_buf_1_9.A 0.02304f
C12196 a_21366_10766# a_21934_10887# 0.01641f
C12197 sg13cmos5l_nand2b_1_1.A_N sg13cmos5l_nor2_1_2.B 0.10836f
C12198 sg13cmos5l_buf_8_2.A a_17825_17774# 0.01463f
C12199 sg13cmos5l_a21oi_1_9.A1 a_12614_6166# 0.01607f
C12200 sg13cmos5l_dfrbpq_1_18.Q a_12040_13058# 0.04846f
C12201 a_14244_20088# a_14532_19783# 0.24435f
C12202 sg13cmos5l_nand4_1_1.B sg13cmos5l_buf_1_20.A 0.01073f
C12203 a_14218_19993# bn2 0.01171f
C12204 a_15023_17869# code0 0.02972f
C12205 a_9636_12528# a_10155_12332# 0.20773f
C12206 sg13cmos5l_a21oi_1_9.A1 sg13cmos5l_a21oi_1_11.Y 1.64109f
C12207 sg13cmos5l_nand4_1_7.B sg13cmos5l_a21oi_1_20.Y 0.03854f
C12208 sg13cmos5l_nand4_1_1.A a_20012_14448# 0.01573f
C12209 sg13cmos5l_nor3_1_1.Y sg13cmos5l_a21oi_1_11.Y 0.40342f
C12210 a_10365_7194# a_10447_7294# 0.01126f
C12211 a_19919_10775# a_19825_10775# 0.16704f
C12212 sg13cmos5l_dfrbpq_1_24.Q a_9147_13028# 0.04894f
C12213 sg13cmos5l_buf_1_15.A a_6123_12983# 0.01453f
C12214 sg13cmos5l_a21oi_1_9.A1 sg13cmos5l_nor3_1_1.Y 0.12823f
C12215 sg13cmos5l_nand4_1_5.D sg13cmos5l_buf_1_57.A 0.05496f
C12216 sg13cmos5l_dfrbpq_1_11.Q a_19430_9190# 0.05059f
C12217 sg13cmos5l_inv_1_32.Y sg13cmos5l_o21ai_1_24.Y 0.11787f
C12218 a_14536_14484# bn5 0.15884f
C12219 sg13cmos5l_nand4_1_18.B sg13cmos5l_o21ai_1_7.A2 0.29522f
C12220 sg13cmos5l_inv_1_4.Y sg13cmos5l_a21oi_1_3.Y 0.01919f
C12221 sg13cmos5l_dlygate4sd3_1_50.X VDD 1.40429f
C12222 sg13cmos5l_o21ai_1_10.A2 a_11100_16362# 0.01573f
C12223 sg13cmos5l_dfrbpq_1_13.RESET_B a_7173_11471# 0.04051f
C12224 sg13cmos5l_dfrbpq_1_41.CLK sg13cmos5l_inv_1_15.A 0.01368f
C12225 sg13cmos5l_nand4_1_1.A sg13cmos5l_a21oi_1_6.A2 0.37708f
C12226 sg13cmos5l_buf_8_2.A a_13764_17512# 0.03722f
C12227 sg13cmos5l_inv_1_16.A sg13cmos5l_a21oi_1_2.B1 0.05442f
C12228 sg13cmos5l_a21oi_1_9.A1 sg13cmos5l_a21oi_1_9.Y 0.33788f
C12229 sg13cmos5l_buf_8_2.A sg13cmos5l_dfrbpq_1_13.CLK 0.09077f
C12230 a_1294_15423# a_1409_15424# 0.3854f
C12231 sg13cmos5l_nand4_1_3.D sg13cmos5l_inv_1_16.A 0.01554f
C12232 sg13cmos5l_inv_1_15.A sg13cmos5l_nand4_1_1.A 0.12606f
C12233 sg13cmos5l_a21oi_1_21.A1 sg13cmos5l_dfrbpq_1_41.CLK 0.014f
C12234 sg13cmos5l_nand2_1_1.A sg13cmos5l_a21oi_1_1.A2 0.31233f
C12235 sg13cmos5l_mux2_1_0.A1 a_8006_13726# 0.01188f
C12236 sg13cmos5l_a21oi_1_6.A2 sg13cmos5l_dfrbpq_1_11.Q 0.07083f
C12237 a_17126_7362# a_17412_6928# 0.26205f
C12238 a_17804_4614# VDD 0.18067f
C12239 a_8434_17886# a_8830_17874# 0.01288f
C12240 sg13cmos5l_inv_1_24.Y bn0 0.01485f
C12241 sg13cmos5l_nand4_1_18.B sg13cmos5l_mux2_1_0.A1 0.05692f
C12242 sg13cmos5l_o21ai_1_21.B1 sg13cmos5l_nand3b_1_3.C 0.04559f
C12243 sg13cmos5l_nand4_1_1.B sg13cmos5l_inv_1_13.Y 0.06399f
C12244 sg13cmos5l_and4_1_1.A sg13cmos5l_nor3_1_4.A 0.25862f
C12245 sg13cmos5l_dfrbpq_1_37.D a_21215_18528# 0.01357f
C12246 sg13cmos5l_o21ai_1_1.B1 a_14646_10766# 0.04431f
C12247 sg13cmos5l_nand4_1_18.B bn6 0.02002f
C12248 a_11180_15198# a_11656_15272# 0.02574f
C12249 a_13212_5773# a_14133_5459# 0.24169f
C12250 sg13cmos5l_o21ai_1_7.B1 sg13cmos5l_o21ai_1_7.A2 0.13826f
C12251 sg13cmos5l_nand4_1_7.B a_15023_16357# 0.0149f
C12252 sg13cmos5l_buf_1_24.A bn2 0.02215f
C12253 a_21839_4727# bp5 0.01227f
C12254 a_19432_3900# bp9 0.06213f
C12255 a_5220_19445# a_5451_19031# 0.07823f
C12256 sg13cmos5l_a21oi_1_2.Y bp2 0.0233f
C12257 a_13210_12936# VDD 0.26812f
C12258 a_21531_13342# bp0 0.01825f
C12259 a_21839_7285# bp1 0.0174f
C12260 sg13cmos5l_dfrbpq_1_5.CLK a_21761_15424# 0.01558f
C12261 sg13cmos5l_nor2b_1_1.A sg13cmos5l_a21oi_1_12.A2 0.12661f
C12262 sg13cmos5l_a21oi_1_17.Y sg13cmos5l_nand4_1_1.A 0.03758f
C12263 sg13cmos5l_nand2_1_19.A sg13cmos5l_nand2_1_19.Y 0.26933f
C12264 a_20997_11471# a_21745_11821# 0.01058f
C12265 sg13cmos5l_dlygate4sd3_1_58.X a_9040_19262# 0.02444f
C12266 a_20554_12433# a_20580_12528# 0.24169f
C12267 sg13cmos5l_o21ai_1_5.A1 sg13cmos5l_buf_1_22.A 0.01484f
C12268 a_15358_14850# a_15582_14850# 0.01261f
C12269 a_6383_9263# a_7050_9484# 0.09257f
C12270 sg13cmos5l_a21oi_1_14.Y a_21911_17137# 0.04875f
C12271 a_19450_18226# VDD 0.25958f
C12272 sg13cmos5l_dfrbpq_1_5.CLK a_18660_11016# 0.04168f
C12273 a_12128_14570# VDD 0.07255f
C12274 sg13cmos5l_buf_1_66.X sg13cmos5l_nand2_1_15.B 0.57331f
C12275 sg13cmos5l_nand2_1_0.B sg13cmos5l_a22oi_1_0.A2 0.32248f
C12276 sg13cmos5l_buf_1_21.A sg13cmos5l_inv_1_8.A 0.17124f
C12277 sg13cmos5l_inv_1_31.A bn4 0.03734f
C12278 sg13cmos5l_o21ai_1_7.Y sg13cmos5l_o21ai_1_20.A1 0.02319f
C12279 sg13cmos5l_nor2_1_10.Y sg13cmos5l_nand3b_1_1.C 0.19633f
C12280 sg13cmos5l_a21oi_1_24.A1 a_9070_18447# 0.01112f
C12281 a_5998_17775# sg13cmos5l_o21ai_1_11.Y 0.01309f
C12282 sg13cmos5l_buf_1_63.A sg13cmos5l_dlygate4sd3_1_69.A 0.03029f
C12283 sg13cmos5l_nor4_1_1.D a_8844_15424# 0.10755f
C12284 sg13cmos5l_nand3_1_0.A sg13cmos5l_nand2_1_5.Y 0.01458f
C12285 a_13862_6166# a_13974_6230# 0.3854f
C12286 sg13cmos5l_a21oi_1_0.A2 sg13cmos5l_nor3_1_7.Y 0.35596f
C12287 sg13cmos5l_buf_1_15.A a_11393_13238# 0.01147f
C12288 sg13cmos5l_inv_1_2.A sg13cmos5l_inv_1_7.Y 0.01843f
C12289 sg13cmos5l_dfrbpq_1_41.CLK sg13cmos5l_nand4_1_5.D 0.02648f
C12290 sg13cmos5l_nand4_1_6.B sg13cmos5l_dfrbpq_1_24.Q 0.2559f
C12291 sg13cmos5l_buf_1_15.A sg13cmos5l_inv_1_1.Y 0.04424f
C12292 sg13cmos5l_dfrbpq_1_13.CLK sg13cmos5l_nor3_1_2.B 0.33924f
C12293 sg13cmos5l_inv_1_6.Y bp2 0.03178f
C12294 sg13cmos5l_nand4_1_1.B sg13cmos5l_dfrbpq_1_30.Q 0.05108f
C12295 sg13cmos5l_inv_1_12.Y sg13cmos5l_dfrbpq_1_7.D 0.08106f
C12296 sg13cmos5l_nand4_1_5.D sg13cmos5l_nand4_1_1.A 0.01696f
C12297 a_9558_13790# a_10016_13854# 0.01604f
C12298 sg13cmos5l_nand2_1_15.B VDD 0.97639f
C12299 a_10155_12332# a_10895_12287# 0.17382f
C12300 sg13cmos5l_nand3b_1_1.Y sg13cmos5l_nand2_1_9.Y 0.14379f
C12301 sg13cmos5l_nand4_1_18.A sg13cmos5l_inv_1_12.A 0.05673f
C12302 sg13cmos5l_a21o_1_0.A1 a_11014_9508# 0.04761f
C12303 a_11656_5498# VDD 0.12654f
C12304 sg13cmos5l_dlygate4sd3_1_72.A sg13cmos5l_nand4_1_5.D 0.04322f
C12305 sg13cmos5l_a21oi_1_2.A2 a_17604_11464# 0.01474f
C12306 sg13cmos5l_a21oi_1_1.A2 sg13cmos5l_dfrbpq_1_11.Q 0.73656f
C12307 sg13cmos5l_inv_1_15.Y sg13cmos5l_buf_1_42.A 0.08656f
C12308 a_20997_11471# VDD 0.24025f
C12309 a_5643_9308# VDD 0.20482f
C12310 sg13cmos5l_inv_1_31.A VDD 1.99584f
C12311 sg13cmos5l_inv_1_6.Y a_21099_4772# 0.01234f
C12312 sg13cmos5l_buf_1_1.A a_21761_15424# 0.01807f
C12313 sg13cmos5l_nor2_1_2.Y a_8620_4948# 0.01407f
C12314 sg13cmos5l_buf_8_2.A a_15023_17869# 0.03595f
C12315 sg13cmos5l_a21oi_1_6.A2 a_17604_11464# 0.01761f
C12316 sg13cmos5l_dfrbpq_1_0.D a_19930_4618# 0.01001f
C12317 sg13cmos5l_nand4_1_8.B bn4 0.01084f
C12318 sg13cmos5l_nand3_1_0.Y sg13cmos5l_dfrbpq_1_9.D 0.01918f
C12319 sg13cmos5l_o21ai_1_26.B1 sg13cmos5l_dfrbpq_1_41.CLK 0.03211f
C12320 sg13cmos5l_a21oi_1_2.A2 sg13cmos5l_dfrbpq_1_3.D 0.32668f
C12321 a_17412_6928# a_17700_7349# 0.24435f
C12322 sg13cmos5l_dfrbpq_1_24.RESET_B a_5157_14495# 0.04304f
C12323 a_17792_14570# VDD 0.07768f
C12324 sg13cmos5l_buf_1_15.A sg13cmos5l_and4_1_1.A 0.18685f
C12325 sg13cmos5l_buf_1_66.X sg13cmos5l_nand4_1_8.B 0.11072f
C12326 sg13cmos5l_nand4_1_18.B sg13cmos5l_nand3b_1_1.C 0.04148f
C12327 sg13cmos5l_buf_1_13.X sg13cmos5l_buf_1_13.A 0.37039f
C12328 sg13cmos5l_a21oi_1_4.A1 sg13cmos5l_inv_1_20.Y 0.02219f
C12329 sg13cmos5l_inv_1_1.Y a_20554_8404# 0.01771f
C12330 a_13343_5383# a_13994_5692# 0.01562f
C12331 a_13191_5499# a_14039_5459# 0.07916f
C12332 sg13cmos5l_nand2_1_1.A sg13cmos5l_dlygate4sd3_1_76.A 0.02368f
C12333 sg13cmos5l_nor3_1_6.Y VDD 1.40313f
C12334 sg13cmos5l_nand2b_1_4.Y a_8061_7194# 0.18615f
C12335 sg13cmos5l_nand4_1_7.B sg13cmos5l_nand4_1_16.D 0.0286f
C12336 sg13cmos5l_a22oi_1_1.B2 clk 0.02894f
C12337 sg13cmos5l_a21oi_1_6.A2 sg13cmos5l_and2_1_5.X 0.03812f
C12338 sg13cmos5l_dlygate4sd3_1_0.A bp5 0.50003f
C12339 a_6191_19381# a_6097_19381# 0.16704f
C12340 a_7310_12400# sg13cmos5l_dfrbpq_1_45.D 0.12761f
C12341 a_10694_18258# a_11499_18380# 0.07916f
C12342 a_10980_18576# a_11397_18237# 0.28324f
C12343 sg13cmos5l_dfrbpq_1_39.D sg13cmos5l_o21ai_1_23.B1 0.04846f
C12344 sg13cmos5l_inv_1_9.Y VDD 0.41186f
C12345 a_21531_13342# a_21839_12287# 0.01189f
C12346 sg13cmos5l_o21ai_1_7.A2 sg13cmos5l_buf_8_2.A 0.6159f
C12347 a_20580_12528# a_21839_12287# 0.01412f
C12348 sg13cmos5l_inv_1_15.Y sg13cmos5l_nand3_1_1.Y 0.01353f
C12349 sg13cmos5l_inv_1_8.A a_14438_6162# 0.0535f
C12350 sg13cmos5l_o21ai_1_17.Y a_11268_18271# 0.01145f
C12351 sg13cmos5l_nand4_1_8.B VDD 0.54719f
C12352 a_15358_14850# VDD 0.17657f
C12353 a_21084_16357# a_21215_15967# 0.28324f
C12354 sg13cmos5l_dfrbpq_1_19.CLK a_7524_19024# 0.05595f
C12355 sg13cmos5l_a21oi_1_24.A1 a_11397_18237# 0.01493f
C12356 a_13015_13686# a_13575_13940# 0.17382f
C12357 sg13cmos5l_o21ai_1_0.A2 a_13148_4968# 0.01113f
C12358 a_21934_10887# bp1 0.02226f
C12359 sg13cmos5l_buf_1_43.X bn5 0.01465f
C12360 sg13cmos5l_inv_1_17.A a_22126_9375# 0.03745f
C12361 sg13cmos5l_buf_8_2.A sg13cmos5l_mux2_1_0.A1 0.04669f
C12362 sg13cmos5l_buf_1_10.A a_17316_8440# 0.02146f
C12363 a_12394_18988# a_12420_19024# 0.24169f
C12364 a_6394_17472# a_6113_17774# 0.18796f
C12365 sg13cmos5l_nand4_1_6.B sg13cmos5l_and2_1_3.X 0.0136f
C12366 a_20974_6351# bp4 0.06061f
C12367 a_17002_15457# a_17445_15213# 0.02241f
C12368 sg13cmos5l_dlygate4sd3_1_81.X a_17028_15552# 0.01712f
C12369 sg13cmos5l_buf_8_2.A bn6 0.01782f
C12370 sg13cmos5l_a21oi_1_17.Y sg13cmos5l_and2_1_5.X 0.15213f
C12371 sg13cmos5l_buf_1_15.A a_21215_15967# 0.04165f
C12372 sg13cmos5l_buf_1_15.A sg13cmos5l_and2_1_6.A 0.05773f
C12373 sg13cmos5l_nand2b_1_1.A_N sg13cmos5l_nand4_1_0.C 0.11863f
C12374 sg13cmos5l_o21ai_1_5.A1 a_9636_12528# 0.01528f
C12375 sg13cmos5l_a21oi_1_7.A2 sg13cmos5l_dlygate4sd3_1_71.X 0.02738f
C12376 sg13cmos5l_nand3b_1_0.C sg13cmos5l_dlygate4sd3_1_15.X 0.07545f
C12377 sg13cmos5l_a21oi_1_6.Y sg13cmos5l_inv_1_4.Y 0.01922f
C12378 sg13cmos5l_nand3_1_8.Y a_20554_13945# 0.0104f
C12379 sg13cmos5l_dfrbpq_1_13.Q a_11674_6130# 0.34199f
C12380 sg13cmos5l_nor4_1_0.C VDD 0.60686f
C12381 sg13cmos5l_nand2_1_0.B sg13cmos5l_nor4_1_0.Y 0.03717f
C12382 sg13cmos5l_buf_1_26.A a_18486_18326# 0.11584f
C12383 a_10895_12287# a_11562_12508# 0.09257f
C12384 sg13cmos5l_a21o_1_0.A1 sg13cmos5l_nand3_1_0.A 0.03662f
C12385 sg13cmos5l_a21oi_1_0.A2 a_17931_6935# 0.02416f
C12386 sg13cmos5l_o21ai_1_7.B1 sg13cmos5l_nand3_1_5.Y 0.02677f
C12387 sg13cmos5l_a21oi_1_27.A1 sg13cmos5l_nand2_1_13.A 0.23135f
C12388 a_13343_5383# VDD 0.25428f
C12389 sg13cmos5l_mux2_1_0.S sg13cmos5l_a21oi_1_27.A2 0.01845f
C12390 sg13cmos5l_nand4_1_18.C sg13cmos5l_a21oi_1_5.A2 0.09214f
C12391 sg13cmos5l_buf_1_59.A bn2 0.12406f
C12392 a_1294_19959# sg13cmos5l_buf_1_30.A 0.10701f
C12393 sg13cmos5l_nor2_1_2.B VDD 0.90992f
C12394 sg13cmos5l_nand4_1_1.A sg13cmos5l_dlygate4sd3_1_76.A 0.38942f
C12395 sg13cmos5l_nor3_1_2.Y VDD 0.28606f
C12396 sg13cmos5l_dlygate4sd3_1_18.A a_18021_11471# 0.01068f
C12397 a_22506_11460# VDD 0.27477f
C12398 sg13cmos5l_inv_1_15.Y sg13cmos5l_inv_1_4.Y 0.15883f
C12399 a_5626_19738# a_5349_19031# 0.01139f
C12400 sg13cmos5l_o21ai_1_23.A2 a_12886_15230# 0.0481f
C12401 sg13cmos5l_buf_1_10.A a_10500_9952# 0.02046f
C12402 a_7616_15366# VDD 0.06406f
C12403 sg13cmos5l_a21oi_1_6.A2 a_19120_11702# 0.01017f
C12404 sg13cmos5l_dfrbpq_1_24.RESET_B a_5036_13686# 0.16544f
C12405 a_4568_15238# sg13cmos5l_nor2_1_6.Y 0.03692f
C12406 sg13cmos5l_a21oi_1_5.A2 sg13cmos5l_buf_1_0.A 0.01741f
C12407 sg13cmos5l_dlygate4sd3_1_29.A sg13cmos5l_a21oi_1_0.Y 0.02177f
C12408 sg13cmos5l_inv_1_5.Y a_15680_5498# 0.01054f
C12409 sg13cmos5l_dfrbpq_1_13.CLK a_10864_5654# 0.01126f
C12410 sg13cmos5l_a21oi_1_21.A1 bn3 0.01811f
C12411 sg13cmos5l_buf_1_1.A sg13cmos5l_buf_1_8.A 0.01082f
C12412 a_17931_6935# a_18928_7166# 0.03546f
C12413 sg13cmos5l_o21ai_1_5.A2 sg13cmos5l_nor2_1_4.Y 0.0942f
C12414 sg13cmos5l_o21ai_1_9.A2 sg13cmos5l_dfrbpq_1_15.CLK 0.16981f
C12415 sg13cmos5l_inv_1_1.Y a_20580_14488# 0.055f
C12416 sg13cmos5l_a21oi_1_1.A2 a_19467_5423# 0.01324f
C12417 sg13cmos5l_buf_8_2.A sg13cmos5l_a21oi_1_24.Y 0.02708f
C12418 a_20503_16710# a_20716_16746# 0.23043f
C12419 sg13cmos5l_nand2_1_6.A sg13cmos5l_a21oi_1_8.A2 0.15269f
C12420 a_8576_10901# sg13cmos5l_dlygate4sd3_1_37.A 0.08786f
C12421 sg13cmos5l_buf_1_5.A sg13cmos5l_dlygate4sd3_1_29.A 0.02427f
C12422 a_1294_19959# VDD 0.15712f
C12423 sg13cmos5l_inv_1_15.A sg13cmos5l_nor4_1_2.Y 0.05722f
C12424 sg13cmos5l_buf_1_63.A a_14763_19892# 0.02016f
C12425 sg13cmos5l_buf_1_13.X sg13cmos5l_buf_1_5.A 0.90211f
C12426 sg13cmos5l_nand2_1_2.Y a_16440_11016# 0.01267f
C12427 sg13cmos5l_dlygate4sd3_1_38.X sg13cmos5l_nor3_1_2.A 0.03733f
C12428 a_11499_18380# a_12496_18478# 0.03412f
C12429 sg13cmos5l_o21ai_1_5.A2 sg13cmos5l_buf_1_53.A 0.13341f
C12430 a_21839_12287# a_22506_12508# 0.09257f
C12431 a_20997_12189# a_21745_12287# 0.01058f
C12432 sg13cmos5l_dlygate4sd3_1_43.X sg13cmos5l_nand2_1_3.Y 0.06625f
C12433 a_13727_13992# sg13cmos5l_nand2_1_19.A 0.01549f
C12434 sg13cmos5l_dfrbpq_1_15.CLK sg13cmos5l_a21oi_1_8.A2 0.04219f
C12435 sg13cmos5l_dfrbpq_1_19.CLK a_8783_19381# 0.01402f
C12436 sg13cmos5l_o21ai_1_19.B1 sg13cmos5l_nand3b_1_1.Y 0.09059f
C12437 sg13cmos5l_dfrbpq_1_19.CLK a_3895_18222# 0.04335f
C12438 sg13cmos5l_dfrbpq_1_15.Q a_6368_6337# 0.10224f
C12439 sg13cmos5l_inv_1_36.A a_6394_13690# 0.0119f
C12440 a_12837_19031# a_12939_19031# 0.3643f
C12441 sg13cmos5l_dfrbpq_1_15.CLK sg13cmos5l_nor3_1_2.A 0.02756f
C12442 sg13cmos5l_dlygate4sd3_1_76.X a_20398_13239# 0.10673f
C12443 sg13cmos5l_o21ai_1_10.A2 a_5686_16374# 0.07408f
C12444 sg13cmos5l_nand2b_1_0.B sg13cmos5l_nor2_1_0.Y 0.33815f
C12445 sg13cmos5l_nand2b_1_1.A_N sg13cmos5l_dlygate4sd3_1_15.X 0.36809f
C12446 sg13cmos5l_buf_8_2.A sg13cmos5l_nand3b_1_1.C 0.12244f
C12447 sg13cmos5l_nand3b_1_3.C sg13cmos5l_nand4_1_6.B 0.01767f
C12448 sg13cmos5l_inv_1_25.Y bn4 0.09364f
C12449 sg13cmos5l_inv_1_17.Y sg13cmos5l_dlygate4sd3_1_71.X 0.05165f
C12450 sg13cmos5l_nand3b_1_1.Y sg13cmos5l_nor4_1_4.C 0.17285f
C12451 a_10607_19847# VDD 0.17032f
C12452 sg13cmos5l_buf_1_2.A a_20488_3176# 0.01929f
C12453 sg13cmos5l_a21oi_1_2.A2 bp9 0.01831f
C12454 sg13cmos5l_dfrbpq_1_27.Q a_21839_13799# 0.01908f
C12455 sg13cmos5l_buf_1_4.A bp2 0.02685f
C12456 sg13cmos5l_nor2b_1_2.Y sg13cmos5l_o21ai_1_4.Y 1.38064f
C12457 sg13cmos5l_o21ai_1_4.A1 a_13434_6887# 0.02055f
C12458 sg13cmos5l_dlygate4sd3_1_74.A sg13cmos5l_dfrbpq_1_29.D 0.04218f
C12459 a_19066_15960# a_18785_16262# 0.18796f
C12460 sg13cmos5l_dfrbpq_1_47.D a_14724_6480# 0.01604f
C12461 sg13cmos5l_buf_1_10.A sg13cmos5l_nand3_1_0.C 0.0509f
C12462 sg13cmos5l_o21ai_1_28.A1 bn3 0.02059f
C12463 sg13cmos5l_nand3_1_5.Y a_7954_17886# 0.05538f
C12464 sg13cmos5l_dfrbpq_1_28.D a_19830_12278# 0.0209f
C12465 a_10607_19847# a_10864_19990# 0.23043f
C12466 sg13cmos5l_a21oi_1_4.A1 sg13cmos5l_a21oi_1_4.A2 0.62241f
C12467 sg13cmos5l_inv_1_1.A sg13cmos5l_buf_1_8.A 0.01704f
C12468 sg13cmos5l_a21o_1_2.X a_5259_14495# 0.02175f
C12469 sg13cmos5l_buf_1_47.X sg13cmos5l_dlygate4sd3_1_56.X 0.01363f
C12470 sg13cmos5l_buf_1_17.X a_1690_9154# 0.01992f
C12471 sg13cmos5l_a22oi_1_0.A2 sg13cmos5l_inv_1_18.Y 0.50974f
C12472 sg13cmos5l_dfrbpq_1_13.CLK sg13cmos5l_o21ai_1_0.A2 0.08565f
C12473 sg13cmos5l_buf_1_7.X sg13cmos5l_inv_1_4.Y 0.19451f
C12474 sg13cmos5l_dfrbpq_1_24.Q VDD 1.20333f
C12475 sg13cmos5l_buf_1_4.A a_21099_4772# 0.02633f
C12476 sg13cmos5l_buf_1_47.X a_10510_19287# 0.02281f
C12477 sg13cmos5l_buf_1_7.X a_18952_4688# 0.18157f
C12478 sg13cmos5l_nor4_1_2.Y sg13cmos5l_nand4_1_5.D 0.0878f
C12479 sg13cmos5l_buf_1_66.X a_5782_15230# 0.05789f
C12480 sg13cmos5l_buf_8_2.A sg13cmos5l_nand3_1_5.Y 0.05032f
C12481 a_4607_18528# a_5222_17508# 0.01248f
C12482 sg13cmos5l_nor4_1_2.Y sg13cmos5l_o21ai_1_28.A1 0.18474f
C12483 sg13cmos5l_buf_1_10.A a_11019_9959# 0.03018f
C12484 sg13cmos5l_dlygate4sd3_1_65.A sg13cmos5l_o21ai_1_15.B1 0.08893f
C12485 sg13cmos5l_inv_1_25.Y VDD 1.65487f
C12486 sg13cmos5l_o21ai_1_21.A2 sg13cmos5l_buf_1_66.X 0.51446f
C12487 a_4127_17016# a_4031_15967# 0.04279f
C12488 sg13cmos5l_buf_1_65.A a_9147_13028# 0.02017f
C12489 sg13cmos5l_buf_8_2.A sg13cmos5l_o21ai_1_1.B1 0.15646f
C12490 sg13cmos5l_dfrbpq_1_9.Q sg13cmos5l_inv_1_14.Y 0.02812f
C12491 sg13cmos5l_dfrbpq_1_24.RESET_B a_3975_16964# 0.28437f
C12492 sg13cmos5l_nand2_1_12.A valid 0.02566f
C12493 sg13cmos5l_inv_1_12.Y sg13cmos5l_buf_1_13.X 0.05691f
C12494 a_16070_5850# a_16356_5416# 0.26205f
C12495 sg13cmos5l_o21ai_1_26.B1 bn3 0.01858f
C12496 sg13cmos5l_dfrbpq_1_13.CLK a_12631_5376# 0.01314f
C12497 sg13cmos5l_buf_1_45.X sg13cmos5l_inv_1_36.A 0.13951f
C12498 sg13cmos5l_inv_1_36.A sg13cmos5l_nand3_1_2.A 0.04145f
C12499 sg13cmos5l_nand3_1_0.Y a_16725_7832# 0.01415f
C12500 sg13cmos5l_buf_8_2.A sg13cmos5l_a21oi_1_26.A2 0.02533f
C12501 sg13cmos5l_nand4_1_18.B a_8960_19902# 0.02278f
C12502 sg13cmos5l_nand4_1_1.C a_16840_12972# 0.01152f
C12503 sg13cmos5l_inv_1_8.Y a_16070_5850# 0.16217f
C12504 sg13cmos5l_buf_1_9.A sg13cmos5l_buf_1_13.A 0.02105f
C12505 sg13cmos5l_a21o_1_0.X a_10771_9380# 0.11824f
C12506 sg13cmos5l_buf_1_2.A sg13cmos5l_buf_1_8.A 0.24249f
C12507 sg13cmos5l_nor3_1_2.B sg13cmos5l_or4_1_0.C 0.14704f
C12508 sg13cmos5l_o21ai_1_28.B1 a_13400_15238# 0.03462f
C12509 a_7937_19960# sg13cmos5l_o21ai_1_19.Y 0.05712f
C12510 sg13cmos5l_inv_1_32.Y sg13cmos5l_nand2_1_19.A 0.05493f
C12511 sg13cmos5l_o21ai_1_21.A2 VDD 0.40237f
C12512 a_7498_18988# a_7941_19031# 0.02241f
C12513 sg13cmos5l_nand3_1_0.B sg13cmos5l_nand3_1_0.C 0.91691f
C12514 sg13cmos5l_a21oi_1_26.A1 sg13cmos5l_a21oi_1_24.A1 0.01929f
C12515 sg13cmos5l_inv_1_36.A a_13590_11484# 0.02051f
C12516 sg13cmos5l_inv_1_13.Y sg13cmos5l_buf_1_5.A 0.02053f
C12517 sg13cmos5l_a21oi_1_4.A1 sg13cmos5l_buf_1_57.A 0.97631f
C12518 sg13cmos5l_nand3_1_0.B a_16950_9972# 0.0109f
C12519 sg13cmos5l_buf_1_25.A code1 0.02469f
C12520 sg13cmos5l_buf_1_25.A sg13cmos5l_a21oi_1_24.A1 0.02323f
C12521 a_10811_4948# VDD 0.16217f
C12522 sg13cmos5l_nand4_1_12.Y sg13cmos5l_nand4_1_7.B 0.03667f
C12523 sg13cmos5l_buf_1_5.A sg13cmos5l_dlygate4sd3_1_18.X 0.0239f
C12524 sg13cmos5l_and4_1_1.A sg13cmos5l_o21ai_1_9.B1 0.01783f
C12525 a_18095_19847# a_18001_19847# 0.16704f
C12526 sg13cmos5l_nor4_1_1.D sg13cmos5l_mux2_1_0.S 0.4601f
C12527 sg13cmos5l_buf_1_24.A a_11288_19061# 0.02731f
C12528 sg13cmos5l_dfrbpq_1_19.CLK a_5303_18649# 0.03412f
C12529 sg13cmos5l_a21oi_1_26.Y sg13cmos5l_a21oi_1_24.A1 0.01583f
C12530 sg13cmos5l_a21oi_1_26.Y code1 0.01798f
C12531 sg13cmos5l_nor2_1_2.A clk 0.02679f
C12532 sg13cmos5l_inv_1_8.A sg13cmos5l_nor3_1_0.Y 0.01087f
C12533 a_13936_19262# a_13679_19381# 0.23043f
C12534 sg13cmos5l_buf_1_9.A bp7 0.1112f
C12535 sg13cmos5l_inv_1_1.Y a_19829_18556# 0.02731f
C12536 a_19169_18448# sg13cmos5l_dlygate4sd3_1_72.A 0.01956f
C12537 sg13cmos5l_buf_1_16.A sg13cmos5l_a21oi_1_24.Y 0.23009f
C12538 sg13cmos5l_buf_1_13.A sg13cmos5l_dfrbpq_1_47.D 0.41202f
C12539 sg13cmos5l_o21ai_1_5.A2 a_10895_12287# 0.02121f
C12540 sg13cmos5l_a21oi_1_5.A2 bp0 0.01172f
C12541 a_11489_17774# VDD 0.207f
C12542 sg13cmos5l_nand3_1_2.Y sg13cmos5l_inv_1_36.A 0.34094f
C12543 sg13cmos5l_o21ai_1_1.B1 sg13cmos5l_nor3_1_2.B 0.3956f
C12544 sg13cmos5l_a21o_1_2.X sg13cmos5l_and4_1_1.A 0.16283f
C12545 sg13cmos5l_inv_1_24.Y a_17051_15996# 0.03341f
C12546 a_11770_17472# VDD 0.28937f
C12547 sg13cmos5l_inv_1_2.A bp2 1.30654f
C12548 sg13cmos5l_dfrbpq_1_28.RESET_B sg13cmos5l_buf_1_57.A 0.64871f
C12549 sg13cmos5l_and2_1_3.X VDD 0.49533f
C12550 a_17872_5654# VDD 0.13615f
C12551 sg13cmos5l_nand3_1_8.Y bn8 0.19617f
C12552 a_18470_19458# a_18730_18988# 0.45119f
C12553 sg13cmos5l_buf_1_1.A a_22096_12430# 0.03083f
C12554 sg13cmos5l_a21oi_1_1.A2 a_19448_12214# 0.06493f
C12555 sg13cmos5l_buf_1_15.A sg13cmos5l_inv_1_20.Y 0.02937f
C12556 a_20384_16283# a_20716_16434# 0.07015f
C12557 sg13cmos5l_buf_1_57.A sg13cmos5l_mux2_1_1.A1 0.01034f
C12558 sg13cmos5l_dfrbpq_1_13.CLK a_9636_12528# 0.05551f
C12559 sg13cmos5l_a21oi_1_0.A2 sg13cmos5l_a21oi_1_7.A2 0.10399f
C12560 sg13cmos5l_nand4_1_0.C VDD 0.3365f
C12561 sg13cmos5l_dlygate4sd3_1_65.A sg13cmos5l_o21ai_1_15.Y 0.04108f
C12562 sg13cmos5l_dfrbpq_1_28.RESET_B sg13cmos5l_nand2_1_1.A 0.29217f
C12563 sg13cmos5l_o21ai_1_23.B1 bn5 0.0747f
C12564 sg13cmos5l_dfrbpq_1_28.D sg13cmos5l_nor3_1_7.Y 0.01203f
C12565 sg13cmos5l_buf_1_7.X sg13cmos5l_nand3_1_0.Y 0.05181f
C12566 sg13cmos5l_dfrbpq_1_37.D sg13cmos5l_inv_1_17.A 0.02994f
C12567 sg13cmos5l_nand4_1_18.A sg13cmos5l_nand4_1_18.C 0.78194f
C12568 sg13cmos5l_inv_1_2.A a_21099_4772# 0.02838f
C12569 a_6442_10666# VDD 0.90471f
C12570 sg13cmos5l_dfrbpq_1_24.RESET_B sg13cmos5l_dfrbpq_1_19.D 0.11856f
C12571 sg13cmos5l_inv_1_18.Y sg13cmos5l_nor4_1_0.Y 0.041f
C12572 sg13cmos5l_dfrbpq_1_5.CLK sg13cmos5l_a21oi_1_18.B1 0.02797f
C12573 a_16356_5416# a_16875_5423# 0.20754f
C12574 a_16773_5423# a_16644_5837# 0.01562f
C12575 sg13cmos5l_inv_1_13.Y sg13cmos5l_inv_1_12.Y 0.11818f
C12576 sg13cmos5l_dlygate4sd3_1_82.A sg13cmos5l_a21oi_1_18.B1 0.13545f
C12577 sg13cmos5l_inv_1_16.Y sg13cmos5l_dfrbpq_1_28.D 0.12119f
C12578 sg13cmos5l_buf_1_57.A bn1 0.01153f
C12579 a_20294_10386# a_21099_9959# 0.07916f
C12580 sg13cmos5l_a21oi_1_2.B1 a_21099_8447# 0.0284f
C12581 sg13cmos5l_nand3_1_0.B a_15804_7638# 0.01121f
C12582 sg13cmos5l_inv_1_1.Y a_19921_17869# 0.01342f
C12583 sg13cmos5l_mux2_1_0.A1 sg13cmos5l_dfrbpq_1_45.Q 0.03237f
C12584 a_7524_19024# a_8783_19381# 0.01412f
C12585 sg13cmos5l_buf_1_5.A sg13cmos5l_buf_1_9.A 0.01974f
C12586 sg13cmos5l_dlygate4sd3_1_54.A code4 0.11656f
C12587 sg13cmos5l_inv_1_1.Y sg13cmos5l_a21oi_1_6.Y 0.11092f
C12588 a_20580_8440# VDD 0.0721f
C12589 sg13cmos5l_buf_1_5.A a_18948_10711# 0.01195f
C12590 sg13cmos5l_o21ai_1_28.B1 sg13cmos5l_o21ai_1_23.A2 0.1734f
C12591 a_12140_19734# code5 0.16273f
C12592 a_9928_10034# clk 0.01107f
C12593 sg13cmos5l_nand2_1_12.A sg13cmos5l_nor2_1_16.Y 0.13077f
C12594 sg13cmos5l_dlygate4sd3_1_80.X a_13670_15238# 0.01643f
C12595 sg13cmos5l_nand3b_1_3.C bn4 0.01556f
C12596 a_21256_3900# bp2 0.19381f
C12597 sg13cmos5l_o21ai_1_18.B1 sg13cmos5l_dfrbpq_1_41.CLK 0.08243f
C12598 sg13cmos5l_a21o_1_0.X clk 0.12573f
C12599 a_14218_18226# busy 0.01216f
C12600 sg13cmos5l_inv_1_5.A VDD 1.85326f
C12601 sg13cmos5l_buf_1_30.A sg13cmos5l_nand3b_1_3.C 0.01117f
C12602 sg13cmos5l_nand3b_1_3.C sg13cmos5l_buf_1_66.X 0.026f
C12603 sg13cmos5l_dfrbpq_1_28.RESET_B a_18756_17512# 0.32215f
C12604 sg13cmos5l_dfrbpq_1_19.CLK sg13cmos5l_nor2_1_10.Y 0.0168f
C12605 a_17030_8874# VDD 0.52297f
C12606 a_14346_19020# sg13cmos5l_dfrbpq_1_44.Q 0.09449f
C12607 sg13cmos5l_a21oi_1_24.A1 a_13574_18262# 0.01028f
C12608 sg13cmos5l_dfrbpq_1_41.CLK sg13cmos5l_dfrbpq_1_28.RESET_B 0.03956f
C12609 sg13cmos5l_inv_1_4.Y bp4 0.08904f
C12610 a_16184_8477# VDD 0.28145f
C12611 sg13cmos5l_o21ai_1_5.A2 a_12987_12214# 0.07206f
C12612 sg13cmos5l_dfrbpq_1_5.CLK sg13cmos5l_buf_1_1.A 0.20934f
C12613 sg13cmos5l_dfrbpq_1_13.CLK sg13cmos5l_a21oi_1_2.B1 0.01948f
C12614 sg13cmos5l_dfrbpq_1_28.RESET_B sg13cmos5l_nand4_1_1.A 0.05762f
C12615 sg13cmos5l_buf_1_24.A sg13cmos5l_o21ai_1_15.B1 0.01395f
C12616 sg13cmos5l_a21oi_1_18.B1 sg13cmos5l_buf_1_1.A 0.0227f
C12617 a_5626_19738# sg13cmos5l_dfrbpq_1_20.Q 0.28817f
C12618 a_17547_15356# a_18544_15454# 0.03412f
C12619 a_12902_17508# VDD 0.23781f
C12620 a_20997_6935# bp2 0.02618f
C12621 sg13cmos5l_nand3b_1_0.C sg13cmos5l_buf_1_14.A 0.03549f
C12622 sg13cmos5l_dlygate4sd3_1_50.X a_3415_16710# 0.02016f
C12623 sg13cmos5l_nand2_1_13.A sg13cmos5l_nand2_1_19.A 0.02134f
C12624 a_15141_6141# a_15243_6284# 0.36168f
C12625 sg13cmos5l_dfrbpq_1_28.RESET_B sg13cmos5l_dlygate4sd3_1_72.A 0.09893f
C12626 sg13cmos5l_a21oi_1_1.A2 a_19534_13239# 0.0607f
C12627 sg13cmos5l_dlygate4sd3_1_15.X VDD 0.33458f
C12628 sg13cmos5l_inv_1_18.A sg13cmos5l_nor2b_1_0.B_N 0.26856f
C12629 sg13cmos5l_dfrbpq_1_15.CLK a_5643_9308# 0.04552f
C12630 sg13cmos5l_nand3b_1_3.C VDD 1.5627f
C12631 a_4182_19044# a_4070_19020# 0.3854f
C12632 a_19534_16263# VDD 0.16051f
C12633 sg13cmos5l_inv_1_16.A bn7 0.12572f
C12634 sg13cmos5l_o21ai_1_8.B1 a_8812_17044# 0.01313f
C12635 a_22235_5412# bp5 0.01269f
C12636 sg13cmos5l_o21ai_1_10.Y a_5686_16374# 0.06773f
C12637 sg13cmos5l_a21oi_1_4.A1 a_7446_14508# 0.06989f
C12638 sg13cmos5l_nor4_1_1.D sg13cmos5l_a21oi_1_12.A2 0.48424f
C12639 sg13cmos5l_o21ai_1_5.A1 sg13cmos5l_mux2_1_0.S 0.04629f
C12640 sg13cmos5l_or2_1_1.X a_12662_7656# 0.01731f
C12641 sg13cmos5l_inv_1_17.Y sg13cmos5l_inv_1_14.Y 0.35988f
C12642 a_11770_17472# a_12118_17886# 0.02803f
C12643 a_10214_10386# VDD 0.52444f
C12644 sg13cmos5l_dfrbpq_1_41.CLK bn1 0.0175f
C12645 sg13cmos5l_buf_1_57.A sg13cmos5l_nor3_1_4.A 0.01736f
C12646 sg13cmos5l_or2_1_1.X a_12414_7996# 0.01178f
C12647 sg13cmos5l_dlygate4sd3_1_4.A bp8 0.02105f
C12648 sg13cmos5l_inv_1_12.Y sg13cmos5l_buf_1_9.A 0.02097f
C12649 VDD sample 0.06934f
C12650 sg13cmos5l_dfrbpq_1_20.Q a_3776_18433# 0.10006f
C12651 sg13cmos5l_dfrbpq_1_7.D a_21745_10309# 0.01339f
C12652 a_11770_17472# sg13cmos5l_dlygate4sd3_1_69.A 0.29038f
C12653 sg13cmos5l_o21ai_1_23.B1 sg13cmos5l_buf_1_43.X 1.14411f
C12654 sg13cmos5l_buf_1_45.X busy 0.12567f
C12655 a_17872_5654# a_17615_5773# 0.23043f
C12656 sg13cmos5l_nor3_1_6.Y sg13cmos5l_dfrbpq_1_15.CLK 0.02308f
C12657 sg13cmos5l_a21oi_1_5.A2 a_19338_6924# 0.02377f
C12658 sg13cmos5l_dlygate4sd3_1_13.A sg13cmos5l_nor3_1_7.Y 0.01554f
C12659 sg13cmos5l_buf_1_45.X a_12134_19458# 0.08622f
C12660 sg13cmos5l_buf_1_45.X sg13cmos5l_nand4_1_7.B 0.02767f
C12661 a_21866_16276# bn6 0.02508f
C12662 a_20294_8874# a_20580_8440# 0.26205f
C12663 sg13cmos5l_nand4_1_18.B sg13cmos5l_dfrbpq_1_19.CLK 0.02895f
C12664 a_16474_18984# sg13cmos5l_a21oi_1_26.A1 0.01511f
C12665 sg13cmos5l_a21oi_1_0.A2 a_18778_6130# 0.06013f
C12666 sg13cmos5l_inv_1_31.A sg13cmos5l_dlygate4sd3_1_98.A 0.02408f
C12667 sg13cmos5l_dfrbpq_1_5.CLK bn9 0.14743f
C12668 sg13cmos5l_buf_1_53.A bn6 2.98402f
C12669 sg13cmos5l_a21o_1_0.A2 a_10917_9959# 0.02084f
C12670 sg13cmos5l_buf_1_4.A a_17804_4614# 0.02165f
C12671 a_22126_7863# VDD 0.15954f
C12672 a_20580_9952# a_21745_10309# 0.25046f
C12673 sg13cmos5l_a21oi_1_18.B1 bn9 0.08147f
C12674 a_20868_10373# a_21099_9959# 0.07823f
C12675 a_20997_14495# VDD 0.24573f
C12676 sg13cmos5l_a21oi_1_9.B1 sg13cmos5l_a21oi_1_11.Y 0.15243f
C12677 sg13cmos5l_dlygate4sd3_1_18.A sg13cmos5l_buf_1_13.X 0.17861f
C12678 a_5386_7897# VDD 0.09439f
C12679 sg13cmos5l_buf_1_45.X sg13cmos5l_nand4_1_3.B 0.04347f
C12680 a_20716_16746# a_21063_16964# 0.03546f
C12681 a_14152_14484# bn6 0.16046f
C12682 sg13cmos5l_a21oi_1_9.B1 sg13cmos5l_a21oi_1_9.A1 0.42902f
C12683 a_9040_19262# a_9450_19020# 0.07015f
C12684 sg13cmos5l_inv_1_3.Y a_17804_4614# 0.04777f
C12685 sg13cmos5l_o21ai_1_7.B1 a_4932_19024# 0.04964f
C12686 sg13cmos5l_buf_1_0.A a_20294_4650# 0.05079f
C12687 sg13cmos5l_buf_1_25.A sg13cmos5l_o21ai_1_28.B1 0.04328f
C12688 sg13cmos5l_nor4_1_0.C sg13cmos5l_nand2_1_6.A 0.01379f
C12689 sg13cmos5l_nand2_1_13.Y a_16954_11424# 0.27933f
C12690 sg13cmos5l_a21oi_1_9.B1 sg13cmos5l_nor3_1_1.Y 0.12378f
C12691 a_21839_8797# VDD 0.17223f
C12692 a_16474_18984# a_16193_19286# 0.18796f
C12693 sg13cmos5l_buf_1_26.A a_10696_15272# 0.19277f
C12694 a_4454_14922# VDD 0.52703f
C12695 sg13cmos5l_a21oi_1_18.B1 sg13cmos5l_inv_1_1.A 0.02798f
C12696 a_3776_18433# a_3584_18390# 0.01702f
C12697 sg13cmos5l_dfrbpq_1_13.RESET_B sg13cmos5l_a21oi_1_8.A2 0.04883f
C12698 sg13cmos5l_buf_1_15.A sg13cmos5l_a21oi_1_4.A2 0.99879f
C12699 a_6756_11464# a_7173_11471# 0.28418f
C12700 a_6470_11898# a_7044_11885# 0.18486f
C12701 sg13cmos5l_inv_1_9.Y a_17578_11428# 0.01469f
C12702 sg13cmos5l_inv_1_1.Y sg13cmos5l_buf_1_7.X 1.7301f
C12703 a_15692_18984# sg13cmos5l_dfrbpq_1_33.D 0.07987f
C12704 a_16474_18984# sg13cmos5l_a21oi_1_26.Y 0.31039f
C12705 sg13cmos5l_buf_1_42.A a_17002_15457# 0.03065f
C12706 sg13cmos5l_dlygate4sd3_1_29.X VDD 0.23688f
C12707 sg13cmos5l_nor2_1_2.B sg13cmos5l_nand2_1_6.A 1.82577f
C12708 sg13cmos5l_buf_1_43.X sg13cmos5l_a21oi_1_19.A2 0.10055f
C12709 a_14661_19749# VDD 0.24392f
C12710 sg13cmos5l_o21ai_1_7.B1 sg13cmos5l_dfrbpq_1_19.CLK 0.36796f
C12711 sg13cmos5l_a21oi_1_9.B1 sg13cmos5l_a21oi_1_9.Y 0.15482f
C12712 sg13cmos5l_dfrbpq_1_13.RESET_B sg13cmos5l_nor3_1_2.A 0.03233f
C12713 sg13cmos5l_buf_1_24.A a_10694_18258# 0.0445f
C12714 sg13cmos5l_a21oi_1_4.A1 sg13cmos5l_and2_1_5.X 0.33612f
C12715 bp9 bp8 0.0395f
C12716 sg13cmos5l_o21ai_1_20.Y a_3872_17594# 0.01054f
C12717 sg13cmos5l_dfrbpq_1_28.RESET_B a_19275_17519# 0.29447f
C12718 sg13cmos5l_o21ai_1_7.B1 sg13cmos5l_nor2_1_7.Y 0.02063f
C12719 sg13cmos5l_buf_1_24.A sg13cmos5l_o21ai_1_15.Y 0.28849f
C12720 a_15780_18576# code1 0.03483f
C12721 sg13cmos5l_a21oi_1_24.A1 a_15780_18576# 0.01162f
C12722 sg13cmos5l_dfrbpq_1_19.CLK a_4366_18258# 0.01498f
C12723 a_15607_9150# sg13cmos5l_buf_1_13.A 0.10884f
C12724 sg13cmos5l_nor3_1_2.C a_6682_8400# 0.04018f
C12725 sg13cmos5l_nand2b_1_1.A_N sg13cmos5l_buf_1_14.A 0.02297f
C12726 sg13cmos5l_dfrbpq_1_13.RESET_B a_5098_9409# 0.2038f
C12727 a_19342_10215# VDD 0.15841f
C12728 sg13cmos5l_buf_1_63.A sg13cmos5l_nand2_1_12.A 0.01595f
C12729 a_21473_5678# VDD 0.20802f
C12730 a_12216_17488# VDD 0.01784f
C12731 sg13cmos5l_inv_1_9.Y sg13cmos5l_o21ai_1_3.Y 0.1092f
C12732 a_18287_15311# a_18954_15532# 0.09257f
C12733 sg13cmos5l_a21oi_1_2.B1 a_17914_9912# 0.05569f
C12734 sg13cmos5l_a21oi_1_17.Y a_17608_13760# 0.2028f
C12735 sg13cmos5l_dfrbpq_1_15.CLK sg13cmos5l_nor2_1_2.B 0.30004f
C12736 a_14438_6162# a_15012_6175# 0.18486f
C12737 sg13cmos5l_buf_1_66.X sg13cmos5l_buf_1_65.A 0.05408f
C12738 sg13cmos5l_dfrbpq_1_15.CLK sg13cmos5l_nor3_1_2.Y 0.08771f
C12739 sg13cmos5l_buf_1_1.A bn9 0.19125f
C12740 sg13cmos5l_o21ai_1_1.B1 sg13cmos5l_o21ai_1_0.A2 0.05058f
C12741 sg13cmos5l_buf_1_21.A sg13cmos5l_nand3_1_2.A 0.22332f
C12742 sg13cmos5l_a21oi_1_17.Y a_17038_14751# 0.03509f
C12743 a_19173_19031# a_19921_19381# 0.01058f
C12744 sg13cmos5l_buf_1_45.X sg13cmos5l_buf_1_21.A 0.28147f
C12745 sg13cmos5l_nand4_1_18.A bp0 0.01591f
C12746 sg13cmos5l_buf_1_45.X sg13cmos5l_dfrbpq_1_33.D 0.09037f
C12747 sg13cmos5l_dlygate4sd3_1_8.X sg13cmos5l_a22oi_1_2.Y 0.02759f
C12748 sg13cmos5l_nand3_1_2.Y sg13cmos5l_nand4_1_3.B 0.09153f
C12749 sg13cmos5l_inv_1_1.A sg13cmos5l_buf_1_1.A 0.01506f
C12750 sg13cmos5l_dfrbpq_1_5.CLK sg13cmos5l_dfrbpq_1_35.Q 0.11552f
C12751 sg13cmos5l_buf_1_13.A sg13cmos5l_o21ai_1_0.A1 0.01775f
C12752 sg13cmos5l_nand3_1_6.C bn3 0.01963f
C12753 sg13cmos5l_buf_1_42.A sg13cmos5l_nand4_1_7.B 0.55447f
C12754 sg13cmos5l_buf_1_45.X a_12239_18335# 0.01612f
C12755 a_10112_10034# VDD 0.06951f
C12756 sg13cmos5l_nand3_1_0.A a_12120_8416# 0.01273f
C12757 sg13cmos5l_buf_1_15.A sg13cmos5l_buf_1_57.A 0.03182f
C12758 a_4744_19808# code6 0.16343f
C12759 sg13cmos5l_dfrbpq_1_20.Q a_4476_18222# 0.04075f
C12760 sg13cmos5l_buf_1_24.A sg13cmos5l_nand4_1_1.B 0.17535f
C12761 sg13cmos5l_inv_1_12.A a_21099_11471# 0.01894f
C12762 a_18282_5412# sg13cmos5l_dlygate4sd3_1_1.A 0.07665f
C12763 sg13cmos5l_buf_1_65.A VDD 1.46775f
C12764 sg13cmos5l_buf_1_45.X a_18352_19990# 0.09962f
C12765 sg13cmos5l_buf_1_42.A sg13cmos5l_nand4_1_3.B 0.12397f
C12766 a_8576_10901# VDD 0.30513f
C12767 sg13cmos5l_buf_1_26.A sg13cmos5l_nor2_1_12.Y 0.11866f
C12768 sg13cmos5l_mux2_1_1.A1 a_10812_14020# 0.01554f
C12769 sg13cmos5l_nand3b_1_1.Y sg13cmos5l_a21oi_1_12.Y 0.10511f
C12770 sg13cmos5l_o21ai_1_20.B1 a_6191_19381# 0.01676f
C12771 sg13cmos5l_o21ai_1_17.B1 a_10694_18258# 0.03085f
C12772 sg13cmos5l_dfrbpq_1_5.CLK a_22005_16904# 0.01767f
C12773 sg13cmos5l_nand2_1_13.A a_10053_12189# 0.01513f
C12774 a_20580_8440# a_20997_8447# 0.28418f
C12775 sg13cmos5l_inv_1_31.A a_21084_18222# 0.06906f
C12776 sg13cmos5l_buf_1_8.A a_20554_4873# 0.02447f
C12777 sg13cmos5l_o21ai_1_25.Y sg13cmos5l_a21oi_1_24.A1 0.021f
C12778 a_7620_9952# VDD 0.07228f
C12779 sg13cmos5l_nand2_1_15.B a_12896_13897# 0.05065f
C12780 sg13cmos5l_inv_1_13.Y sg13cmos5l_dlygate4sd3_1_18.A 0.02379f
C12781 sg13cmos5l_o21ai_1_11.Y a_6286_16263# 0.03443f
C12782 sg13cmos5l_nand3_1_5.Y sg13cmos5l_nor2_1_4.Y 0.03117f
C12783 a_3392_10034# VDD 0.07043f
C12784 sg13cmos5l_nand4_1_3.D bn6 0.02999f
C12785 sg13cmos5l_a21oi_1_18.B1 a_15754_18481# 0.03046f
C12786 sg13cmos5l_buf_1_24.A sg13cmos5l_dfrbpq_1_39.Q 0.08308f
C12787 sg13cmos5l_dfrbpq_1_24.RESET_B sg13cmos5l_dlygate4sd3_1_56.X 0.06307f
C12788 a_4108_18258# a_4455_18476# 0.03546f
C12789 sg13cmos5l_nand4_1_1.B a_15322_16714# 0.01221f
C12790 a_20890_15202# sg13cmos5l_a21oi_1_13.Y 0.28819f
C12791 sg13cmos5l_dfrbpq_1_35.D sg13cmos5l_buf_1_25.A 0.44246f
C12792 sg13cmos5l_nand3_1_0.Y a_16186_6888# 0.04447f
C12793 sg13cmos5l_nor4_1_2.Y sg13cmos5l_a21oi_1_4.A1 0.0182f
C12794 sg13cmos5l_o21ai_1_21.B1 a_4070_19020# 0.02149f
C12795 sg13cmos5l_o21ai_1_18.B1 bn3 0.03693f
C12796 sg13cmos5l_a21oi_1_17.Y a_17621_12972# 0.01235f
C12797 sg13cmos5l_inv_1_1.A bn9 0.0274f
C12798 sg13cmos5l_nand4_1_1.B sg13cmos5l_nor2_1_15.Y 0.01339f
C12799 sg13cmos5l_nand3_1_2.Y sg13cmos5l_buf_1_21.A 0.02085f
C12800 sg13cmos5l_inv_1_1.Y a_20554_6892# 0.02327f
C12801 sg13cmos5l_dfrbpq_1_24.RESET_B a_10510_19287# 0.01609f
C12802 sg13cmos5l_dfrbpq_1_24.RESET_B sg13cmos5l_o21ai_1_21.Y 0.05893f
C12803 sg13cmos5l_dfrbpq_1_28.RESET_B a_21080_17549# 0.01332f
C12804 a_5998_13911# a_6113_13912# 0.3854f
C12805 sg13cmos5l_nor4_1_1.D a_10914_14020# 0.02276f
C12806 sg13cmos5l_buf_1_15.A a_5032_9948# 0.20669f
C12807 sg13cmos5l_dfrbpq_1_19.CLK sg13cmos5l_buf_8_2.A 0.09775f
C12808 sg13cmos5l_a21oi_1_25.A2 VDD 0.57539f
C12809 sg13cmos5l_buf_8_2.A sg13cmos5l_nor2_1_7.Y 0.03603f
C12810 a_15436_7674# VDD 0.13633f
C12811 sg13cmos5l_buf_1_16.A a_18660_11016# 0.01202f
C12812 sg13cmos5l_a21oi_1_2.B1 sg13cmos5l_dlygate4sd3_1_2.A 0.17511f
C12813 sg13cmos5l_nor2_1_7.Y sg13cmos5l_a21o_1_2.B1 0.08346f
C12814 a_9322_19993# code5 0.02589f
C12815 sg13cmos5l_nand4_1_15.B sg13cmos5l_a21oi_1_16.A2 0.03106f
C12816 sg13cmos5l_nand4_1_3.B a_9446_13726# 0.01388f
C12817 sg13cmos5l_nor3_1_0.Y a_15405_11808# 0.2116f
C12818 a_16091_9948# VDD 0.17265f
C12819 sg13cmos5l_buf_1_15.A sg13cmos5l_dfrbpq_1_41.CLK 0.0257f
C12820 sg13cmos5l_nand4_1_15.B sg13cmos5l_nand2_1_9.Y 0.23252f
C12821 sg13cmos5l_nand4_1_15.B sg13cmos5l_inv_1_16.Y 0.02866f
C12822 sg13cmos5l_inv_1_20.Y a_15329_10214# 0.0126f
C12823 sg13cmos5l_a21o_1_2.A1 a_7334_14484# 0.04454f
C12824 sg13cmos5l_buf_1_13.X sg13cmos5l_buf_1_10.A 0.28132f
C12825 sg13cmos5l_inv_1_9.Y sg13cmos5l_dlygate4sd3_1_14.A 0.08513f
C12826 a_21350_17508# bn5 0.01623f
C12827 sg13cmos5l_dfrbpq_1_28.RESET_B sg13cmos5l_nor4_1_2.Y 0.04032f
C12828 a_12597_11722# a_12758_11826# 0.01261f
C12829 sg13cmos5l_dfrbpq_1_24.RESET_B a_4906_18988# 0.21609f
C12830 a_12837_19031# bn0 0.02935f
C12831 sg13cmos5l_inv_1_17.Y a_19829_14020# 0.0269f
C12832 sg13cmos5l_nor4_1_2.Y sg13cmos5l_mux2_1_1.A1 0.05484f
C12833 sg13cmos5l_o21ai_1_7.B1 a_6113_17774# 0.03647f
C12834 a_20294_14922# a_20554_14452# 0.45119f
C12835 sg13cmos5l_dlygate4sd3_1_69.A a_12216_17488# 0.01087f
C12836 sg13cmos5l_o21ai_1_7.B1 a_4744_19808# 0.19056f
C12837 sg13cmos5l_o21ai_1_5.A1 sg13cmos5l_inv_1_24.Y 0.87822f
C12838 sg13cmos5l_buf_1_15.A sg13cmos5l_dlygate4sd3_1_72.A 0.02824f
C12839 sg13cmos5l_nand4_1_18.B a_7524_19024# 0.01817f
C12840 sg13cmos5l_buf_1_25.A a_21080_19061# 0.01391f
C12841 sg13cmos5l_a21oi_1_24.A1 valid 0.23754f
C12842 bn4 bn2 0.02276f
C12843 bn3 bn1 0.02222f
C12844 valid code1 0.07219f
C12845 sg13cmos5l_a21oi_1_18.B1 sg13cmos5l_nand4_1_18.D 0.37016f
C12846 sg13cmos5l_buf_1_54.A sg13cmos5l_a21oi_1_4.A2 0.32446f
C12847 sg13cmos5l_inv_1_1.A sg13cmos5l_buf_1_2.A 0.01917f
C12848 a_6094_19959# code6 0.01529f
C12849 sg13cmos5l_buf_1_0.A bp3 0.01687f
C12850 a_16170_20068# code1 0.04635f
C12851 sg13cmos5l_dlygate4sd3_1_43.A VDD 0.24372f
C12852 sg13cmos5l_buf_1_26.A sg13cmos5l_nand2_1_12.Y 0.01059f
C12853 sg13cmos5l_mux2_1_0.S sg13cmos5l_dfrbpq_1_13.CLK 0.18111f
C12854 sg13cmos5l_buf_1_66.X bn2 0.14738f
C12855 a_16942_19287# sg13cmos5l_a21oi_1_19.Y 0.03412f
C12856 sg13cmos5l_buf_1_9.A a_20580_4968# 0.01129f
C12857 sg13cmos5l_dfrbpq_1_21.D a_6858_19020# 0.0184f
C12858 sg13cmos5l_buf_1_21.A sg13cmos5l_nand3_1_1.Y 0.11957f
C12859 sg13cmos5l_dfrbpq_1_28.D sg13cmos5l_a21oi_1_7.A2 0.88023f
C12860 sg13cmos5l_o21ai_1_25.Y a_13936_19262# 0.02296f
C12861 sg13cmos5l_buf_1_43.X sg13cmos5l_inv_1_12.A 0.0225f
C12862 sg13cmos5l_inv_1_1.Y bp4 0.07904f
C12863 sg13cmos5l_a21oi_1_13.Y sg13cmos5l_inv_1_17.Y 0.06323f
C12864 a_8879_10309# VDD 0.18739f
C12865 sg13cmos5l_a21oi_1_26.A1 a_15494_18258# 0.01425f
C12866 sg13cmos5l_a21oi_1_6.A2 sg13cmos5l_a21oi_1_0.A2 0.01549f
C12867 a_3296_16921# VDD 0.2867f
C12868 sg13cmos5l_nor4_1_2.Y bn1 0.01708f
C12869 sg13cmos5l_a21oi_1_16.A2 sg13cmos5l_a21oi_1_15.A2 0.02613f
C12870 sg13cmos5l_o21ai_1_5.A2 sg13cmos5l_a21oi_1_12.A2 0.04612f
C12871 sg13cmos5l_dfrbpq_1_17.Q VDD 0.55634f
C12872 sg13cmos5l_nor3_1_6.Y a_19048_12248# 0.01118f
C12873 a_18634_7897# a_18660_7992# 0.24169f
C12874 sg13cmos5l_dlygate4sd3_1_29.X a_18374_7674# 0.17065f
C12875 a_5931_7796# VDD 0.20526f
C12876 sg13cmos5l_o21ai_1_18.B1 sg13cmos5l_o21ai_1_18.A2 0.1369f
C12877 a_4476_18222# a_5397_18416# 0.24169f
C12878 sg13cmos5l_inv_1_16.Y sg13cmos5l_a21oi_1_15.A2 0.01572f
C12879 a_18106_17472# a_17825_17774# 0.18796f
C12880 a_8015_11821# a_8682_11460# 0.09257f
C12881 sg13cmos5l_a21oi_1_27.B1 a_9062_19770# 0.02735f
C12882 sg13cmos5l_nand4_1_18.B sg13cmos5l_a21oi_1_18.B1 0.04407f
C12883 VDD bn2 0.99989f
C12884 sg13cmos5l_nand3b_1_1.C sg13cmos5l_o21ai_1_22.B1 0.01629f
C12885 sg13cmos5l_inv_1_12.A a_15104_13058# 0.03045f
C12886 a_15208_12972# sg13cmos5l_nand2_1_1.Y 0.02354f
C12887 sg13cmos5l_dfrbpq_1_18.Q sg13cmos5l_nand2_1_13.A 0.01225f
C12888 sg13cmos5l_a21oi_1_26.Y a_15494_18258# 0.0408f
C12889 a_17710_17775# sg13cmos5l_buf_1_54.A 0.10711f
C12890 sg13cmos5l_a21o_1_1.A2 sg13cmos5l_o21ai_1_6.Y 0.13228f
C12891 sg13cmos5l_dfrbpq_1_24.RESET_B a_10625_19286# 0.02262f
C12892 sg13cmos5l_inv_1_36.A a_11393_13238# 0.01005f
C12893 sg13cmos5l_o21ai_1_20.Y a_4220_17488# 0.01087f
C12894 sg13cmos5l_inv_1_5.A a_17835_8447# 0.01842f
C12895 sg13cmos5l_buf_1_13.A a_16167_9404# 0.27971f
C12896 a_22126_6351# VDD 0.15969f
C12897 sg13cmos5l_o21ai_1_9.Y a_6835_13916# 0.01732f
C12898 sg13cmos5l_nand3_1_4.Y sg13cmos5l_a22oi_1_1.B2 0.18989f
C12899 a_17030_8874# a_17835_8447# 0.07916f
C12900 sg13cmos5l_inv_1_15.A a_19745_15424# 0.01343f
C12901 sg13cmos5l_a21oi_1_8.A2 sg13cmos5l_a21oi_1_8.Y 0.03352f
C12902 sg13cmos5l_inv_1_9.Y sg13cmos5l_dlygate4sd3_1_13.X 0.13006f
C12903 sg13cmos5l_dfrbpq_1_40.Q a_19642_19738# 0.01f
C12904 sg13cmos5l_inv_1_17.A bp3 0.08181f
C12905 sg13cmos5l_buf_1_54.A sg13cmos5l_buf_1_57.A 0.0189f
C12906 sg13cmos5l_buf_1_66.X a_12381_13912# 0.15471f
C12907 sg13cmos5l_nand3_1_0.A sg13cmos5l_nand3_1_0.Y 0.15773f
C12908 sg13cmos5l_nand4_1_1.B sg13cmos5l_buf_1_59.A 0.02548f
C12909 sg13cmos5l_dfrbpq_1_24.RESET_B a_4838_15238# 0.08605f
C12910 sg13cmos5l_a21oi_1_8.A2 a_7068_6126# 0.01625f
C12911 sg13cmos5l_dlygate4sd3_1_2.A a_22235_5412# 0.09934f
C12912 sg13cmos5l_inv_1_15.Y sg13cmos5l_inv_1_20.Y 0.05615f
C12913 a_20294_10386# VDD 0.52424f
C12914 sg13cmos5l_dfrbpq_1_13.RESET_B a_5643_9308# 0.28796f
C12915 sg13cmos5l_a21oi_1_27.B1 sg13cmos5l_o21ai_1_22.Y 0.0203f
C12916 sg13cmos5l_dlygate4sd3_1_50.X sg13cmos5l_o21ai_1_11.B1 0.01885f
C12917 sg13cmos5l_a21oi_1_3.Y a_17290_8404# 0.01466f
C12918 sg13cmos5l_o21ai_1_7.A2 a_7196_15552# 0.01045f
C12919 sg13cmos5l_inv_1_36.Y a_14446_12508# 0.0133f
C12920 sg13cmos5l_o21ai_1_10.A2 sg13cmos5l_o21ai_1_11.A2 0.03443f
C12921 sg13cmos5l_buf_1_14.A VDD 0.86587f
C12922 a_6209_19960# a_6490_19738# 0.18796f
C12923 sg13cmos5l_o21ai_1_7.Y sg13cmos5l_o21ai_1_11.Y 0.01437f
C12924 sg13cmos5l_dfrbpq_1_15.CLK a_6442_10666# 0.68577f
C12925 sg13cmos5l_o21ai_1_23.B1 sg13cmos5l_a21oi_1_19.A2 0.02599f
C12926 sg13cmos5l_dfrbpq_1_24.RESET_B a_6191_19381# 0.12405f
C12927 sg13cmos5l_buf_1_26.A a_17710_17775# 0.01238f
C12928 a_20554_13945# a_20580_14040# 0.24169f
C12929 sg13cmos5l_dlygate4sd3_1_43.X sg13cmos5l_nor2_1_2.A 0.05479f
C12930 sg13cmos5l_dlygate4sd3_1_76.X a_20294_13722# 0.16716f
C12931 a_13478_17946# a_14181_17519# 0.02431f
C12932 a_1690_9154# rst_n 0.29887f
C12933 a_12381_13912# VDD 0.19143f
C12934 sg13cmos5l_o21ai_1_5.A2 sg13cmos5l_inv_1_24.Y 0.15467f
C12935 a_20580_14488# a_20868_14909# 0.24435f
C12936 sg13cmos5l_nor3_1_6.Y sg13cmos5l_dfrbpq_1_13.RESET_B 0.0388f
C12937 sg13cmos5l_dlygate4sd3_1_72.A a_19066_15960# 0.28404f
C12938 sg13cmos5l_buf_1_66.X a_4823_17137# 0.01759f
C12939 a_15610_9912# VDD 0.26049f
C12940 sg13cmos5l_o21ai_1_7.B1 a_6094_19959# 0.12652f
C12941 sg13cmos5l_nand4_1_18.B a_8783_19381# 0.04238f
C12942 sg13cmos5l_inv_1_36.A sg13cmos5l_and4_1_1.A 1.04371f
C12943 sg13cmos5l_dfrbpq_1_37.D a_21084_16710# 0.0169f
C12944 sg13cmos5l_nor4_1_2.Y sg13cmos5l_nor3_1_4.A 0.25315f
C12945 sg13cmos5l_and2_1_3.X a_15597_12256# 0.0771f
C12946 sg13cmos5l_inv_1_17.Y sg13cmos5l_dfrbpq_1_28.D 0.06292f
C12947 sg13cmos5l_buf_1_26.A sg13cmos5l_buf_1_57.A 0.02052f
C12948 a_17057_19286# sg13cmos5l_a21oi_1_19.Y 0.03564f
C12949 sg13cmos5l_buf_1_26.A a_13478_17946# 0.01123f
C12950 sg13cmos5l_buf_1_15.A sg13cmos5l_and2_1_5.X 0.01066f
C12951 sg13cmos5l_dfrbpq_1_21.D a_7524_19024# 0.01296f
C12952 sg13cmos5l_o21ai_1_14.A1 VDD 0.61429f
C12953 a_7066_18226# sg13cmos5l_o21ai_1_14.Y 0.28404f
C12954 sg13cmos5l_a21oi_1_27.B1 sg13cmos5l_nand2_1_9.Y 0.09847f
C12955 a_21839_8797# a_22506_8436# 0.09257f
C12956 sg13cmos5l_nand2_1_13.A sg13cmos5l_nand2_1_19.Y 0.05471f
C12957 sg13cmos5l_a21oi_1_1.A2 sg13cmos5l_inv_1_14.Y 0.23755f
C12958 sg13cmos5l_inv_1_18.A sg13cmos5l_buf_1_10.A 0.14134f
C12959 sg13cmos5l_dfrbpq_1_13.CLK a_10500_9952# 0.10263f
C12960 a_18374_7674# a_18948_7687# 0.18486f
C12961 a_21084_18222# sg13cmos5l_inv_1_25.Y 0.05098f
C12962 sg13cmos5l_inv_1_1.A sg13cmos5l_nand4_1_18.D 0.10902f
C12963 VDD comp_clk 0.07223f
C12964 a_4823_17137# VDD 0.52376f
C12965 sg13cmos5l_dfrbpq_1_29.Q a_21911_16043# 0.01467f
C12966 a_18470_17946# a_18756_17512# 0.26205f
C12967 sg13cmos5l_o21ai_1_19.Y a_8060_17488# 0.01087f
C12968 sg13cmos5l_o21ai_1_26.B1 a_12420_19024# 0.0126f
C12969 a_10771_9380# a_11014_9508# 0.08536f
C12970 a_8682_11460# a_9056_11546# 0.01702f
C12971 a_22126_6351# a_22241_6352# 0.3854f
C12972 sg13cmos5l_inv_1_16.A sg13cmos5l_buf_1_13.X 0.03873f
C12973 a_14661_19749# a_14763_19892# 0.36168f
C12974 a_14244_20088# sg13cmos5l_dfrbpq_1_41.CLK 0.05552f
C12975 a_3895_18222# a_4366_18258# 0.16704f
C12976 a_4607_18528# a_5258_18416# 0.01562f
C12977 sg13cmos5l_dfrbpq_1_41.CLK sg13cmos5l_buf_1_54.A 0.35412f
C12978 sg13cmos5l_a21oi_1_3.A2 sg13cmos5l_dlygate4sd3_1_13.A 0.16346f
C12979 a_8734_12214# a_8848_12214# 0.03097f
C12980 sg13cmos5l_mux2_1_1.X a_9350_12210# 0.18837f
C12981 sg13cmos5l_buf_1_21.A a_10508_10662# 0.17833f
C12982 sg13cmos5l_buf_1_45.X sg13cmos5l_buf_1_47.X 0.02456f
C12983 sg13cmos5l_inv_1_1.Y a_20398_13239# 0.04696f
C12984 sg13cmos5l_a21oi_1_25.Y sg13cmos5l_nand4_1_12.Y 0.02033f
C12985 sg13cmos5l_inv_1_32.Y sg13cmos5l_o21ai_1_23.B1 0.014f
C12986 sg13cmos5l_inv_1_36.A sg13cmos5l_and2_1_6.A 0.03819f
C12987 sg13cmos5l_a21o_1_0.X a_10474_9916# 0.011f
C12988 sg13cmos5l_dlygate4sd3_1_72.A a_18470_17946# 0.02815f
C12989 sg13cmos5l_inv_1_5.A sg13cmos5l_inv_1_11.Y 0.06799f
C12990 sg13cmos5l_dlygate4sd3_1_50.X a_3592_19106# 0.01555f
C12991 sg13cmos5l_buf_1_13.A sg13cmos5l_dfrbpq_1_11.D 0.02583f
C12992 a_15935_7944# a_16586_7832# 0.01562f
C12993 a_17604_8861# a_17835_8447# 0.07823f
C12994 a_17316_8440# a_18481_8797# 0.25046f
C12995 sg13cmos5l_nand4_1_18.B sg13cmos5l_inv_1_1.A 0.46684f
C12996 sg13cmos5l_mux2_1_0.S sg13cmos5l_mux2_1_0.A1 0.53361f
C12997 sg13cmos5l_dfrbpq_1_13.RESET_B sg13cmos5l_nor2_1_2.B 0.22809f
C12998 sg13cmos5l_dfrbpq_1_41.CLK a_14181_17519# 0.24165f
C12999 sg13cmos5l_inv_1_5.A a_15783_7892# 0.05168f
C13000 sg13cmos5l_dfrbpq_1_1.D sg13cmos5l_a21oi_1_0.Y 0.41239f
C13001 sg13cmos5l_dfrbpq_1_13.RESET_B sg13cmos5l_nor3_1_2.Y 0.10195f
C13002 sg13cmos5l_nand4_1_6.B sg13cmos5l_nand4_1_1.C 0.3319f
C13003 sg13cmos5l_nand4_1_7.B a_10833_14874# 0.09474f
C13004 a_15692_18984# sg13cmos5l_o21ai_1_25.B1 0.19776f
C13005 bp2 bp1 0.08189f
C13006 sg13cmos5l_nand2_1_19.A sg13cmos5l_inv_1_8.A 0.2144f
C13007 sg13cmos5l_a21oi_1_9.A1 a_10864_5654# 0.01671f
C13008 sg13cmos5l_inv_1_32.Y a_13738_17476# 0.03075f
C13009 sg13cmos5l_inv_1_1.Y a_20176_10918# 0.02839f
C13010 a_11374_17775# bn3 0.03401f
C13011 sg13cmos5l_buf_1_66.X sg13cmos5l_o21ai_1_10.A2 0.04819f
C13012 sg13cmos5l_inv_1_32.Y a_13727_13992# 0.04047f
C13013 a_16954_11424# VDD 0.28568f
C13014 sg13cmos5l_dfrbpq_1_34.Q a_21953_19960# 0.0265f
C13015 sg13cmos5l_dfrbpq_1_5.CLK sg13cmos5l_buf_8_2.A 0.22691f
C13016 sg13cmos5l_buf_1_10.A sg13cmos5l_buf_1_9.A 0.06604f
C13017 sg13cmos5l_dfrbpq_1_35.Q a_21350_19020# 0.01623f
C13018 sg13cmos5l_a21oi_1_18.B1 sg13cmos5l_buf_8_2.A 0.17727f
C13019 sg13cmos5l_buf_1_26.A a_18756_17512# 0.03076f
C13020 sg13cmos5l_buf_1_5.A sg13cmos5l_dfrbpq_1_1.D 0.10465f
C13021 sg13cmos5l_buf_1_7.X a_16356_5416# 0.27759f
C13022 sg13cmos5l_nand3_1_2.A sg13cmos5l_nor3_1_0.Y 0.05709f
C13023 sg13cmos5l_inv_1_8.A sg13cmos5l_nor2_1_0.Y 0.10625f
C13024 sg13cmos5l_o21ai_1_3.Y sg13cmos5l_inv_1_5.A 0.02775f
C13025 sg13cmos5l_nand2_1_1.A a_17318_11898# 0.01263f
C13026 sg13cmos5l_dfrbpq_1_24.RESET_B a_7498_18988# 0.20795f
C13027 a_17518_10215# a_17633_10214# 0.3854f
C13028 sg13cmos5l_dfrbpq_1_41.CLK sg13cmos5l_buf_1_26.A 0.03266f
C13029 sg13cmos5l_a21oi_1_27.B1 sg13cmos5l_a21oi_1_24.A1 0.02393f
C13030 a_14181_17519# a_14052_17933# 0.01562f
C13031 a_13764_17512# a_14283_17519# 0.20754f
C13032 sg13cmos5l_buf_1_7.X sg13cmos5l_inv_1_8.Y 0.07827f
C13033 sg13cmos5l_nand2b_1_1.A_N a_12082_7302# 0.07554f
C13034 sg13cmos5l_o21ai_1_20.A1 sg13cmos5l_or4_1_1.X 0.19835f
C13035 a_14938_6888# VDD 0.25761f
C13036 sg13cmos5l_inv_1_3.Y a_17872_5654# 0.01104f
C13037 sg13cmos5l_a21oi_1_21.A1 a_17717_19020# 0.02731f
C13038 a_21099_14495# a_21839_14845# 0.17382f
C13039 sg13cmos5l_nor2_1_0.Y sg13cmos5l_a22oi_1_2.Y 0.01114f
C13040 sg13cmos5l_o21ai_1_10.A2 VDD 0.49809f
C13041 sg13cmos5l_o21ai_1_21.A2 a_4917_16904# 0.02053f
C13042 sg13cmos5l_dfrbpq_1_37.D a_21911_17137# 0.18521f
C13043 a_20294_14922# bn6 0.01174f
C13044 sg13cmos5l_buf_1_25.A sg13cmos5l_inv_1_15.A 0.01012f
C13045 a_3512_9989# a_3782_9948# 0.18796f
C13046 sg13cmos5l_buf_1_15.A sg13cmos5l_nor4_1_2.Y 1.95747f
C13047 sg13cmos5l_a21oi_1_27.B1 a_4064_15366# 0.02206f
C13048 sg13cmos5l_nand2b_1_1.A_N a_10709_6460# 0.07716f
C13049 sg13cmos5l_a21oi_1_21.A1 sg13cmos5l_buf_1_25.A 0.01537f
C13050 sg13cmos5l_dlygate4sd3_1_1.A a_19467_5423# 0.01086f
C13051 sg13cmos5l_a21oi_1_17.Y a_16478_15242# 0.01759f
C13052 sg13cmos5l_buf_1_45.X sg13cmos5l_o21ai_1_25.B1 0.0444f
C13053 sg13cmos5l_o21ai_1_20.B1 a_4476_18222# 0.02175f
C13054 sg13cmos5l_nand2b_1_1.A_N sg13cmos5l_a21oi_1_10.Y 0.0346f
C13055 sg13cmos5l_nand3b_1_3.C sg13cmos5l_o21ai_1_8.B1 0.01544f
C13056 sg13cmos5l_dfrbpq_1_13.CLK a_11019_9959# 0.05138f
C13057 sg13cmos5l_o21ai_1_0.A2 sg13cmos5l_o21ai_1_0.B1 0.15688f
C13058 a_9610_12433# VDD 0.09614f
C13059 sg13cmos5l_inv_1_15.Y sg13cmos5l_a21oi_1_4.A2 0.17412f
C13060 sg13cmos5l_nor3_1_7.Y a_18769_11821# 0.01615f
C13061 sg13cmos5l_a21o_1_2.X a_4714_14452# 0.01741f
C13062 sg13cmos5l_a21oi_1_6.Y a_19829_8436# 0.09932f
C13063 sg13cmos5l_nand2b_1_0.B sg13cmos5l_nand2b_1_3.B 0.06637f
C13064 a_18470_17946# a_19275_17519# 0.07916f
C13065 a_8734_12214# VDD 0.10378f
C13066 sg13cmos5l_o21ai_1_7.B1 a_5303_18649# 0.05672f
C13067 sg13cmos5l_o21ai_1_26.B1 a_13679_19381# 0.03881f
C13068 a_20513_4166# VDD 0.20575f
C13069 sg13cmos5l_nand2_1_0.B sg13cmos5l_and4_1_0.D 0.18724f
C13070 sg13cmos5l_o21ai_1_0.A2 a_11840_9389# 0.03266f
C13071 sg13cmos5l_o21ai_1_0.A2 a_12614_6166# 0.06552f
C13072 sg13cmos5l_buf_8_2.A sg13cmos5l_buf_1_1.A 0.02551f
C13073 sg13cmos5l_nand3_1_0.B sg13cmos5l_buf_1_9.A 0.01816f
C13074 sg13cmos5l_o21ai_1_0.A2 sg13cmos5l_a21oi_1_11.Y 0.02351f
C13075 a_1690_15202# start 0.29611f
C13076 sg13cmos5l_inv_1_16.A sg13cmos5l_inv_1_13.Y 0.01773f
C13077 sg13cmos5l_o21ai_1_0.A2 sg13cmos5l_a21oi_1_9.A1 0.21314f
C13078 a_22126_17775# VDD 0.15689f
C13079 a_10500_9952# a_11759_10309# 0.01412f
C13080 a_15494_18258# a_15780_18576# 0.26205f
C13081 sg13cmos5l_o21ai_1_0.A2 sg13cmos5l_nor3_1_1.Y 0.10566f
C13082 sg13cmos5l_inv_1_11.Y sg13cmos5l_dlygate4sd3_1_29.X 0.03536f
C13083 sg13cmos5l_inv_1_1.Y a_20580_12528# 0.05535f
C13084 sg13cmos5l_o21ai_1_18.B1 a_10118_18262# 0.01674f
C13085 sg13cmos5l_inv_1_16.A sg13cmos5l_dlygate4sd3_1_18.X 0.03418f
C13086 sg13cmos5l_buf_1_63.A a_12394_18988# 0.03032f
C13087 sg13cmos5l_o21ai_1_18.A2 a_8540_17488# 0.01038f
C13088 sg13cmos5l_inv_1_20.Y a_17043_12236# 0.01168f
C13089 sg13cmos5l_buf_1_63.A code1 0.0246f
C13090 sg13cmos5l_buf_1_63.A sg13cmos5l_a21oi_1_24.A1 0.02222f
C13091 a_18575_8797# a_18481_8797# 0.16704f
C13092 a_20225_19960# sg13cmos5l_buf_1_24.A 0.01077f
C13093 sg13cmos5l_o21ai_1_18.B1 sg13cmos5l_dlygate4sd3_1_55.X 0.04428f
C13094 sg13cmos5l_nor3_1_2.B sg13cmos5l_nor3_1_2.C 1.04207f
C13095 sg13cmos5l_dfrbpq_1_24.Q sg13cmos5l_dfrbpq_1_13.RESET_B 0.01422f
C13096 a_20580_6928# VDD 0.0733f
C13097 sg13cmos5l_o21ai_1_6.Y sg13cmos5l_nand3_1_4.Y 0.02837f
C13098 a_15607_9150# a_16078_9186# 0.16704f
C13099 sg13cmos5l_inv_1_5.A sg13cmos5l_inv_1_3.Y 0.1096f
C13100 a_8576_10901# sg13cmos5l_dlygate4sd3_1_38.X 0.18516f
C13101 sg13cmos5l_buf_1_15.A sg13cmos5l_o21ai_1_18.A2 0.14175f
C13102 a_8520_8436# sg13cmos5l_nor4_1_0.C 0.15596f
C13103 sg13cmos5l_a21oi_1_9.A1 a_12631_5376# 0.03448f
C13104 sg13cmos5l_dfrbpq_1_13.CLK a_18021_11471# 0.20148f
C13105 sg13cmos5l_nand2_1_11.B sg13cmos5l_nor4_1_1.D 0.02903f
C13106 sg13cmos5l_buf_1_25.A sg13cmos5l_o21ai_1_28.A1 0.02622f
C13107 sg13cmos5l_inv_1_9.Y a_17622_10766# 0.0186f
C13108 sg13cmos5l_dlygate4sd3_1_38.X a_7620_9952# 0.03076f
C13109 a_13686_18326# bn0 0.01435f
C13110 a_9646_6351# clk 0.0625f
C13111 sg13cmos5l_inv_1_15.Y sg13cmos5l_buf_1_57.A 0.02709f
C13112 sg13cmos5l_nand2b_1_0.B a_14230_7670# 0.0573f
C13113 sg13cmos5l_dfrbpq_1_24.RESET_B a_9040_19262# 0.10214f
C13114 sg13cmos5l_inv_1_31.A a_20384_16921# 0.01177f
C13115 a_14283_17519# a_15023_17869# 0.17382f
C13116 sg13cmos5l_dfrbpq_1_25.Q sg13cmos5l_o21ai_1_20.B1 0.16114f
C13117 sg13cmos5l_o21ai_1_5.A2 sg13cmos5l_nand2_1_18.A 0.06119f
C13118 a_7334_10386# a_7908_10373# 0.18486f
C13119 a_7620_9952# a_8037_9959# 0.28418f
C13120 sg13cmos5l_buf_8_2.A bn9 0.06571f
C13121 sg13cmos5l_dfrbpq_1_15.CLK a_8576_10901# 0.03959f
C13122 a_20580_14040# bn8 0.01354f
C13123 sg13cmos5l_nand4_1_15.B sg13cmos5l_a21oi_1_3.A2 0.02089f
C13124 a_20997_13701# a_21099_13844# 0.36168f
C13125 sg13cmos5l_inv_1_17.A bn5 0.02563f
C13126 sg13cmos5l_inv_1_17.A a_21099_11471# 0.02201f
C13127 a_16568_9989# a_16838_9948# 0.18796f
C13128 a_12414_7996# VDD 0.20593f
C13129 sg13cmos5l_buf_8_2.A sg13cmos5l_inv_1_1.A 0.94892f
C13130 sg13cmos5l_dfrbpq_1_15.CLK a_7620_9952# 0.06856f
C13131 a_21099_14495# bn6 0.02363f
C13132 sg13cmos5l_nor4_1_2.Y a_19066_15960# 0.01235f
C13133 sg13cmos5l_buf_1_20.A sg13cmos5l_nor4_1_1.D 0.01236f
C13134 sg13cmos5l_dlygate4sd3_1_43.X a_5829_7653# 0.02139f
C13135 sg13cmos5l_a21oi_1_7.A2 bp2 0.20221f
C13136 sg13cmos5l_a21oi_1_1.A2 a_19829_14020# 0.028f
C13137 sg13cmos5l_nand2b_1_0.B a_14465_10214# 0.04076f
C13138 sg13cmos5l_o21ai_1_26.B1 sg13cmos5l_buf_1_25.A 0.04277f
C13139 sg13cmos5l_buf_1_17.X a_3208_10034# 0.01367f
C13140 sg13cmos5l_dlygate4sd3_1_65.A sg13cmos5l_nor2b_1_1.A 0.01788f
C13141 sg13cmos5l_nor3_1_0.Y sg13cmos5l_nand3_1_1.Y 0.01945f
C13142 sg13cmos5l_a21oi_1_2.A2 sg13cmos5l_inv_1_7.Y 0.18212f
C13143 sg13cmos5l_dfrbpq_1_13.CLK a_12987_10318# 0.68888f
C13144 sg13cmos5l_buf_1_45.X sg13cmos5l_a21oi_1_25.Y 0.17842f
C13145 a_18922_5380# a_19365_5423# 0.02241f
C13146 code2 bn0 0.12573f
C13147 sg13cmos5l_nand4_1_3.B sg13cmos5l_and4_1_1.A 0.07905f
C13148 sg13cmos5l_buf_1_3.A bp9 1.6658f
C13149 sg13cmos5l_a21oi_1_5.A2 sg13cmos5l_inv_1_4.Y 0.02194f
C13150 sg13cmos5l_a21oi_1_18.B1 sg13cmos5l_buf_1_16.A 1.11152f
C13151 a_18756_17512# a_19921_17869# 0.25046f
C13152 sg13cmos5l_nand4_1_18.B sg13cmos5l_nand4_1_18.D 0.49102f
C13153 sg13cmos5l_o21ai_1_7.B1 code6 0.68806f
C13154 a_22241_4166# VDD 0.20327f
C13155 a_15503_19847# code2 0.04501f
C13156 a_14763_19892# bn2 0.04764f
C13157 sg13cmos5l_dfrbpq_1_28.D sg13cmos5l_a21oi_1_2.A2 0.02777f
C13158 sg13cmos5l_buf_1_7.X a_18660_7992# 0.30294f
C13159 a_8122_8400# VDD 0.26214f
C13160 a_13409_16936# a_13690_16714# 0.18796f
C13161 sg13cmos5l_o21ai_1_21.B1 a_4607_18528# 0.01646f
C13162 a_11019_9959# a_11759_10309# 0.17382f
C13163 sg13cmos5l_a21oi_1_3.A2 sg13cmos5l_a21oi_1_15.A2 0.12828f
C13164 a_15706_13342# sg13cmos5l_dlygate4sd3_1_13.A 0.01559f
C13165 sg13cmos5l_buf_1_63.A a_19246_19959# 0.01022f
C13166 sg13cmos5l_buf_1_65.A a_10710_14020# 0.01484f
C13167 sg13cmos5l_buf_1_2.A a_20554_4873# 0.02951f
C13168 sg13cmos5l_inv_1_2.A a_20580_8440# 0.09761f
C13169 sg13cmos5l_nor3_1_6.Y sg13cmos5l_nor3_1_7.Y 0.06552f
C13170 sg13cmos5l_inv_1_3.Y a_17715_7700# 0.01159f
C13171 sg13cmos5l_a21oi_1_6.A2 sg13cmos5l_dfrbpq_1_28.D 0.06791f
C13172 sg13cmos5l_dfrbpq_1_28.RESET_B a_20503_16710# 0.10898f
C13173 a_9885_7194# a_9967_7294# 0.01126f
C13174 a_19718_12214# VDD 0.20527f
C13175 a_17318_11898# a_17604_11464# 0.26205f
C13176 sg13cmos5l_inv_1_15.A sg13cmos5l_dfrbpq_1_28.D 0.02084f
C13177 sg13cmos5l_dfrbpq_1_47.D a_13212_5773# 0.01729f
C13178 sg13cmos5l_a21oi_1_25.Y a_16299_18380# 0.02025f
C13179 sg13cmos5l_buf_1_20.A a_11562_12508# 0.04635f
C13180 sg13cmos5l_buf_1_45.X sg13cmos5l_o21ai_1_24.Y 0.22694f
C13181 a_21099_6935# VDD 0.20626f
C13182 sg13cmos5l_inv_1_9.Y sg13cmos5l_nor3_1_7.Y 0.01283f
C13183 sg13cmos5l_dlygate4sd3_1_43.A sg13cmos5l_nand2_1_6.A 0.02924f
C13184 a_13768_14484# busy 0.1566f
C13185 a_11288_19061# VDD 0.25792f
C13186 sg13cmos5l_dfrbpq_1_41.CLK sg13cmos5l_inv_1_15.Y 0.02152f
C13187 sg13cmos5l_inv_1_24.Y sg13cmos5l_mux2_1_0.A1 0.02115f
C13188 sg13cmos5l_a21oi_1_24.Y a_19173_17519# 0.01582f
C13189 sg13cmos5l_buf_1_54.A sg13cmos5l_nor4_1_2.Y 0.02961f
C13190 sg13cmos5l_inv_1_15.Y sg13cmos5l_nand4_1_1.A 0.02769f
C13191 a_19642_19738# sg13cmos5l_a21oi_1_25.Y 0.28821f
C13192 sg13cmos5l_dfrbpq_1_13.RESET_B a_6442_10666# 0.10686f
C13193 sg13cmos5l_nor3_1_6.Y sg13cmos5l_inv_1_16.Y 0.10288f
C13194 sg13cmos5l_nand3_1_8.Y VDD 0.75973f
C13195 sg13cmos5l_a21oi_1_16.A2 sg13cmos5l_inv_1_9.Y 0.11919f
C13196 sg13cmos5l_dfrbpq_1_11.Q a_19457_10214# 0.04001f
C13197 sg13cmos5l_buf_1_45.X a_14517_13880# 0.22476f
C13198 a_15223_7638# a_15804_7638# 0.01412f
C13199 a_15436_7674# a_15783_7892# 0.03546f
C13200 sg13cmos5l_nand3_1_0.C a_16631_8065# 0.03987f
C13201 a_15023_16357# bn5 0.01263f
C13202 sg13cmos5l_buf_1_16.A sg13cmos5l_buf_1_1.A 0.77394f
C13203 a_19179_10820# VDD 0.20605f
C13204 sg13cmos5l_buf_1_26.A bn3 0.4128f
C13205 a_15023_17869# sg13cmos5l_dfrbpq_1_38.Q 0.01053f
C13206 sg13cmos5l_nand4_1_1.C VDD 1.16524f
C13207 sg13cmos5l_nor2_1_2.B sg13cmos5l_a21oi_1_8.Y 0.09951f
C13208 sg13cmos5l_dlygate4sd3_1_45.X sg13cmos5l_mux2_1_0.A1 0.01246f
C13209 sg13cmos5l_buf_1_24.A bn0 0.02085f
C13210 sg13cmos5l_nor3_1_2.A sg13cmos5l_dlygate4sd3_1_42.A 0.03171f
C13211 sg13cmos5l_dfrbpq_1_24.RESET_B a_4476_18222# 0.28756f
C13212 sg13cmos5l_dfrbpq_1_15.CLK sg13cmos5l_dlygate4sd3_1_43.A 0.01033f
C13213 a_17510_10702# VDD 0.20646f
C13214 sg13cmos5l_nand4_1_8.B sg13cmos5l_nand2_1_9.Y 0.01062f
C13215 sg13cmos5l_nand4_1_1.B sg13cmos5l_nand4_1_6.B 0.01897f
C13216 sg13cmos5l_nor2_1_2.B a_7068_6126# 0.04119f
C13217 sg13cmos5l_nand4_1_8.B sg13cmos5l_inv_1_16.Y 0.01468f
C13218 a_4727_16043# a_5686_16374# 0.02349f
C13219 a_12188_6904# VDD 0.01874f
C13220 sg13cmos5l_inv_1_17.Y bp2 0.03034f
C13221 sg13cmos5l_buf_1_66.X sg13cmos5l_o21ai_1_10.Y 0.02027f
C13222 bn6 bn7 0.09144f
C13223 a_4070_19020# VDD 0.20666f
C13224 sg13cmos5l_nand4_1_17.Y sg13cmos5l_nand4_1_1.B 0.03155f
C13225 sg13cmos5l_a21o_1_2.B1 a_6835_13916# 0.14346f
C13226 a_11670_19044# sg13cmos5l_inv_1_25.Y 0.01054f
C13227 sg13cmos5l_buf_1_53.A sg13cmos5l_a21oi_1_20.A2 0.01713f
C13228 sg13cmos5l_dfrbpq_1_15.CLK a_5931_7796# 0.07909f
C13229 sg13cmos5l_nand2_1_11.B sg13cmos5l_o21ai_1_5.A1 0.01659f
C13230 sg13cmos5l_inv_1_31.A sg13cmos5l_a21oi_1_24.A1 0.3806f
C13231 sg13cmos5l_inv_1_1.A sg13cmos5l_a21oi_1_15.Y 0.02189f
C13232 a_18948_5416# a_20207_5773# 0.01412f
C13233 a_11674_6130# VDD 0.26431f
C13234 sg13cmos5l_buf_1_21.A sg13cmos5l_and2_1_6.A 0.06309f
C13235 sg13cmos5l_inv_1_8.A a_15496_5498# 0.01676f
C13236 sg13cmos5l_inv_1_36.Y sg13cmos5l_inv_1_18.A 0.01613f
C13237 sg13cmos5l_o21ai_1_26.B1 a_13574_18262# 0.01235f
C13238 sg13cmos5l_a21oi_1_4.A1 sg13cmos5l_dfrbpq_1_45.D 0.015f
C13239 sg13cmos5l_o21ai_1_20.A1 sg13cmos5l_o21ai_1_18.A2 0.04904f
C13240 sg13cmos5l_a21oi_1_1.A2 sg13cmos5l_dfrbpq_1_28.D 0.01814f
C13241 a_20272_17750# a_20682_17508# 0.07015f
C13242 sg13cmos5l_o21ai_1_10.Y VDD 0.28946f
C13243 sg13cmos5l_nor2_1_15.Y bn0 0.01797f
C13244 a_21256_3176# VDD 0.17829f
C13245 a_10709_6460# VDD 0.17492f
C13246 sg13cmos5l_a21oi_1_9.A2 sg13cmos5l_dlygate4sd3_1_7.X 0.03045f
C13247 sg13cmos5l_dlygate4sd3_1_64.X a_5222_17508# 0.02121f
C13248 sg13cmos5l_buf_1_10.A a_15480_8752# 0.01193f
C13249 sg13cmos5l_buf_1_66.X sg13cmos5l_dfrbpq_1_23.D 0.02678f
C13250 sg13cmos5l_inv_1_12.Y a_19995_9190# 0.01376f
C13251 sg13cmos5l_a21oi_1_5.A2 sg13cmos5l_nand3_1_0.Y 0.04526f
C13252 sg13cmos5l_a21oi_1_10.Y VDD 0.27327f
C13253 sg13cmos5l_buf_1_7.X a_19919_7751# 0.14998f
C13254 a_19035_16750# VDD 0.88743f
C13255 sg13cmos5l_nor2_1_10.Y sg13cmos5l_buf_8_2.A 0.03836f
C13256 a_9077_6460# VDD 0.18166f
C13257 a_16197_18237# a_16945_18335# 0.01058f
C13258 a_17296_18478# a_17706_18556# 0.07015f
C13259 sg13cmos5l_a21oi_1_27.A1 a_10461_11730# 0.18991f
C13260 sg13cmos5l_nand3_1_3.Y a_10990_8052# 0.01684f
C13261 sg13cmos5l_o21ai_1_5.A1 sg13cmos5l_buf_1_20.A 0.21326f
C13262 sg13cmos5l_buf_1_16.A sg13cmos5l_inv_1_1.A 0.0418f
C13263 sg13cmos5l_buf_1_43.X sg13cmos5l_a21oi_1_20.Y 0.11573f
C13264 sg13cmos5l_nand4_1_3.B a_18104_14850# 0.01168f
C13265 sg13cmos5l_o21ai_1_18.B1 a_11397_18237# 0.01574f
C13266 sg13cmos5l_a21oi_1_1.A2 a_19246_6351# 0.03749f
C13267 sg13cmos5l_o21ai_1_17.B1 bn0 0.02098f
C13268 sg13cmos5l_buf_1_59.A a_14926_16935# 0.11125f
C13269 a_20794_12936# VDD 0.25498f
C13270 a_13862_6166# a_13343_5383# 0.01281f
C13271 sg13cmos5l_o21ai_1_18.B1 sg13cmos5l_nand3b_1_1.Y 0.03486f
C13272 sg13cmos5l_dlygate4sd3_1_3.A VDD 0.37191f
C13273 sg13cmos5l_o21ai_1_14.A1 a_9734_17508# 0.01156f
C13274 sg13cmos5l_dfrbpq_1_25.Q sg13cmos5l_dfrbpq_1_24.RESET_B 0.01625f
C13275 sg13cmos5l_dfrbpq_1_23.D VDD 0.33466f
C13276 a_16188_9150# a_16970_9344# 0.24435f
C13277 sg13cmos5l_a21oi_1_6.A2 sg13cmos5l_dlygate4sd3_1_13.A 0.03258f
C13278 sg13cmos5l_buf_1_59.A a_13294_16935# 0.02231f
C13279 sg13cmos5l_o21ai_1_19.Y sg13cmos5l_o21ai_1_7.A2 0.05425f
C13280 sg13cmos5l_o21ai_1_18.B1 a_12420_19024# 0.02245f
C13281 sg13cmos5l_nand2_1_1.Y a_16954_10702# 0.0149f
C13282 a_20503_18222# a_20015_17869# 0.01283f
C13283 sg13cmos5l_buf_8_2.A sg13cmos5l_nand4_1_18.D 0.02163f
C13284 sg13cmos5l_dfrbpq_1_13.RESET_B a_10214_10386# 0.08678f
C13285 sg13cmos5l_dfrbpq_1_13.Q a_11274_5412# 0.07596f
C13286 a_6113_13912# a_6021_12983# 0.01281f
C13287 sg13cmos5l_o21ai_1_14.Y a_7858_16742# 0.03469f
C13288 sg13cmos5l_inv_1_8.A a_15104_13058# 0.02284f
C13289 sg13cmos5l_o21ai_1_15.B1 VDD 0.43649f
C13290 a_21254_10702# VDD 0.20773f
C13291 a_15804_7638# a_16631_8065# 0.26205f
C13292 sg13cmos5l_inv_1_2.A a_21473_5678# 0.05302f
C13293 sg13cmos5l_buf_1_21.A clk 0.13401f
C13294 sg13cmos5l_o21ai_1_13.B1 a_10510_19287# 0.12264f
C13295 sg13cmos5l_nand4_1_16.D bn5 0.01829f
C13296 sg13cmos5l_o21ai_1_13.B1 code4 0.02088f
C13297 a_20586_10996# VDD 0.27612f
C13298 sg13cmos5l_dfrbpq_1_5.CLK a_20294_11898# 0.01079f
C13299 a_17296_18478# valid 0.01174f
C13300 a_8879_10309# a_9546_9948# 0.09257f
C13301 sg13cmos5l_a21oi_1_21.A1 sg13cmos5l_o21ai_1_25.Y 0.01437f
C13302 sg13cmos5l_inv_1_15.Y sg13cmos5l_dfrbpq_1_3.D 0.01014f
C13303 a_6286_16263# sg13cmos5l_o21ai_1_12.Y 0.01293f
C13304 sg13cmos5l_dfrbpq_1_13.RESET_B a_5386_7897# 0.2001f
C13305 a_17126_7362# VDD 0.52533f
C13306 a_3296_16921# a_3415_16710# 0.09257f
C13307 sg13cmos5l_nand2b_1_1.A_N a_14561_9376# 0.0147f
C13308 a_20384_18433# a_20716_18258# 0.07015f
C13309 a_15968_14570# VDD 0.07864f
C13310 sg13cmos5l_a21oi_1_17.Y sg13cmos5l_dlygate4sd3_1_13.A 0.49008f
C13311 sg13cmos5l_dfrbpq_1_34.Q sg13cmos5l_buf_1_24.A 0.02931f
C13312 sg13cmos5l_dlygate4sd3_1_4.A sg13cmos5l_dfrbpq_1_0.D 0.11617f
C13313 sg13cmos5l_dlygate4sd3_1_3.A bp6 0.02871f
C13314 sg13cmos5l_buf_1_16.A sg13cmos5l_dlygate4sd3_1_77.A 0.30964f
C13315 sg13cmos5l_a21oi_1_4.B1 VDD 0.176f
C13316 sg13cmos5l_nand4_1_18.B sg13cmos5l_buf_8_2.A 0.31771f
C13317 sg13cmos5l_nor4_1_1.D a_8879_15238# 0.02596f
C13318 sg13cmos5l_nor3_1_2.A sg13cmos5l_dfrbpq_1_15.Q 0.05361f
C13319 sg13cmos5l_inv_1_8.A sg13cmos5l_nand2_1_19.Y 0.12231f
C13320 a_17253_19749# a_17124_19783# 0.01562f
C13321 a_20874_5412# a_21358_5679# 0.01641f
C13322 a_5412_7992# a_6671_7751# 0.01412f
C13323 a_21462_17532# a_21920_17594# 0.01604f
C13324 sg13cmos5l_nand2_1_11.B sg13cmos5l_o21ai_1_5.A2 0.52559f
C13325 sg13cmos5l_dfrbpq_1_28.RESET_B a_19745_15424# 0.06116f
C13326 a_20464_5654# a_20874_5412# 0.07015f
C13327 sg13cmos5l_dfrbpq_1_24.RESET_B a_4682_16276# 0.01103f
C13328 sg13cmos5l_dlygate4sd3_1_81.X VDD 0.19489f
C13329 a_13592_6166# VDD 0.29577f
C13330 sg13cmos5l_dlygate4sd3_1_14.A a_16091_9948# 0.09934f
C13331 sg13cmos5l_a21oi_1_20.A2 sg13cmos5l_nand4_1_3.D 0.02162f
C13332 sg13cmos5l_buf_1_3.A a_19336_3176# 0.0278f
C13333 sg13cmos5l_buf_8_2.A code0 0.14768f
C13334 sg13cmos5l_a21oi_1_2.Y a_20580_6928# 0.04483f
C13335 sg13cmos5l_a21oi_1_18.B1 sg13cmos5l_buf_1_53.A 0.01431f
C13336 sg13cmos5l_o21ai_1_20.Y a_3800_19061# 0.32489f
C13337 a_14350_10215# a_14465_10214# 0.3854f
C13338 a_16556_15960# VDD 0.18331f
C13339 sg13cmos5l_nand2b_1_1.A_N sg13cmos5l_nand2b_1_4.B 0.22773f
C13340 sg13cmos5l_o21ai_1_22.Y sg13cmos5l_o21ai_1_21.A2 0.02033f
C13341 sg13cmos5l_dfrbpq_1_8.D a_20294_7362# 0.16755f
C13342 sg13cmos5l_dfrbpq_1_28.RESET_B a_16742_15234# 0.08358f
C13343 a_19430_9190# a_19542_9254# 0.3854f
C13344 sg13cmos5l_o21ai_1_5.A2 sg13cmos5l_buf_1_20.A 0.76237f
C13345 a_17706_18556# sg13cmos5l_dfrbpq_1_33.Q 0.09455f
C13346 a_15760_19990# a_16170_20068# 0.07015f
C13347 sg13cmos5l_o21ai_1_9.A2 a_5554_13718# 0.04812f
C13348 a_6670_18447# a_6785_18448# 0.3854f
C13349 sg13cmos5l_nand2_1_9.Y sg13cmos5l_inv_1_25.Y 0.02448f
C13350 sg13cmos5l_buf_1_59.A bn0 0.16599f
C13351 sg13cmos5l_nand3b_1_3.C sg13cmos5l_o21ai_1_11.B1 0.03142f
C13352 a_17892_11885# a_18123_11471# 0.07823f
C13353 sg13cmos5l_buf_1_63.A sg13cmos5l_dfrbpq_1_35.D 0.01029f
C13354 a_22784_13058# VDD 0.07033f
C13355 a_10694_18258# VDD 0.52297f
C13356 sg13cmos5l_buf_1_15.A a_9348_20088# 0.29671f
C13357 a_9322_19993# a_9765_19749# 0.02241f
C13358 sg13cmos5l_o21ai_1_0.A1 a_12022_8814# 0.02589f
C13359 bn9 VSS 1.25767f
C13360 bp3 VSS 1.26844f
C13361 bp5 VSS 0.77888f
C13362 bp4 VSS 0.66102f
C13363 bp7 VSS 0.53778f
C13364 bp8 VSS 0.6457f
C13365 sample VSS 1.92521f
C13366 comp_clk VSS 1.37167f
C13367 bp1 VSS 1.41884f
C13368 bp2 VSS 1.02295f
C13369 bp6 VSS 0.941f
C13370 bp9 VSS 0.56677f
C13371 bn8 VSS 0.75103f
C13372 bn7 VSS 0.58721f
C13373 bp0 VSS 0.66598f
C13374 code0 VSS 1.79004f
C13375 bn5 VSS 0.57965f
C13376 bn6 VSS 0.69916f
C13377 busy VSS 2.45728f
C13378 bn0 VSS 4.80955f
C13379 bn1 VSS 2.247f
C13380 bn2 VSS 1.83779f
C13381 code1 VSS 1.82311f
C13382 valid VSS 2.57547f
C13383 bn4 VSS 2.06516f
C13384 bn3 VSS 1.39545f
C13385 code2 VSS 1.33874f
C13386 code3 VSS 1.38512f
C13387 code5 VSS 1.88529f
C13388 code4 VSS 1.60602f
C13389 code6 VSS 1.96029f
C13390 code7 VSS 1.79182f
C13391 code8 VSS 1.76177f
C13392 code9 VSS 1.86924f
C13393 VDD VSS 0.24926p
C13394 a_22522_3106# VSS 0.31663f
C13395 a_21640_3176# VSS 0.0339f
C13396 a_20104_3176# VSS 0.02964f
C13397 a_19720_3176# VSS 0.01854f
C13398 a_19336_3176# VSS 0.07627f
C13399 a_22522_3864# VSS 0.08627f
C13400 a_21152_3986# VSS 0.04244f ; **FLOATING
C13401 a_19829_3900# VSS 0.61314f
C13402 a_21256_3900# VSS 0.03623f
C13403 a_20513_4166# VSS 0.07159f
C13404 a_19923_4248# VSS 0.89951f
C13405 sg13cmos5l_inv_1_0.A VSS 0.07315f
C13406 sg13cmos5l_inv_1_2.Y VSS 0.11022f
C13407 a_17704_3986# VSS 0.0988f ; **FLOATING
C13408 sg13cmos5l_inv_1_7.Y VSS 0.05383f
C13409 a_22258_4650# VSS 0.1385f
C13410 a_21745_4727# VSS 0.21189f
C13411 a_20806_4663# VSS 0.07309f
C13412 a_20868_4663# VSS 0.31931f
C13413 a_20388_4650# VSS 0.03995f
C13414 a_20937_5041# VSS 0.50248f
C13415 a_20294_4650# VSS 0.25642f
C13416 a_19328_4782# VSS 0.04506f ; **FLOATING
C13417 a_18689_4676# VSS 0.48391f
C13418 sg13cmos5l_buf_1_6.A VSS 0.17185f
C13419 a_18587_4948# VSS 0.91106f
C13420 a_18188_4614# VSS 0.03978f
C13421 a_13042_4646# VSS 0.40581f
C13422 a_12712_4782# VSS 0.08917f ; **FLOATING
C13423 a_11394_4658# VSS 0.01244f
C13424 a_11292_4658# VSS 0.08795f
C13425 a_10913_4676# VSS 0.01131f
C13426 a_10592_4782# VSS 0.05008f ; **FLOATING
C13427 a_8620_4948# VSS 0.9375f
C13428 a_8296_4782# VSS 0.08696f ; **FLOATING
C13429 a_22235_5412# VSS 0.02413f
C13430 a_20409_5535# VSS 0.20634f
C13431 a_22337_5760# VSS 1.23111f
C13432 sg13cmos5l_dfrbpq_1_0.D VSS 0.08616f
C13433 sg13cmos5l_dlygate4sd3_1_2.A VSS 0.43359f
C13434 sg13cmos5l_dlygate4sd3_1_4.A VSS 0.09895f
C13435 a_20626_5850# VSS 0.13858f
C13436 a_20113_5773# VSS 0.21081f
C13437 a_20874_5412# VSS 0.10317f
C13438 a_19236_5837# VSS 0.56044f
C13439 a_19174_5837# VSS 0.52378f
C13440 a_18756_5850# VSS 0.17775f
C13441 a_18662_5850# VSS 0.3012f
C13442 a_16713_5459# VSS 0.50343f
C13443 a_18034_5850# VSS 0.25229f
C13444 a_17521_5773# VSS 0.4901f
C13445 a_16644_5837# VSS 0.17804f
C13446 a_16582_5837# VSS 0.04481f
C13447 a_16164_5850# VSS 0.59241f
C13448 a_16070_5850# VSS 0.73434f
C13449 a_15680_5498# VSS 0.03831f ; **FLOATING
C13450 a_15496_5498# VSS 0.08356f ; **FLOATING
C13451 sg13cmos5l_inv_1_5.Y VSS 0.10215f
C13452 a_15016_5498# VSS 0.08428f ; **FLOATING
C13453 a_14235_5459# VSS 0.24041f
C13454 a_14786_5850# VSS 0.25056f
C13455 a_14039_5459# VSS 0.39574f
C13456 a_14390_5837# VSS 0.51364f
C13457 a_13994_5692# VSS 0.66151f
C13458 a_12029_5412# VSS 0.03934f
C13459 a_13102_5850# VSS 0.14613f
C13460 a_12938_5850# VSS 0.07362f
C13461 a_11840_5498# VSS 0.03744f ; **FLOATING
C13462 a_11656_5498# VSS 0.08027f ; **FLOATING
C13463 a_13212_5773# VSS 0.21852f
C13464 a_9705_5459# VSS 0.04619f
C13465 a_10513_5773# VSS 0.14339f
C13466 a_10607_5773# VSS 0.11048f
C13467 a_9636_5837# VSS 0.54039f
C13468 a_9574_5837# VSS 0.50372f
C13469 a_9348_5416# VSS 0.11048f
C13470 a_9156_5850# VSS 1.70716f
C13471 a_9062_5850# VSS 0.50585f
C13472 a_8719_5782# VSS 0.5824f
C13473 a_8480_5498# VSS 0.04218f ; **FLOATING
C13474 a_8115_5760# VSS 0.31684f
C13475 a_7904_5498# VSS 0.06529f ; **FLOATING
C13476 sg13cmos5l_nor2_1_2.Y VSS 0.06076f
C13477 sg13cmos5l_a21oi_1_8.A1 VSS 0.57382f
C13478 a_22522_6130# VSS 0.27418f
C13479 sg13cmos5l_buf_1_4.A VSS 0.15803f
C13480 a_21089_6352# VSS 0.23152f
C13481 a_19361_6352# VSS 0.48646f
C13482 a_18778_6130# VSS 0.19023f
C13483 a_15889_6239# VSS 0.88692f
C13484 a_15012_6175# VSS 0.03745f
C13485 a_16185_6477# VSS 0.20962f
C13486 a_16650_6460# VSS 0.12267f
C13487 a_15081_6553# VSS 0.5259f
C13488 a_14438_6162# VSS 0.27519f
C13489 sg13cmos5l_dfrbpq_1_47.D VSS 0.07145f
C13490 a_12614_6166# VSS 0.01715f
C13491 a_12224_6294# VSS 0.03763f ; **FLOATING
C13492 a_12040_6294# VSS 0.07836f ; **FLOATING
C13493 a_10803_6188# VSS 0.01131f
C13494 a_11393_6352# VSS 0.15083f
C13495 a_10592_6294# VSS 0.03726f ; **FLOATING
C13496 a_10408_6294# VSS 0.07937f ; **FLOATING
C13497 a_9171_6188# VSS 0.01131f
C13498 a_8642_6162# VSS 0.1483f
C13499 a_10709_6460# VSS 0.38654f
C13500 sg13cmos5l_nor3_1_1.Y VSS 0.43232f
C13501 a_10042_6130# VSS 0.12337f
C13502 a_8872_6294# VSS 0.081f ; **FLOATING
C13503 a_8246_6175# VSS 0.76732f
C13504 a_6958_6162# VSS 0.21065f
C13505 a_7850_6320# VSS 1.01324f
C13506 a_9077_6460# VSS 0.54737f
C13507 a_8091_6553# VSS 0.50326f
C13508 a_7895_6553# VSS 0.60945f
C13509 a_22041_7047# VSS 0.11022f
C13510 a_20937_6971# VSS 0.04498f
C13511 a_22258_7362# VSS 0.05844f
C13512 a_21745_7285# VSS 0.17079f
C13513 a_20868_7349# VSS 0.53983f
C13514 a_20806_7349# VSS 0.50317f
C13515 a_20192_7010# VSS 0.03876f ; **FLOATING
C13516 a_20388_7362# VSS 0.2107f
C13517 a_20294_7362# VSS 0.4432f
C13518 a_19827_7272# VSS 0.37545f
C13519 a_17769_6971# VSS 0.50287f
C13520 a_18577_7285# VSS 0.1434f
C13521 a_17700_7349# VSS 0.08426f
C13522 a_17638_7349# VSS 0.0476f
C13523 a_17024_7010# VSS 0.03858f ; **FLOATING
C13524 a_17412_6928# VSS 0.1514f
C13525 a_17220_7362# VSS 0.12209f
C13526 a_17126_7362# VSS 0.51848f
C13527 a_16770_7290# VSS 0.47851f
C13528 a_16668_7290# VSS 0.26842f
C13529 a_13460_6924# VSS 0.44144f
C13530 a_12188_6904# VSS 0.13846f
C13531 a_15790_7191# VSS 0.14568f
C13532 sg13cmos5l_dlygate4sd3_1_7.X VSS 0.09037f
C13533 a_13039_7294# VSS 0.09431f
C13534 a_12430_6980# VSS 0.02803f
C13535 a_12082_7302# VSS 0.15674f
C13536 sg13cmos5l_o21ai_1_4.Y VSS 0.39278f
C13537 sg13cmos5l_o21ai_1_0.Y VSS 0.21774f
C13538 a_11053_7314# VSS 0.01311f
C13539 a_10447_7294# VSS 0.65852f
C13540 a_9967_7294# VSS 0.09183f
C13541 a_9640_7010# VSS 0.08333f ; **FLOATING
C13542 a_10878_7180# VSS 0.42819f
C13543 a_10365_7194# VSS 0.27295f
C13544 a_8993_7190# VSS 0.12854f
C13545 a_8143_7294# VSS 0.10003f
C13546 a_7520_7010# VSS 0.04158f ; **FLOATING
C13547 a_6881_7190# VSS 0.16329f
C13548 a_22241_7864# VSS 0.16876f
C13549 a_21832_7806# VSS 0.08349f ; **FLOATING
C13550 a_20338_7674# VSS 0.13625f
C13551 a_21185_7864# VSS 0.1148f
C13552 a_19825_7751# VSS 0.21106f
C13553 a_18948_7687# VSS 0.03666f
C13554 a_18468_7674# VSS 0.07708f
C13555 a_17715_7700# VSS 0.01131f
C13556 a_19017_8065# VSS 0.82225f
C13557 a_18374_7674# VSS 0.49467f
C13558 a_15694_7674# VSS 0.14394f
C13559 a_16586_7832# VSS 0.2437f
C13560 a_17621_7972# VSS 0.5401f
C13561 sg13cmos5l_inv_1_3.Y VSS 0.28622f
C13562 a_16827_8065# VSS 0.5037f
C13563 a_16631_8065# VSS 0.24229f
C13564 a_14230_7670# VSS 0.71524f
C13565 a_15804_7638# VSS 0.14464f
C13566 a_14144_7806# VSS 0.04228f ; **FLOATING
C13567 a_13018_7678# VSS 0.31392f
C13568 a_12662_7656# VSS 0.06722f
C13569 a_12414_7656# VSS 0.28592f
C13570 a_13786_7642# VSS 0.03435f
C13571 a_12058_7678# VSS 0.3221f
C13572 a_12414_7996# VSS 0.12536f
C13573 sg13cmos5l_dfrbpq_1_13.Q VSS 0.16607f
C13574 a_10784_7806# VSS 0.04385f ; **FLOATING
C13575 a_9754_7678# VSS 0.81187f
C13576 a_9368_7682# VSS 0.72386f
C13577 a_9266_7682# VSS 0.27121f
C13578 a_8942_7656# VSS 0.28972f
C13579 a_8671_7656# VSS 0.36052f
C13580 a_7090_7674# VSS 0.2497f
C13581 sg13cmos5l_nand2_1_6.A VSS 0.08577f
C13582 a_8671_7996# VSS 0.3975f
C13583 a_6577_7751# VSS 0.3659f
C13584 a_5638_7687# VSS 0.50313f
C13585 a_5700_7687# VSS 0.53979f
C13586 a_6873_7989# VSS 0.12318f
C13587 a_5769_8065# VSS 0.04646f
C13588 a_5126_7674# VSS 0.52579f
C13589 a_4936_7806# VSS 0.09195f ; **FLOATING
C13590 a_22041_8559# VSS 0.20764f
C13591 a_22258_8874# VSS 0.24123f
C13592 a_21745_8797# VSS 0.26203f
C13593 a_20868_8861# VSS 0.53961f
C13594 a_20806_8861# VSS 0.50295f
C13595 a_19829_8436# VSS 0.04334f
C13596 a_20580_8440# VSS 0.06251f
C13597 a_20388_8874# VSS 0.21236f
C13598 a_19923_8784# VSS 0.46275f
C13599 a_19624_8522# VSS 0.08347f ; **FLOATING
C13600 a_20294_8874# VSS 2.45725f
C13601 a_17673_8483# VSS 0.8666f
C13602 a_18481_8797# VSS 0.14378f
C13603 a_17604_8861# VSS 0.13635f
C13604 a_17542_8861# VSS 0.09969f
C13605 a_15622_8412# VSS 0.49912f
C13606 a_17124_8874# VSS 0.15344f
C13607 a_17030_8874# VSS 0.27733f
C13608 sg13cmos5l_dfrbpq_1_9.D VSS 0.0872f
C13609 a_15000_8416# VSS 0.63543f
C13610 a_14668_8436# VSS 0.2694f
C13611 a_13566_8412# VSS 0.32894f
C13612 a_14902_8814# VSS 0.17656f
C13613 a_14155_8784# VSS 0.44117f
C13614 sg13cmos5l_dfrbpq_1_2.D VSS 0.26254f
C13615 a_12512_8522# VSS 0.04433f ; **FLOATING
C13616 a_12120_8416# VSS 0.44557f
C13617 a_13014_8460# VSS 0.14439f
C13618 a_12022_8814# VSS 0.68632f
C13619 a_9500_8416# VSS 0.049f
C13620 a_8859_8436# VSS 0.04913f
C13621 a_8716_8436# VSS 0.04913f
C13622 a_9394_8814# VSS 0.14914f
C13623 a_7841_8702# VSS 0.02469f
C13624 a_7362_8802# VSS 0.01201f
C13625 a_6401_8702# VSS 0.0822f
C13626 a_5600_8522# VSS 0.06427f ; **FLOATING
C13627 a_6286_8703# VSS 0.19932f
C13628 a_21363_9212# VSS 0.49793f
C13629 a_21269_9484# VSS 0.394f
C13630 a_19160_9190# VSS 0.0915f
C13631 a_16078_9186# VSS 0.13594f
C13632 a_15914_9186# VSS 0.13968f
C13633 a_16970_9344# VSS 0.13312f
C13634 sg13cmos5l_dfrbpq_1_11.D VSS 0.09567f
C13635 a_17211_9577# VSS 0.50188f
C13636 a_17015_9577# VSS 0.88776f
C13637 a_16188_9150# VSS 0.39877f
C13638 a_16078_9501# VSS 0.07612f
C13639 a_15208_9318# VSS 0.08418f ; **FLOATING
C13640 a_13808_9194# VSS 0.11276f
C13641 a_14561_9376# VSS 0.34908f
C13642 a_12826_9154# VSS 0.15288f
C13643 a_12224_9318# VSS 0.04385f ; **FLOATING
C13644 a_12430_9375# VSS 0.19368f
C13645 sg13cmos5l_inv_1_22.Y VSS 0.09251f
C13646 a_11360_9318# VSS 0.04304f ; **FLOATING
C13647 a_11150_9232# VSS 0.44731f
C13648 a_11014_9508# VSS 0.14389f
C13649 a_7886_9232# VSS 0.54772f
C13650 a_10771_9380# VSS 0.22693f
C13651 sg13cmos5l_nand4_1_0.C VSS 0.18656f
C13652 sg13cmos5l_o21ai_1_6.Y VSS 0.0245f
C13653 sg13cmos5l_nand2b_1_5.Y VSS 0.47094f
C13654 a_7750_9508# VSS 0.91125f
C13655 a_6289_9263# VSS 0.14607f
C13656 a_5350_9199# VSS 0.13539f
C13657 a_5412_9199# VSS 0.17212f
C13658 a_6585_9501# VSS 0.16923f
C13659 sg13cmos5l_nor3_1_2.A VSS 0.07046f
C13660 a_7050_9484# VSS 0.1636f
C13661 a_4932_9186# VSS 0.25745f
C13662 a_5481_9577# VSS 0.5034f
C13663 a_4838_9186# VSS 0.43667f
C13664 a_4736_9318# VSS 0.06493f ; **FLOATING
C13665 a_1294_9375# VSS 0.17206f
C13666 a_22041_10071# VSS 0.47647f
C13667 sg13cmos5l_dlygate4sd3_1_16.A VSS 0.09621f
C13668 a_20937_9995# VSS 0.55163f
C13669 a_21745_10309# VSS 0.14322f
C13670 a_20868_10373# VSS 0.0571f
C13671 a_20806_10373# VSS 0.02044f
C13672 a_20104_10034# VSS 0.07991f ; **FLOATING
C13673 a_20388_10386# VSS 0.20998f
C13674 a_20294_10386# VSS 0.3803f
C13675 a_19457_10214# VSS 0.09843f
C13676 a_18272_10034# VSS 0.04384f ; **FLOATING
C13677 sg13cmos5l_dfrbpq_1_11.Q VSS 0.09215f
C13678 a_18478_10215# VSS 0.09606f
C13679 a_16448_10034# VSS 0.04288f ; **FLOATING
C13680 a_16091_9948# VSS 0.04088f
C13681 a_17518_10215# VSS 0.23674f
C13682 a_16950_9972# VSS 0.17813f
C13683 sg13cmos5l_o21ai_1_3.Y VSS 0.19975f
C13684 a_16193_10296# VSS 0.01131f
C13685 sg13cmos5l_o21ai_1_3.A2 VSS 0.15523f
C13686 a_12808_10034# VSS 0.08197f ; **FLOATING
C13687 a_11961_10071# VSS 0.09666f
C13688 sg13cmos5l_dlygate4sd3_1_14.A VSS 0.03663f
C13689 a_15610_9912# VSS 0.20254f
C13690 a_12178_10386# VSS 0.14022f
C13691 a_11665_10309# VSS 0.21287f
C13692 a_11019_9959# VSS 0.90107f
C13693 a_10788_10373# VSS 0.67322f
C13694 a_10726_10373# VSS 0.63656f
C13695 a_10112_10034# VSS 0.03392f ; **FLOATING
C13696 a_9928_10034# VSS 0.07711f ; **FLOATING
C13697 a_9081_10071# VSS 0.17278f
C13698 a_10214_10386# VSS 0.31954f
C13699 a_7977_9995# VSS 0.52338f
C13700 a_9298_10386# VSS 0.24883f
C13701 a_8785_10309# VSS 0.41009f
C13702 a_9546_9948# VSS 0.04875f
C13703 a_7908_10373# VSS 0.03666f
C13704 a_7144_10034# VSS 0.10507f ; **FLOATING
C13705 a_7428_10386# VSS 0.26296f
C13706 a_7334_10386# VSS 0.39961f
C13707 a_5416_9948# VSS 0.26185f
C13708 sg13cmos5l_dlygate4sd3_1_33.X VSS 0.08852f
C13709 a_3392_10034# VSS 0.03857f ; **FLOATING
C13710 a_3208_10034# VSS 0.10831f ; **FLOATING
C13711 a_3512_9989# VSS 0.5834f
C13712 sg13cmos5l_buf_1_17.X VSS 0.14527f
C13713 a_22696_10830# VSS 0.12018f ; **FLOATING
C13714 a_22330_10666# VSS 0.09087f
C13715 a_22049_10888# VSS 0.41473f
C13716 a_19825_10775# VSS 0.06776f
C13717 a_18948_10711# VSS 0.03666f
C13718 a_20121_11013# VSS 0.10153f
C13719 a_20984_10702# VSS 0.20422f
C13720 a_18468_10698# VSS 0.12626f
C13721 a_16954_10702# VSS 0.14406f
C13722 a_16342_10694# VSS 0.48985f
C13723 a_19017_11089# VSS 0.62711f
C13724 a_18374_10698# VSS 0.48717f
C13725 sg13cmos5l_dlygate4sd3_1_18.X VSS 0.11948f
C13726 a_17510_10702# VSS 0.05264f
C13727 a_16440_11016# VSS 0.34892f
C13728 a_15299_10996# VSS 0.08987f
C13729 a_15197_10996# VSS 0.04033f
C13730 a_14144_10830# VSS 0.04307f ; **FLOATING
C13731 a_13880_10706# VSS 0.50565f
C13732 a_13778_10706# VSS 0.01515f
C13733 a_13298_10706# VSS 0.01203f
C13734 a_14264_10702# VSS 0.52387f
C13735 a_12940_10996# VSS 0.04434f
C13736 sg13cmos5l_dlygate4sd3_1_15.X VSS 0.12387f
C13737 a_11648_10830# VSS 0.04343f ; **FLOATING
C13738 a_10774_10694# VSS 0.15906f
C13739 sg13cmos5l_buf_1_10.A VSS 0.07611f
C13740 sg13cmos5l_a21o_1_0.A2 VSS 0.19646f
C13741 a_10872_11016# VSS 0.19646f
C13742 a_10304_10830# VSS 0.06688f ; **FLOATING
C13743 a_8713_10744# VSS 0.24081f
C13744 sg13cmos5l_dlygate4sd3_1_38.X VSS 0.05746f
C13745 a_8122_10666# VSS 0.03081f
C13746 a_6272_10830# VSS 0.04906f ; **FLOATING
C13747 a_22041_11583# VSS 0.14215f
C13748 sg13cmos5l_dlygate4sd3_1_20.A VSS 0.15559f
C13749 a_21745_11821# VSS 0.06776f
C13750 a_20868_11885# VSS 0.66076f
C13751 a_20806_11885# VSS 0.6241f
C13752 a_19065_11583# VSS 0.18634f
C13753 a_20388_11898# VSS 0.1745f
C13754 a_20294_11898# VSS 0.33478f
C13755 a_19282_11898# VSS 1.35677f
C13756 a_18769_11821# VSS 0.16037f
C13757 a_19912_11460# VSS 0.03835f
C13758 a_17892_11885# VSS 0.60931f
C13759 a_17830_11885# VSS 0.57265f
C13760 a_16215_11460# VSS 0.20197f
C13761 a_16101_11460# VSS 0.22805f
C13762 a_17412_11898# VSS 0.0945f
C13763 a_17318_11898# VSS 0.3032f
C13764 a_16673_11726# VSS 0.20242f
C13765 a_15872_11546# VSS 0.04317f ; **FLOATING
C13766 a_16954_11424# VSS 0.14251f
C13767 a_15208_11546# VSS 0.08235f ; **FLOATING
C13768 a_14561_11726# VSS 0.12918f
C13769 a_13478_11460# VSS 0.36843f
C13770 sg13cmos5l_nand2_1_0.A VSS 0.15105f
C13771 a_12139_11808# VSS 0.04421f
C13772 a_13590_11484# VSS 0.09465f
C13773 a_12045_11808# VSS 0.36741f
C13774 a_11770_11830# VSS 0.20216f
C13775 a_11552_11546# VSS 0.06476f ; **FLOATING
C13776 a_9557_11460# VSS 0.19402f
C13777 a_9651_11808# VSS 0.01131f
C13778 a_9056_11546# VSS 0.0468f ; **FLOATING
C13779 a_7113_11507# VSS 0.32175f
C13780 a_7921_11821# VSS 0.21159f
C13781 a_7044_11885# VSS 0.6361f
C13782 a_6982_11885# VSS 0.5024f
C13783 a_6280_11546# VSS 0.08709f ; **FLOATING
C13784 a_6564_11898# VSS 0.30947f
C13785 a_6470_11898# VSS 0.6639f
C13786 a_21745_12287# VSS 0.2978f
C13787 a_20868_12223# VSS 0.13259f
C13788 a_22041_12525# VSS 0.06672f
C13789 a_20388_12210# VSS 0.65732f
C13790 a_20937_12601# VSS 0.57573f
C13791 a_20580_12528# VSS 0.04796f
C13792 a_20294_12210# VSS 0.60002f
C13793 a_19718_12214# VSS 0.14731f
C13794 a_18578_12218# VSS 0.01201f
C13795 a_18002_12218# VSS 0.01202f
C13796 a_17523_12236# VSS 0.01131f
C13797 a_17043_12236# VSS 0.41663f
C13798 a_16666_12214# VSS 0.62627f
C13799 a_16179_12236# VSS 0.01131f
C13800 a_15691_12256# VSS 0.03249f
C13801 a_19048_12248# VSS 0.18878f
C13802 sg13cmos5l_nor3_1_7.Y VSS 0.02461f
C13803 a_17429_12508# VSS 0.4361f
C13804 a_16949_12508# VSS 0.129f
C13805 a_16085_12508# VSS 0.04669f
C13806 a_15488_12342# VSS 0.04141f ; **FLOATING
C13807 a_15226_12214# VSS 0.36533f
C13808 a_14548_12236# VSS 0.44903f
C13809 a_14446_12508# VSS 0.26821f
C13810 a_14240_12342# VSS 0.04128f ; **FLOATING
C13811 a_10801_12287# VSS 0.21359f
C13812 a_9862_12223# VSS 0.57623f
C13813 a_9924_12223# VSS 0.82091f
C13814 a_9444_12210# VSS 0.03899f
C13815 a_8848_12214# VSS 0.15605f
C13816 a_8637_12214# VSS 0.69129f
C13817 a_9350_12210# VSS 0.33791f
C13818 a_8911_12508# VSS 0.0718f
C13819 a_8200_12342# VSS 0.08485f ; **FLOATING
C13820 a_7482_12214# VSS 0.85491f
C13821 a_7482_12508# VSS 0.07008f
C13822 a_22784_13058# VSS 0.07999f ; **FLOATING
C13823 a_20513_13238# VSS 0.22223f
C13824 a_19649_13238# VSS 0.24557f
C13825 a_19240_13058# VSS 0.08476f ; **FLOATING
C13826 a_21160_12972# VSS 0.06073f
C13827 a_18872_13338# VSS 0.25702f
C13828 a_18770_13338# VSS 0.26114f
C13829 sg13cmos5l_a21oi_1_5.A2 VSS 0.03928f
C13830 a_18194_13338# VSS 0.01202f
C13831 a_17715_13320# VSS 0.55707f
C13832 sg13cmos5l_inv_1_12.Y VSS 0.06059f
C13833 a_16578_13338# VSS 0.01198f
C13834 a_15706_13342# VSS 0.07047f
C13835 a_15104_13058# VSS 0.04088f ; **FLOATING
C13836 a_14842_13342# VSS 0.01004f
C13837 sg13cmos5l_nand3_1_2.A VSS 0.18512f
C13838 a_14347_13320# VSS 0.37817f
C13839 sg13cmos5l_nand2_1_19.A VSS 0.12552f
C13840 a_12224_13058# VSS 0.03861f ; **FLOATING
C13841 a_12040_13058# VSS 0.0856f ; **FLOATING
C13842 a_11072_13058# VSS 0.04377f ; **FLOATING
C13843 a_11674_12936# VSS 0.05269f
C13844 sg13cmos5l_buf_1_22.A VSS 0.07418f
C13845 a_10112_13058# VSS 0.04208f ; **FLOATING
C13846 a_9879_12972# VSS 0.44531f
C13847 a_9765_12972# VSS 0.09584f
C13848 a_9056_13058# VSS 0.04191f ; **FLOATING
C13849 a_7065_13095# VSS 0.18883f
C13850 a_8635_13362# VSS 0.08557f
C13851 a_8533_13362# VSS 0.12492f
C13852 a_8431_13362# VSS 0.05094f
C13853 sg13cmos5l_dfrbpq_1_45.Q VSS 0.09739f
C13854 a_7282_13410# VSS 0.05951f
C13855 a_6769_13333# VSS 0.09591f
C13856 a_7912_12972# VSS 0.12926f
C13857 a_5892_13397# VSS 0.61312f
C13858 a_5830_13397# VSS 0.57646f
C13859 a_5216_13058# VSS 0.06365f ; **FLOATING
C13860 a_5412_13410# VSS 0.16477f
C13861 a_5318_13410# VSS 0.38695f
C13862 a_21745_13799# VSS 0.29815f
C13863 a_20806_13735# VSS 0.65695f
C13864 a_20868_13735# VSS 0.13267f
C13865 a_22041_14037# VSS 0.06722f
C13866 a_19923_13748# VSS 0.48071f
C13867 a_19346_13730# VSS 0.01202f
C13868 a_20937_14113# VSS 0.52286f
C13869 a_20580_14040# VSS 0.46358f
C13870 a_20294_13722# VSS 1.12691f
C13871 sg13cmos5l_dlygate4sd3_1_76.X VSS 0.04036f
C13872 a_19136_13854# VSS 0.03973f ; **FLOATING
C13873 a_18882_13730# VSS 0.01201f
C13874 a_18195_13748# VSS 0.81599f
C13875 sg13cmos5l_dlygate4sd3_1_76.A VSS 0.63133f
C13876 a_17984_13854# VSS 0.04368f ; **FLOATING
C13877 a_17342_13730# VSS 0.04385f
C13878 a_17240_13730# VSS 0.04898f
C13879 a_17138_13730# VSS 0.01201f
C13880 a_16766_13730# VSS 0.54414f
C13881 a_16664_13730# VSS 1.02306f
C13882 a_16562_13730# VSS 0.48583f
C13883 a_15986_13730# VSS 0.01202f
C13884 a_15392_13854# VSS 0.03974f ; **FLOATING
C13885 a_14774_13735# VSS 0.02632f
C13886 a_13486_13722# VSS 0.07747f
C13887 a_14378_13880# VSS 0.1698f
C13888 a_14619_14113# VSS 0.64962f
C13889 a_14517_13880# VSS 0.67359f
C13890 a_14423_14113# VSS 1.67946f
C13891 a_13486_14037# VSS 0.30481f
C13892 a_10245_14020# VSS 0.75172f
C13893 a_10016_13854# VSS 0.04569f ; **FLOATING
C13894 a_9446_13726# VSS 0.12849f
C13895 a_8118_13790# VSS 0.06567f
C13896 a_7616_13854# VSS 0.0383f ; **FLOATING
C13897 a_7432_13854# VSS 0.07886f ; **FLOATING
C13898 a_7214_13768# VSS 0.21479f
C13899 a_5554_13718# VSS 0.17906f
C13900 a_7078_14044# VSS 0.0198f
C13901 a_6394_13690# VSS 0.16747f
C13902 a_5660_14040# VSS 0.18885f
C13903 sg13cmos5l_o21ai_1_9.Y VSS 0.03051f
C13904 a_5312_13854# VSS 0.0439f ; **FLOATING
C13905 a_5036_13686# VSS 0.04283f
C13906 a_20937_14531# VSS 0.07216f
C13907 a_21745_14845# VSS 0.29714f
C13908 a_20868_14909# VSS 0.53962f
C13909 a_20806_14909# VSS 0.50296f
C13910 a_20388_14922# VSS 0.7819f
C13911 a_20294_14922# VSS 0.52409f
C13912 sg13cmos5l_a21oi_1_13.A2 VSS 0.1748f
C13913 a_19442_14850# VSS 0.01198f
C13914 a_18689_14750# VSS 0.25533f
C13915 a_18002_14850# VSS 0.01198f
C13916 a_17792_14570# VSS 0.04073f ; **FLOATING
C13917 a_16469_14484# VSS 0.3169f
C13918 a_16563_14832# VSS 0.17533f
C13919 a_17434_14448# VSS 0.16529f
C13920 a_15968_14570# VSS 0.04445f ; **FLOATING
C13921 a_15582_14850# VSS 0.06484f
C13922 a_13384_14484# VSS 0.2716f
C13923 a_12128_14570# VSS 0.04207f ; **FLOATING
C13924 a_10530_14484# VSS 0.03675f
C13925 a_10428_14484# VSS 0.03675f
C13926 a_12616_14484# VSS 0.02074f
C13927 a_11131_14874# VSS 0.0131f
C13928 a_9064_14570# VSS 0.09057f ; **FLOATING
C13929 a_6201_14607# VSS 0.09714f
C13930 a_8410_14854# VSS 0.07084f
C13931 a_8026_14854# VSS 0.48256f
C13932 a_7334_14484# VSS 0.12519f
C13933 a_7064_14525# VSS 0.0491f
C13934 a_6418_14922# VSS 2.45845f
C13935 a_5905_14845# VSS 0.23663f
C13936 a_5028_14909# VSS 0.57533f
C13937 a_4966_14909# VSS 0.53799f
C13938 a_4264_14570# VSS 0.11468f ; **FLOATING
C13939 a_4740_14488# VSS 0.2224f
C13940 a_4548_14922# VSS 0.27948f
C13941 a_4454_14922# VSS 0.86553f
C13942 a_1192_14484# VSS 0.34433f
C13943 a_22625_15260# VSS 0.43042f
C13944 a_22523_15532# VSS 0.09531f
C13945 sg13cmos5l_inv_1_31.Y VSS 0.09171f
C13946 a_20890_15202# VSS 0.33121f
C13947 sg13cmos5l_dfrbpq_1_29.D VSS 0.03159f
C13948 a_19745_15424# VSS 0.26347f
C13949 a_19336_15366# VSS 0.08595f ; **FLOATING
C13950 a_18706_15234# VSS 4.43216f
C13951 a_18193_15311# VSS 0.06776f
C13952 a_17316_15247# VSS 0.14641f
C13953 a_18489_15549# VSS 0.07681f
C13954 a_16376_15242# VSS 0.23948f
C13955 a_16274_15242# VSS 0.90423f
C13956 a_17385_15625# VSS 0.59995f
C13957 a_16742_15234# VSS 0.28901f
C13958 sg13cmos5l_dlygate4sd3_1_81.X VSS 0.15265f
C13959 a_14624_15366# VSS 0.04187f ; **FLOATING
C13960 a_12886_15230# VSS 1.15526f
C13961 a_12406_15230# VSS 0.36738f
C13962 a_13670_15238# VSS 0.30735f
C13963 a_12504_15552# VSS 0.33827f
C13964 a_11464_15366# VSS 0.08202f ; **FLOATING
C13965 a_8879_15238# VSS 0.19537f
C13966 a_10696_15272# VSS 0.02066f
C13967 a_8513_15260# VSS 0.40928f
C13968 a_9674_15532# VSS 0.38087f
C13969 a_9018_15532# VSS 0.1884f
C13970 a_8192_15366# VSS 0.04228f ; **FLOATING
C13971 a_7907_15532# VSS 3.63102f
C13972 a_7805_15532# VSS 3.63088f
C13973 a_7616_15366# VSS 0.03591f ; **FLOATING
C13974 a_7432_15366# VSS 0.07489f ; **FLOATING
C13975 a_7090_15230# VSS 0.29337f
C13976 sg13cmos5l_a21o_1_2.A1 VSS 0.12196f
C13977 a_7196_15552# VSS 0.20143f
C13978 a_6760_15366# VSS 0.08339f ; **FLOATING
C13979 a_6418_15230# VSS 0.74002f
C13980 a_5782_15230# VSS 0.31207f
C13981 a_5880_15552# VSS 0.16583f
C13982 a_4064_15366# VSS 0.06519f ; **FLOATING
C13983 a_4568_15238# VSS 0.34357f
C13984 a_22107_16043# VSS 0.50255f
C13985 a_22658_16434# VSS 0.15865f
C13986 a_21911_16043# VSS 0.57492f
C13987 a_22262_16421# VSS 0.23724f
C13988 a_21866_16276# VSS 0.37016f
C13989 a_20974_16434# VSS 0.14379f
C13990 a_20810_16434# VSS 0.26512f
C13991 a_19649_16262# VSS 0.27373f
C13992 a_18785_16262# VSS 0.16702f
C13993 a_18098_16362# VSS 0.05309f
C13994 a_17730_16362# VSS 0.01202f
C13995 a_17526_16362# VSS 0.63702f
C13996 a_17153_16344# VSS 0.98699f
C13997 a_16832_16082# VSS 0.04208f ; **FLOATING
C13998 a_15225_16119# VSS 0.12057f
C13999 a_19930_15960# VSS 0.06288f
C14000 sg13cmos5l_inv_1_24.Y VSS 0.41808f
C14001 a_14121_16043# VSS 0.80926f
C14002 a_15442_16434# VSS 0.39532f
C14003 a_14929_16357# VSS 0.21199f
C14004 a_16556_15960# VSS 0.32855f
C14005 a_14052_16421# VSS 0.03666f
C14006 a_13572_16434# VSS 0.1979f
C14007 a_13478_16434# VSS 1.06078f
C14008 a_12136_16082# VSS 0.08165f ; **FLOATING
C14009 a_11202_16362# VSS 0.24606f
C14010 a_11100_16362# VSS 0.24124f
C14011 a_10448_16362# VSS 0.10985f
C14012 a_9832_16082# VSS 0.08256f ; **FLOATING
C14013 a_8960_16082# VSS 0.0424f ; **FLOATING
C14014 a_7484_15976# VSS 0.24351f
C14015 a_8698_16366# VSS 0.25064f
C14016 a_7938_16362# VSS 0.1515f
C14017 a_7378_16374# VSS 0.33005f
C14018 a_7048_16082# VSS 0.08302f ; **FLOATING
C14019 a_5784_15976# VSS 0.08974f
C14020 a_6401_16262# VSS 0.18024f
C14021 a_6682_15960# VSS 0.01994f
C14022 a_5686_16374# VSS 0.14775f
C14023 a_5474_16434# VSS 0.19342f
C14024 a_3790_16119# VSS 0.10505f
C14025 a_4727_16043# VSS 0.93764f
C14026 a_5078_16421# VSS 0.68325f
C14027 a_4682_16276# VSS 0.72121f
C14028 a_3790_16434# VSS 0.1626f
C14029 a_2920_16082# VSS 0.09382f ; **FLOATING
C14030 a_20974_16746# VSS 0.06776f
C14031 a_21866_16904# VSS 0.03666f
C14032 a_22107_17137# VSS 0.57641f
C14033 a_21911_17137# VSS 0.59251f
C14034 a_17922_16754# VSS 0.01202f
C14035 a_17820_16754# VSS 0.03163f
C14036 a_17718_16754# VSS 0.02653f
C14037 a_17346_16754# VSS 0.012f
C14038 a_21084_16710# VSS 0.32841f
C14039 a_20974_17061# VSS 0.32586f
C14040 a_18401_16936# VSS 0.12855f
C14041 sg13cmos5l_inv_1_1.A VSS 0.07335f
C14042 a_16840_16878# VSS 0.08186f ; **FLOATING
C14043 a_16578_16754# VSS 0.01202f
C14044 a_16002_16754# VSS 0.63721f
C14045 a_15900_16754# VSS 0.63309f
C14046 a_15798_16754# VSS 0.04173f
C14047 a_14038_16742# VSS 0.57057f
C14048 sg13cmos5l_buf_1_43.X VSS 0.01308f
C14049 a_12694_16742# VSS 0.32285f
C14050 sg13cmos5l_inv_1_35.Y VSS 0.80769f
C14051 a_12058_16750# VSS 0.16562f
C14052 sg13cmos5l_nor2_1_15.Y VSS 0.0397f
C14053 a_12458_17044# VSS 0.96738f
C14054 a_11368_16878# VSS 0.08253f ; **FLOATING
C14055 a_10880_16878# VSS 0.04063f ; **FLOATING
C14056 a_10162_16742# VSS 0.52029f
C14057 a_9526_16742# VSS 0.61879f
C14058 a_10634_17044# VSS 0.95051f
C14059 sg13cmos5l_buf_1_59.A VSS 0.08945f
C14060 a_10268_17064# VSS 0.3217f
C14061 a_9624_17064# VSS 0.05143f
C14062 a_9056_16878# VSS 0.0418f ; **FLOATING
C14063 a_8338_16742# VSS 0.41309f
C14064 a_7858_16742# VSS 0.36511f
C14065 a_8812_17044# VSS 0.05219f
C14066 sg13cmos5l_o21ai_1_10.Y VSS 0.24143f
C14067 a_6958_16935# VSS 0.02705f
C14068 a_5800_16878# VSS 0.08143f ; **FLOATING
C14069 a_3886_16746# VSS 0.0708f
C14070 a_4778_16904# VSS 0.13789f
C14071 sg13cmos5l_dfrbpq_1_19.D VSS 0.09005f
C14072 a_5019_17137# VSS 0.55137f
C14073 a_4823_17137# VSS 0.54476f
C14074 a_3996_16710# VSS 0.10829f
C14075 a_3886_17061# VSS 0.08697f
C14076 a_22241_17774# VSS 0.27995f
C14077 a_21920_17594# VSS 0.04428f ; **FLOATING
C14078 a_20217_17631# VSS 0.17344f
C14079 sg13cmos5l_dfrbpq_1_30.D VSS 0.08047f
C14080 a_19113_17555# VSS 0.5235f
C14081 a_20434_17946# VSS 0.3116f
C14082 a_19921_17869# VSS 0.06776f
C14083 a_19044_17933# VSS 0.33164f
C14084 a_18756_17512# VSS 0.14749f
C14085 a_18564_17946# VSS 0.78365f
C14086 a_18470_17946# VSS 0.25261f
C14087 a_17345_17856# VSS 0.30104f
C14088 a_16865_17856# VSS 1.10196f
C14089 a_16385_17856# VSS 0.46294f
C14090 a_16064_17594# VSS 0.04293f ; **FLOATING
C14091 a_15225_17631# VSS 0.16771f
C14092 a_17710_17775# VSS 0.15866f
C14093 sg13cmos5l_dfrbpq_1_38.Q VSS 0.09727f
C14094 a_14121_17555# VSS 0.85603f
C14095 a_15442_17946# VSS 0.34709f
C14096 a_14929_17869# VSS 0.06776f
C14097 a_14052_17933# VSS 0.03666f
C14098 a_12216_17488# VSS 0.3204f
C14099 a_13572_17946# VSS 0.17738f
C14100 a_13478_17946# VSS 1.04043f
C14101 a_10872_17488# VSS 0.15263f
C14102 a_12902_17508# VSS 0.09882f
C14103 a_12632_17549# VSS 0.16604f
C14104 sg13cmos5l_nand2_1_12.Y VSS 0.04533f
C14105 a_12118_17886# VSS 0.7682f
C14106 a_11489_17774# VSS 0.12191f
C14107 a_8540_17488# VSS 0.11377f
C14108 a_8060_17488# VSS 0.18942f
C14109 sg13cmos5l_o21ai_1_22.B1 VSS 0.07171f
C14110 a_11770_17472# VSS 0.1602f
C14111 a_10774_17886# VSS 0.18357f
C14112 a_10530_17874# VSS 0.31462f
C14113 a_9054_17874# VSS 0.04656f
C14114 a_9846_17532# VSS 0.1852f
C14115 a_8434_17886# VSS 0.27152f
C14116 a_7954_17886# VSS 0.4221f
C14117 a_6760_17594# VSS 0.0831f ; **FLOATING
C14118 sg13cmos5l_o21ai_1_19.B1 VSS 0.11377f
C14119 a_7350_17532# VSS 0.14812f
C14120 a_5792_17594# VSS 0.04433f ; **FLOATING
C14121 a_4700_17488# VSS 0.14544f
C14122 a_6394_17472# VSS 0.11726f
C14123 a_5334_17532# VSS 0.23454f
C14124 a_4594_17886# VSS 0.19317f
C14125 sg13cmos5l_o21ai_1_21.Y VSS 0.18596f
C14126 a_4114_17886# VSS 0.14969f
C14127 a_3872_17594# VSS 0.06782f ; **FLOATING
C14128 a_22262_18271# VSS 0.24367f
C14129 a_20974_18258# VSS 0.06776f
C14130 a_20810_18258# VSS 0.3116f
C14131 a_21866_18416# VSS 0.37689f
C14132 a_22107_18649# VSS 0.52403f
C14133 a_21911_18649# VSS 0.80248f
C14134 a_19923_18284# VSS 0.53455f
C14135 a_20974_18573# VSS 0.07624f
C14136 a_19829_18556# VSS 0.4048f
C14137 a_19450_18226# VSS 0.08814f
C14138 sg13cmos5l_dfrbpq_1_39.D VSS 0.17329f
C14139 a_18486_18326# VSS 0.10693f
C14140 sg13cmos5l_dfrbpq_1_33.Q VSS 0.126f
C14141 a_16945_18335# VSS 0.27682f
C14142 a_16006_18271# VSS 0.52389f
C14143 a_16068_18271# VSS 0.56055f
C14144 a_17241_18573# VSS 0.26892f
C14145 a_16137_18649# VSS 0.46006f
C14146 a_15494_18258# VSS 0.26871f
C14147 a_15392_18390# VSS 0.03871f ; **FLOATING
C14148 sg13cmos5l_dfrbpq_1_48.Q VSS 0.19804f
C14149 a_12145_18335# VSS 0.27691f
C14150 a_11206_18271# VSS 0.5036f
C14151 a_11268_18271# VSS 0.54026f
C14152 a_11337_18649# VSS 0.31802f
C14153 a_10694_18258# VSS 0.364f
C14154 a_10230_18326# VSS 0.17414f
C14155 a_9848_18262# VSS 0.08825f
C14156 a_9185_18448# VSS 0.22058f
C14157 sg13cmos5l_o21ai_1_14.Y VSS 0.11406f
C14158 sg13cmos5l_inv_1_29.Y VSS 0.08847f
C14159 a_5654_18271# VSS 0.07969f
C14160 a_4366_18258# VSS 0.1472f
C14161 a_5258_18416# VSS 0.1166f
C14162 sg13cmos5l_dfrbpq_1_20.D VSS 0.17757f
C14163 a_5499_18649# VSS 0.52535f
C14164 a_5303_18649# VSS 0.60691f
C14165 a_3584_18390# VSS 0.0517f ; **FLOATING
C14166 a_22784_19106# VSS 0.08038f ; **FLOATING
C14167 a_20217_19143# VSS 0.07563f
C14168 a_22145_19286# VSS 0.21439f
C14169 a_21462_19044# VSS 0.10825f
C14170 a_21080_19061# VSS 0.08203f
C14171 sg13cmos5l_dfrbpq_1_35.Q VSS 0.22247f
C14172 a_19113_19067# VSS 0.50387f
C14173 a_20434_19458# VSS 0.3116f
C14174 a_19921_19381# VSS 0.29084f
C14175 a_19044_19445# VSS 0.1335f
C14176 a_17717_19020# VSS 0.20834f
C14177 a_18756_19024# VSS 0.41791f
C14178 a_18564_19458# VSS 0.05139f
C14179 a_18470_19458# VSS 0.39267f
C14180 a_17811_19368# VSS 0.34254f
C14181 a_17057_19286# VSS 0.35727f
C14182 a_16193_19286# VSS 0.19199f
C14183 a_13881_19143# VSS 0.07051f
C14184 sg13cmos5l_dfrbpq_1_33.D VSS 0.04149f
C14185 sg13cmos5l_a21oi_1_26.Y VSS 0.35645f
C14186 a_15014_19020# VSS 0.20719f
C14187 a_12777_19067# VSS 0.51036f
C14188 a_14098_19458# VSS 0.3471f
C14189 a_13585_19381# VSS 0.1507f
C14190 a_12708_19445# VSS 0.4268f
C14191 a_12646_19445# VSS 0.28623f
C14192 a_10172_19000# VSS 0.21917f
C14193 a_12228_19458# VSS 0.02351f
C14194 a_12134_19458# VSS 0.53963f
C14195 a_10625_19286# VSS 0.28522f
C14196 a_11288_19061# VSS 0.1114f
C14197 a_10066_19398# VSS 0.14855f
C14198 a_9824_19106# VSS 0.04477f ; **FLOATING
C14199 a_8985_19143# VSS 0.07607f
C14200 sg13cmos5l_nor2_1_10.Y VSS 0.47724f
C14201 sg13cmos5l_dlygate4sd3_1_65.A VSS 0.12996f
C14202 a_7881_19067# VSS 0.06613f
C14203 a_9202_19458# VSS 0.23998f
C14204 a_8689_19381# VSS 0.18609f
C14205 a_7812_19445# VSS 0.66465f
C14206 a_7750_19445# VSS 0.62799f
C14207 a_6393_19143# VSS 0.18625f
C14208 a_7332_19458# VSS 0.04116f
C14209 a_7238_19458# VSS 0.35236f
C14210 a_6610_19458# VSS 0.18925f
C14211 a_6097_19381# VSS 0.16072f
C14212 a_5220_19445# VSS 0.61098f
C14213 a_5158_19445# VSS 0.57402f
C14214 a_4740_19458# VSS 0.04103f
C14215 a_4646_19458# VSS 0.26733f
C14216 a_3592_19106# VSS 0.1174f ; **FLOATING
C14217 a_4070_19020# VSS 0.32526f
C14218 sg13cmos5l_dlygate4sd3_1_51.X VSS 0.04385f
C14219 a_1192_19020# VSS 0.31504f
C14220 sg13cmos5l_inv_1_33.Y VSS 0.16455f
C14221 sg13cmos5l_buf_1_25.A VSS 0.04355f
C14222 a_21838_19959# VSS 0.11405f
C14223 a_21089_19960# VSS 0.32779f
C14224 a_18514_19770# VSS 0.34709f
C14225 a_19642_19738# VSS 0.35502f
C14226 a_18001_19847# VSS 0.37149f
C14227 a_17062_19783# VSS 0.52405f
C14228 a_17124_19783# VSS 0.56071f
C14229 a_18297_20085# VSS 0.09894f
C14230 a_16644_19770# VSS 0.89391f
C14231 a_15922_19770# VSS 0.34709f
C14232 a_16550_19770# VSS 0.28476f
C14233 sg13cmos5l_dlygate4sd3_1_82.X VSS 0.11986f
C14234 sg13cmos5l_dfrbpq_1_34.Q VSS 0.16928f
C14235 a_15409_19847# VSS 0.14542f
C14236 a_14532_19783# VSS 0.03666f
C14237 a_14052_19770# VSS 0.387f
C14238 a_11026_19770# VSS 0.26512f
C14239 a_14601_20161# VSS 1.01521f
C14240 a_13958_19770# VSS 0.62419f
C14241 sg13cmos5l_buf_1_45.X VSS 8.55981f
C14242 sg13cmos5l_o21ai_1_26.B1 VSS 0.04703f
C14243 a_13676_19734# VSS 0.06784f
C14244 a_12929_19960# VSS 0.16859f
C14245 sg13cmos5l_o21ai_1_17.B1 VSS 0.07525f
C14246 sg13cmos5l_a21oi_1_21.A1 VSS 0.04063f
C14247 a_10513_19847# VSS 0.14528f
C14248 a_9574_19783# VSS 1.06072f
C14249 a_9636_19783# VSS 0.53948f
C14250 a_10809_20085# VSS 0.09851f
C14251 sg13cmos5l_buf_1_63.A VSS 0.10802f
C14252 a_9156_19770# VSS 0.21355f
C14253 a_9705_20161# VSS 0.0569f
C14254 a_9348_20088# VSS 0.04288f
C14255 a_9062_19770# VSS 0.35004f
C14256 a_8960_19902# VSS 0.04027f ; **FLOATING
C14257 sg13cmos5l_dfrbpq_1_21.D VSS 0.0428f
C14258 sg13cmos5l_o21ai_1_7.Y VSS 0.03804f
C14259 a_7822_19959# VSS 0.16372f
C14260 a_7073_19960# VSS 0.33495f
C14261 a_6490_19738# VSS 0.24797f
C14262 sg13cmos5l_dfrbpq_1_20.Q VSS 0.17922f
C14263 a_4168_19902# VSS 0.09796f ; **FLOATING
C14264 a_3296_19902# VSS 0.04078f ; **FLOATING
C14265 a_3112_19902# VSS 0.10625f ; **FLOATING
C14266 sg13cmos5l_o21ai_1_21.B1 VSS 0.10763f
C14267 a_1690_19738# VSS 0.40596f
C14268 sg13cmos5l_buf_1_15.A.n0 VSS 7.32326f
C14269 sg13cmos5l_buf_1_15.A.n1 VSS 2.85532f
C14270 sg13cmos5l_buf_1_15.A.n2 VSS 3.24838f
C14271 sg13cmos5l_buf_1_15.A.n3 VSS 2.6352f
C14272 sg13cmos5l_buf_1_15.A.n4 VSS 1.93711f
C14273 sg13cmos5l_buf_1_15.A.t0 VSS 0.25002f
C14274 sg13cmos5l_buf_1_45.X.n0 VSS 1.8346f
C14275 sg13cmos5l_buf_1_45.X.n1 VSS 2.41221f
C14276 sg13cmos5l_buf_1_45.X.n2 VSS 1.18751f
C14277 sg13cmos5l_buf_1_45.X.n3 VSS 1.09966f
C14278 sg13cmos5l_buf_1_45.X.n4 VSS 1.13027f
C14279 sg13cmos5l_buf_1_45.X.n5 VSS 1.76904f
C14280 sg13cmos5l_buf_1_45.X.n6 VSS 2.66666f
C14281 sg13cmos5l_buf_1_45.X.t0 VSS 0.47518f
C14282 sg13cmos5l_dfrbpq_1_28.RESET_B.t0 VSS 0.37485f
C14283 sg13cmos5l_dfrbpq_1_28.RESET_B.n0 VSS 1.34261f
C14284 sg13cmos5l_dfrbpq_1_28.RESET_B.n1 VSS 1.05527f
C14285 sg13cmos5l_dfrbpq_1_28.RESET_B.n2 VSS 2.41901f
C14286 sg13cmos5l_dfrbpq_1_28.RESET_B.n3 VSS 1.22534f
C14287 sg13cmos5l_dfrbpq_1_28.RESET_B.n4 VSS 0.68022f
C14288 sg13cmos5l_dfrbpq_1_28.RESET_B.n5 VSS 2.64375f
C14289 sg13cmos5l_dfrbpq_1_28.RESET_B.n6 VSS 2.42066f
C14290 sg13cmos5l_buf_8_2.A.t0 VSS 1.13575f
C14291 sg13cmos5l_buf_8_2.A.n0 VSS 4.12331f
C14292 sg13cmos5l_buf_8_2.A.n1 VSS 2.29557f
C14293 sg13cmos5l_buf_8_2.A.n2 VSS 2.95684f
C14294 sg13cmos5l_buf_8_2.A.n3 VSS 3.37804f
C14295 sg13cmos5l_buf_8_2.A.n4 VSS 1.20304f
C14296 sg13cmos5l_buf_8_2.A.n5 VSS 2.14577f
C14297 sg13cmos5l_buf_8_2.A.n6 VSS 2.03522f
C14298 sg13cmos5l_o21ai_1_5.A2.n0 VSS 1.60516f
C14299 sg13cmos5l_o21ai_1_5.A2.t0 VSS 0.28552f
C14300 sg13cmos5l_o21ai_1_5.A2.n1 VSS 1.59359f
C14301 sg13cmos5l_o21ai_1_5.A2.n2 VSS 1.58626f
C14302 sg13cmos5l_o21ai_1_5.A2.n3 VSS 2.00278f
C14303 sg13cmos5l_o21ai_1_5.A2.n4 VSS 3.87713f
C14304 sg13cmos5l_o21ai_1_5.A2.n5 VSS 1.99983f
C14305 VSS.t271 VSS 0.95768f
C14306 VSS.t242 VSS 0.52968f
C14307 VSS.t253 VSS 0.4402f
C14308 VSS.t2 VSS 0.21203f
C14309 VSS.t674 VSS 0.80383f
C14310 VSS.t493 VSS 1.55479f
C14311 VSS.t169 VSS 0.93288f
C14312 VSS.t266 VSS 2.77298f
C14313 VSS.t264 VSS 1.01819f
C14314 VSS.t1941 VSS 0.09906f
C14315 VSS.t571 VSS 0.0209f
C14316 VSS.t1834 VSS 0.06627f
C14317 VSS.t1646 VSS 0.13253f
C14318 VSS.t2083 VSS 0.33301f
C14319 VSS.t2088 VSS 0.27962f
C14320 VSS.t2093 VSS 0.06627f
C14321 VSS.t2098 VSS 0.06627f
C14322 VSS.t2103 VSS 0.06627f
C14323 VSS.t2108 VSS 0.06627f
C14324 VSS.t2113 VSS 0.06627f
C14325 VSS.t2118 VSS 0.06627f
C14326 VSS.t2123 VSS 0.06627f
C14327 VSS.t2128 VSS 0.06627f
C14328 VSS.t2133 VSS 0.06627f
C14329 VSS.t2138 VSS 0.06627f
C14330 VSS.t2143 VSS 0.06627f
C14331 VSS.t2148 VSS 0.06627f
C14332 VSS.t2153 VSS 0.06627f
C14333 VSS.t2158 VSS 0.06627f
C14334 VSS.t1999 VSS 0.0656f
C14335 VSS.t1997 VSS 0.06627f
C14336 VSS.t273 VSS 2.78907f
C14337 VSS.t22 VSS 1.38737f
C14338 VSS.t192 VSS 0.31903f
C14339 VSS.t850 VSS 0.13119f
C14340 VSS.t2045 VSS 0.06627f
C14341 VSS.t1981 VSS 0.06627f
C14342 VSS.t1966 VSS 4.05869f
C14343 VSS.t1971 VSS 4.12496f
C14344 VSS.t9 VSS 0.84423f
C14345 VSS.t17 VSS 0.23004f
C14346 VSS.t7 VSS 2.63093f
C14347 VSS.t232 VSS 0.19446f
C14348 VSS.t222 VSS 0.73765f
C14349 VSS.t153 VSS 3.30294f
C14350 VSS.t344 VSS 0.0328f
C14351 VSS.t50 VSS 0.14528f
C14352 VSS.t74 VSS 0.91201f
C14353 VSS.t1211 VSS 0.06627f
C14354 VSS.t1757 VSS 0.09906f
C14355 VSS.t1747 VSS 0.13253f
C14356 VSS.t1742 VSS 0.13253f
C14357 VSS.t1741 VSS 0.13253f
C14358 VSS.t918 VSS 0.37926f
C14359 VSS.t89 VSS 0.81971f
C14360 VSS.t1842 VSS 0.06627f
C14361 VSS.t1832 VSS 0.13253f
C14362 VSS.t1836 VSS 0.06627f
C14363 VSS.t1835 VSS 0.06627f
C14364 VSS.t1849 VSS 0.06627f
C14365 VSS.t1208 VSS 0.06627f
C14366 VSS.t388 VSS 0.79688f
C14367 VSS.t260 VSS 1.742f
C14368 VSS.t190 VSS 0.05746f
C14369 VSS.t569 VSS 1.7445f
C14370 VSS.t441 VSS 0.29655f
C14371 VSS.t97 VSS 1.63663f
C14372 VSS.t81 VSS 0.65016f
C14373 VSS.t545 VSS 0.28701f
C14374 VSS.t83 VSS 1.37113f
C14375 VSS.t15 VSS 2.40209f
C14376 VSS.t342 VSS 0.46267f
C14377 VSS.t284 VSS 0.9638f
C14378 VSS.t101 VSS 0.51566f
C14379 VSS.t759 VSS 0.0328f
C14380 VSS.t1053 VSS 0.27582f
C14381 VSS.t779 VSS 0.04573f
C14382 VSS.t812 VSS 0.2023f
C14383 VSS.t1902 VSS 0.0656f
C14384 VSS.t702 VSS 0.38699f
C14385 VSS.t1885 VSS 0.09906f
C14386 VSS.t1702 VSS 0.13253f
C14387 VSS.t1698 VSS 0.13253f
C14388 VSS.t1703 VSS 0.13253f
C14389 VSS.t182 VSS 0.41057f
C14390 VSS.t67 VSS 1.05144f
C14391 VSS.t196 VSS 1.17365f
C14392 VSS.t159 VSS 1.20048f
C14393 VSS.t150 VSS 0.12654f
C14394 VSS.t245 VSS 0.49114f
C14395 VSS.t576 VSS 0.08007f
C14396 VSS.t172 VSS 0.08639f
C14397 VSS.t164 VSS 0.17335f
C14398 VSS.t129 VSS 0.42751f
C14399 VSS.t949 VSS 0.08395f
C14400 VSS.t1059 VSS 0.40752f
C14401 VSS.t1353 VSS 0.08703f
C14402 VSS.t583 VSS 0.22223f
C14403 VSS.t395 VSS 0.65695f
C14404 VSS.t396 VSS 0.62459f
C14405 VSS.t163 VSS 0.76131f
C14406 VSS.t239 VSS 0.08389f
C14407 VSS.t79 VSS 1.22674f
C14408 VSS.t199 VSS 0.49272f
C14409 VSS.t136 VSS 0.79607f
C14410 VSS.t393 VSS 4.42883f
C14411 VSS.t201 VSS 1.36074f
C14412 VSS.t653 VSS 0.0656f
C14413 VSS.t46 VSS 0.13253f
C14414 VSS.t500 VSS 0.72336f
C14415 VSS.t514 VSS 0.08389f
C14416 VSS.t634 VSS 0.2524f
C14417 VSS.t132 VSS 1.24701f
C14418 VSS.t863 VSS 0.33782f
C14419 VSS.t134 VSS 1.42104f
C14420 VSS.t373 VSS 0.79715f
C14421 VSS.t437 VSS 0.08945f
C14422 VSS.t204 VSS 0.82268f
C14423 VSS.t52 VSS 0.67888f
C14424 VSS.t402 VSS 0.47724f
C14425 VSS.t54 VSS 0.04022f
C14426 VSS.t48 VSS 0.80119f
C14427 VSS.t839 VSS 0.31689f
C14428 VSS.t375 VSS 0.41405f
C14429 VSS.t407 VSS 0.93802f
C14430 VSS.t176 VSS 0.46025f
C14431 VSS.t228 VSS 0.08855f
C14432 VSS.t1112 VSS 0.07832f
C14433 VSS.t384 VSS 0.12356f
C14434 VSS.t70 VSS 0.23454f
C14435 VSS.t69 VSS 0.697f
C14436 VSS.t58 VSS 0.83001f
C14437 VSS.t56 VSS 0.84639f
C14438 VSS.t5 VSS 1.01332f
C14439 VSS.t953 VSS 0.21513f
C14440 VSS.t382 VSS 0.28333f
C14441 VSS.t380 VSS 1.59132f
C14442 VSS.t726 VSS 0.14025f
C14443 VSS.t113 VSS 0.91427f
C14444 VSS.t1315 VSS 0.55473f
C14445 VSS.t922 VSS 0.18996f
C14446 VSS.t180 VSS 0.61693f
C14447 VSS.t91 VSS 0.96585f
C14448 VSS.t117 VSS 0.96922f
C14449 VSS.t435 VSS 1.26629f
C14450 VSS.t587 VSS 0.23013f
C14451 VSS.t455 VSS 0.23079f
C14452 VSS.t831 VSS 0.48735f
C14453 VSS.t1433 VSS 0.32949f
C14454 VSS.t107 VSS 1.1932f
C14455 VSS.t915 VSS 0.06784f
C14456 VSS.t927 VSS 0.43183f
C14457 VSS.t2518 VSS 0.04167f
C14458 VSS.t105 VSS 0.57804f
C14459 VSS.t307 VSS 0.04149f
C14460 VSS.t423 VSS 0.77548f
C14461 VSS.t422 VSS 0.11986f
C14462 VSS.t357 VSS 0.33123f
C14463 VSS.t931 VSS 1.60134f
C14464 VSS.t1436 VSS 0.7136f
C14465 VSS.t1056 VSS 0.64136f
C14466 VSS.t1099 VSS 1.81557f
C14467 VSS.t937 VSS 0.86298f
C14468 VSS.t1155 VSS 0.59963f
C14469 VSS.t1127 VSS 0.28618f
C14470 VSS.t1130 VSS 0.54267f
C14471 VSS.t1132 VSS 0.54913f
C14472 VSS.t369 VSS 0.69848f
C14473 VSS.t1614 VSS 0.06627f
C14474 VSS.t997 VSS 0.06627f
C14475 VSS.t853 VSS 0.1935f
C14476 VSS.t1609 VSS 0.06627f
C14477 VSS.t400 VSS 0.26587f
C14478 VSS.t1618 VSS 0.13253f
C14479 VSS.t1623 VSS 0.13253f
C14480 VSS.t1628 VSS 0.13253f
C14481 VSS.t1632 VSS 0.19813f
C14482 VSS.t1644 VSS 0.06627f
C14483 VSS.t1643 VSS 0.13253f
C14484 VSS.t1649 VSS 0.09906f
C14485 VSS.t309 VSS 0.46643f
C14486 VSS.t1645 VSS 0.06627f
C14487 VSS.t1658 VSS 0.1988f
C14488 VSS.t230 VSS 0.50172f
C14489 VSS.t312 VSS 0.1766f
C14490 VSS.t1676 VSS 0.06627f
C14491 VSS.t585 VSS 3.05916f
C14492 VSS.t124 VSS 0.7423f
C14493 VSS.t1683 VSS 0.13253f
C14494 VSS.t1688 VSS 0.13253f
C14495 VSS.t1693 VSS 0.13253f
C14496 VSS.t1135 VSS 0.15937f
C14497 VSS.t677 VSS 0.8029f
C14498 VSS.t72 VSS 1.42873f
C14499 VSS.t1737 VSS 0.13253f
C14500 VSS.t1732 VSS 0.13253f
C14501 VSS.t1727 VSS 0.13253f
C14502 VSS.t1722 VSS 0.13253f
C14503 VSS.t1803 VSS 0.06627f
C14504 VSS.t820 VSS 0.06627f
C14505 VSS.t1800 VSS 0.06627f
C14506 VSS.t1795 VSS 0.13253f
C14507 VSS.t1790 VSS 0.13253f
C14508 VSS.t1785 VSS 0.13253f
C14509 VSS.t1805 VSS 0.13253f
C14510 VSS.t845 VSS 0.18902f
C14511 VSS.t174 VSS 0.48886f
C14512 VSS.t161 VSS 0.71969f
C14513 VSS.t120 VSS 1.03676f
C14514 VSS.t86 VSS 4.88536f
C14515 VSS.t248 VSS 0.2431f
C14516 VSS.t103 VSS 1.01218f
C14517 VSS.t1083 VSS 0.09843f
C14518 VSS.t596 VSS 0.33759f
C14519 VSS.t76 VSS 0.85899f
C14520 VSS.t547 VSS 0.28863f
C14521 VSS.t1921 VSS 0.13253f
C14522 VSS.t1916 VSS 0.13253f
C14523 VSS.t1911 VSS 0.13253f
C14524 VSS.t1906 VSS 0.13253f
C14525 VSS.t2078 VSS 16.23477f
C14526 VSS.t1926 VSS 0.13253f
C14527 VSS.t1931 VSS 0.13253f
C14528 VSS.t1936 VSS 0.13253f
C14529 VSS.t1963 VSS 0.06627f
C14530 VSS.t1964 VSS 0.26317f
C14531 VSS.t293 VSS 2.44709f
C14532 VSS.t279 VSS 1.16965f
C14533 VSS.t825 VSS 0.0656f
C14534 VSS.t206 VSS 0.2015f
C14535 VSS.t13 VSS 1.45513f
C14536 VSS.t39 VSS 0.62888f
C14537 VSS.t11 VSS 1.82472f
C14538 VSS.t479 VSS 1.39288f
C14539 VSS.t237 VSS 0.27418f
C14540 VSS.t1938 VSS 0.06627f
C14541 VSS.t1872 VSS 0.06627f
C14542 VSS.t1875 VSS 0.13253f
C14543 VSS.t1870 VSS 0.13253f
C14544 VSS.t1864 VSS 0.06627f
C14545 VSS.t1865 VSS 0.13253f
C14546 VSS.t1860 VSS 0.13253f
C14547 VSS.t1880 VSS 0.13253f
C14548 VSS.t1884 VSS 0.0328f
C14549 VSS.t19 VSS 0.2749f
C14550 VSS.t26 VSS 0.78763f
C14551 VSS.t37 VSS 0.5866f
C14552 VSS.t31 VSS 1.26531f
C14553 VSS.t99 VSS 0.52322f
C14554 VSS.t1752 VSS 0.13253f
C14555 VSS.t1756 VSS 0.0328f
C14556 VSS.t1754 VSS 0.13253f
C14557 VSS.t1781 VSS 0.06627f
C14558 VSS.t1206 VSS 0.21209f
C14559 VSS.t111 VSS 0.10538f
C14560 VSS.t498 VSS 0.1924f
C14561 VSS.t887 VSS 0.10525f
C14562 VSS.t122 VSS 0.82226f
C14563 VSS.t762 VSS 0.65796f
C14564 VSS.t210 VSS 0.60471f
C14565 VSS.t2188 VSS 0.06627f
C14566 VSS.t2183 VSS 0.06627f
C14567 VSS.t2178 VSS 0.06627f
C14568 VSS.t2173 VSS 0.06627f
C14569 VSS.t2168 VSS 0.06627f
C14570 VSS.t2162 VSS 0.06627f
C14571 VSS.t2163 VSS 0.06627f
C14572 VSS.t2193 VSS 0.06627f
C14573 VSS.t269 VSS 0.2229f
C14574 VDD.n0 VSS 0.30842f
C14575 VDD.n1 VSS 0.15053f
C14576 VDD.n2 VSS 0.24346f
C14577 VDD.n3 VSS 0.23338f
C14578 VDD.n4 VSS 0.57616f
C14579 VDD.n5 VSS 0.27861f
C14580 VDD.n7 VSS 0.51907f
C14581 VDD.n8 VSS 0.07537f
C14582 VDD.n9 VSS 0.21961f
C14583 VDD.n10 VSS 0.08613f
C14584 VDD.n12 VSS 0.06298f
C14585 VDD.n13 VSS 0.10463f
C14586 VDD.n14 VSS 0.50691f
C14587 VDD.n16 VSS 1.20655f
C14588 VDD.n17 VSS 0.23203f
C14589 VDD.n18 VSS 0.55866f
C14590 VDD.n19 VSS 0.21006f
C14591 VDD.n21 VSS 0.01834f
C14592 VDD.n22 VSS 0.08686f
C14593 VDD.n23 VSS 0.01289f
C14594 VDD.n24 VSS 0.07943f
C14595 VDD.n25 VSS 0.0778f
C14596 VDD.n26 VSS 0.21068f
C14597 VDD.n27 VSS 0.56237f
C14598 VDD.t231 VSS 32.49778f
C14599 VDD.n28 VSS 0.06593f
C14600 VDD.t310 VSS 33.84698f
C14601 VDD.n29 VSS 0.03546f
C14602 VDD.n30 VSS 0.1046f
C14603 VDD.n31 VSS 0.10463f
C14604 VDD.n32 VSS 1.1124f
C14605 VDD.n34 VSS 1.68841f
C14606 VDD.n36 VSS 0.25822f
C14607 VDD.n38 VSS 0.90038f
C14608 VDD.n39 VSS 0.43435f
C14609 VDD.n40 VSS 0.24466f
C14610 VDD.n41 VSS 0.10463f
C14611 VDD.n42 VSS 0.1046f
C14612 VDD.n43 VSS 0.1046f
C14613 VDD.n44 VSS 0.10463f
C14614 VDD.n45 VSS 1.81024f
C14615 VDD.n48 VSS 0.10463f
C14616 VDD.n49 VSS 0.10463f
C14617 VDD.t617 VSS 0.86938f
C14618 VDD.n50 VSS 0.01919f
C14619 VDD.n51 VSS 0.21329f
C14620 VDD.n52 VSS 0.70084f
C14621 VDD.n53 VSS 0.99917f
C14622 VDD.n55 VSS 0.1046f
C14623 VDD.n56 VSS 0.80231f
C14624 VDD.n57 VSS 0.06061f
C14625 VDD.n58 VSS 0.34371f
C14626 VDD.n59 VSS 0.40011f
C14627 VDD.n61 VSS 0.1046f
C14628 VDD.n63 VSS 0.10463f
C14629 VDD.n64 VSS 0.10463f
C14630 VDD.n65 VSS 0.77031f
C14631 VDD.n66 VSS 0.42325f
C14632 VDD.n67 VSS 0.4813f
C14633 VDD.n68 VSS 0.09521f
C14634 VDD.n69 VSS 0.1841f
C14635 VDD.n71 VSS 0.01919f
C14636 VDD.n72 VSS 0.10463f
C14637 VDD.n73 VSS 0.39922f
C14638 VDD.n74 VSS 0.87977f
C14639 VDD.n75 VSS 0.72698f
C14640 VDD.n76 VSS 2.22497f
C14641 VDD.n77 VSS 0.14016f
C14642 VDD.n78 VSS 0.01919f
C14643 VDD.n79 VSS 0.15813f
C14644 VDD.n80 VSS 0.33771f
C14645 VDD.n82 VSS 0.06581f
C14646 VDD.n83 VSS 0.8799f
C14647 VDD.n84 VSS 0.06581f
C14648 VDD.n85 VSS 0.8799f
C14649 VDD.n86 VSS 0.06581f
C14650 VDD.n87 VSS 0.8799f
C14651 VDD.n88 VSS 0.06581f
C14652 VDD.n89 VSS 0.8799f
C14653 VDD.n90 VSS 0.50169f
C14654 VDD.n91 VSS 0.38458f
C14655 VDD.n92 VSS 0.05543f
C14656 VDD.n93 VSS 0.01174f
C14657 VDD.n94 VSS 0.20016f
C14658 VDD.n95 VSS 0.08857f
C14659 VDD.n96 VSS 0.01919f
C14660 VDD.n97 VSS 0.19182f
C14661 VDD.n98 VSS 0.01758f
C14662 VDD.n99 VSS 0.06581f
C14663 VDD.n101 VSS 0.42438f
C14664 VDD.n102 VSS 0.10828f
C14665 VDD.n103 VSS 0.19693f
C14666 VDD.n104 VSS 0.31668f
C14667 VDD.n106 VSS 0.41173f
C14668 VDD.n107 VSS 0.23338f
C14669 VDD.n110 VSS 0.43747f
C14670 VDD.n112 VSS 0.0966f
C14671 VDD.n113 VSS 0.27495f
C14672 VDD.n115 VSS 0.17849f
C14673 VDD.n116 VSS 0.177f
C14674 VDD.n118 VSS 0.27639f
C14675 VDD.t268 VSS 9.63323f
C14676 VDD.n119 VSS 0.10475f
C14677 VDD.n121 VSS 0.10463f
C14678 VDD.n122 VSS 0.17364f
C14679 VDD.n123 VSS 0.189f
C14680 VDD.n124 VSS 0.1729f
C14681 VDD.n125 VSS 0.11133f
C14682 VDD.n128 VSS 0.18044f
C14683 VDD.n129 VSS 0.32385f
C14684 VDD.n131 VSS 0.23338f
C14685 VDD.n132 VSS 0.1046f
C14686 VDD.n133 VSS 0.14342f
C14687 VDD.n135 VSS 0.11725f
C14688 VDD.n136 VSS 0.17862f
C14689 VDD.n138 VSS 0.04321f
C14690 VDD.n139 VSS 0.18896f
C14691 VDD.n141 VSS 0.16776f
C14692 VDD.n142 VSS 0.13496f
C14693 VDD.n143 VSS 0.04452f
C14694 VDD.n144 VSS 0.2094f
C14695 VDD.n146 VSS 0.13136f
C14696 VDD.n148 VSS 0.10809f
C14697 VDD.n149 VSS 0.18091f
C14698 VDD.t2 VSS 32.58952f
C14699 VDD.n150 VSS 0.04967f
C14700 VDD.n152 VSS 0.09544f
C14701 VDD.n153 VSS 0.08925f
C14702 VDD.n154 VSS 0.12909f
C14703 VDD.n156 VSS 0.01919f
C14704 VDD.n157 VSS 0.08515f
C14705 VDD.n159 VSS 0.09609f
C14706 VDD.n161 VSS 0.06999f
C14707 VDD.t5 VSS 31.0364f
C14708 VDD.n163 VSS 0.44221f
C14709 VDD.n164 VSS 0.13466f
C14710 VDD.n165 VSS 0.05586f
C14711 VDD.n166 VSS 0.07599f
C14712 VDD.n168 VSS 0.05501f
C14713 VDD.n169 VSS 0.08946f
C14714 VDD.n170 VSS 0.06404f
C14715 VDD.n171 VSS 0.0182f
C14716 VDD.n172 VSS 0.07809f
C14717 VDD.n173 VSS 0.05752f
C14718 VDD.n174 VSS 0.07774f
C14719 VDD.n175 VSS 0.01009f
C14720 VDD.n176 VSS 0.05754f
C14721 VDD.n177 VSS 0.07517f
C14722 VDD.n178 VSS 0.09134f
C14723 VDD.n179 VSS 0.0638f
C14724 VDD.n180 VSS 0.08188f
C14725 VDD.n181 VSS 0.44221f
C14726 VDD.n182 VSS 0.11451f
C14727 VDD.n184 VSS 0.18372f
C14728 VDD.n186 VSS 0.18372f
C14729 VDD.n188 VSS 0.02767f
C14730 VDD.n189 VSS 0.18372f
C14731 VDD.n191 VSS 0.05981f
C14732 VDD.n193 VSS 0.08415f
C14733 VDD.n194 VSS 0.09405f
C14734 VDD.n195 VSS 0.06271f
C14735 VDD.n196 VSS 0.12019f
C14736 VDD.n197 VSS 0.10402f
C14737 VDD.n199 VSS 0.1046f
C14738 VDD.n200 VSS 0.17676f
C14739 VDD.n202 VSS 0.08332f
C14740 VDD.n204 VSS 0.09154f
C14741 VDD.n205 VSS 0.01354f
C14742 VDD.n206 VSS 0.102f
C14743 VDD.n208 VSS 0.09315f
C14744 VDD.n209 VSS 0.09999f
C14745 VDD.n210 VSS 0.07542f
C14746 VDD.n211 VSS 0.09392f
C14747 VDD.n212 VSS 0.01268f
C14748 VDD.n213 VSS 0.20171f
C14749 VDD.n214 VSS 0.05343f
C14750 VDD.n215 VSS 0.0801f
C14751 VDD.n217 VSS 0.11891f
C14752 VDD.n218 VSS 0.11593f
C14753 VDD.n220 VSS 0.07273f
C14754 VDD.n222 VSS 0.07786f
C14755 VDD.n223 VSS 0.08103f
C14756 VDD.n225 VSS 0.09053f
C14757 VDD.n226 VSS 0.01919f
C14758 VDD.n227 VSS 0.0949f
C14759 VDD.n228 VSS 0.07751f
C14760 VDD.n230 VSS 0.08901f
C14761 VDD.n231 VSS 0.12869f
C14762 VDD.n232 VSS 0.12192f
C14763 VDD.n233 VSS 0.07686f
C14764 VDD.n234 VSS 0.15684f
C14765 VDD.n235 VSS 0.08461f
C14766 VDD.n237 VSS 0.10295f
C14767 VDD.n239 VSS 0.11549f
C14768 VDD.n241 VSS 0.07005f
C14769 VDD.t270 VSS 19.3593f
C14770 VDD.n245 VSS 0.12367f
C14771 VDD.n246 VSS 0.10463f
C14772 VDD.n247 VSS 0.0931f
C14773 VDD.n249 VSS 0.10463f
C14774 VDD.n250 VSS 0.07046f
C14775 VDD.n251 VSS 0.1046f
C14776 VDD.n252 VSS 0.10463f
C14777 VDD.n253 VSS 0.09593f
C14778 VDD.n254 VSS 0.1046f
C14779 VDD.n255 VSS 0.10463f
C14780 VDD.n256 VSS 0.09593f
C14781 VDD.n257 VSS 0.1046f
C14782 VDD.n258 VSS 0.08708f
C14783 VDD.n260 VSS 0.1938f
C14784 VDD.n261 VSS 0.10463f
C14785 VDD.n262 VSS 0.08921f
C14786 VDD.n263 VSS 0.10463f
C14787 VDD.n264 VSS 0.08456f
C14788 VDD.n265 VSS 0.23338f
C14789 VDD.n266 VSS 0.1046f
C14790 VDD.n267 VSS 0.10463f
C14791 VDD.n268 VSS 0.09593f
C14792 VDD.n269 VSS 0.10463f
C14793 VDD.n270 VSS 0.07531f
C14794 VDD.n271 VSS 0.1046f
C14795 VDD.n272 VSS 0.10463f
C14796 VDD.n273 VSS 0.09789f
C14797 VDD.n274 VSS 0.1046f
C14798 VDD.n275 VSS 0.10463f
C14799 VDD.n276 VSS 0.09593f
C14800 VDD.n280 VSS 0.05623f
C14801 VDD.n281 VSS 0.03618f
C14802 VDD.n283 VSS 0.17478f
C14803 VDD.n285 VSS 0.11803f
C14804 VDD.n286 VSS 0.01788f
C14805 VDD.n287 VSS 0.13713f
C14806 VDD.n290 VSS 0.06822f
C14807 VDD.n292 VSS 0.12212f
C14808 VDD.n293 VSS 0.03088f
C14809 VDD.n294 VSS 0.11758f
C14810 VDD.n295 VSS 0.50432f
C14811 VDD.n296 VSS 0.01549f
C14812 VDD.n297 VSS 0.09337f
C14813 VDD.n298 VSS 0.01391f
C14814 VDD.n299 VSS 0.08495f
C14815 VDD.n300 VSS 0.05568f
C14816 VDD.n301 VSS 0.08307f
C14817 VDD.n302 VSS 0.03454f
C14818 VDD.n303 VSS 0.05347f
C14819 VDD.t16 VSS 31.2753f
C14820 VDD.n305 VSS 0.06411f
C14821 VDD.n306 VSS 0.07884f
C14822 VDD.n307 VSS 0.07973f
C14823 VDD.n308 VSS 0.09612f
C14824 VDD.n309 VSS 0.01343f
C14825 VDD.n310 VSS 0.09358f
C14826 VDD.n312 VSS 0.0627f
C14827 VDD.n313 VSS 0.10463f
C14828 VDD.n314 VSS 0.1046f
C14829 VDD.n315 VSS 0.10463f
C14830 VDD.n316 VSS 0.22336f
C14831 VDD.n317 VSS 0.12811f
C14832 VDD.n319 VSS 0.20626f
C14833 VDD.n320 VSS 0.10463f
C14834 VDD.n321 VSS 0.1046f
C14835 VDD.n322 VSS 0.10463f
C14836 VDD.n323 VSS 0.1046f
C14837 VDD.n324 VSS 0.10463f
C14838 VDD.n325 VSS 0.1046f
C14839 VDD.n326 VSS 0.10463f
C14840 VDD.n327 VSS 0.1046f
C14841 VDD.n328 VSS 0.10463f
C14842 VDD.n329 VSS 0.13226f
C14843 VDD.n330 VSS 0.15326f
C14844 VDD.n331 VSS 0.11028f
C14845 VDD.n332 VSS 0.22265f
C14846 VDD.n334 VSS 0.43306f
C14847 VDD.n335 VSS 0.11028f
C14848 VDD.n336 VSS 0.22265f
C14849 VDD.n338 VSS 0.11028f
C14850 VDD.n339 VSS 0.22265f
C14851 VDD.n341 VSS 0.23417f
C14852 VDD.n343 VSS 0.23348f
C14853 VDD.n345 VSS 0.05201f
C14854 VDD.n346 VSS 0.25768f
C14855 VDD.n347 VSS 0.1304f
C14856 VDD.n349 VSS 0.11654f
C14857 VDD.n350 VSS 0.06271f
C14858 VDD.n351 VSS 0.09735f
C14859 VDD.n352 VSS 0.21991f
C14860 VDD.n353 VSS 0.11572f
C14861 VDD.n354 VSS 0.01919f
C14862 VDD.n355 VSS 0.1808f
C14863 VDD.n356 VSS 0.29183f
C14864 VDD.n358 VSS 0.29183f
C14865 VDD.n360 VSS 0.11663f
C14866 VDD.n361 VSS 0.21773f
C14867 VDD.n362 VSS 0.01919f
C14868 VDD.n363 VSS 0.11631f
C14869 VDD.n364 VSS 0.01919f
C14870 VDD.n365 VSS 0.01043f
C14871 VDD.n366 VSS 0.10834f
C14872 VDD.n367 VSS 0.12427f
C14873 VDD.n369 VSS 0.25478f
C14874 VDD.n370 VSS 0.11261f
C14875 VDD.n371 VSS 0.12576f
C14876 VDD.n373 VSS 0.13095f
C14877 VDD.n374 VSS 0.15487f
C14878 VDD.n376 VSS 0.16954f
C14879 VDD.n377 VSS 0.01919f
C14880 VDD.n378 VSS 0.09787f
C14881 VDD.n380 VSS 0.01492f
C14882 VDD.n381 VSS 0.06271f
C14883 VDD.n382 VSS 0.01919f
C14884 VDD.n383 VSS 0.20616f
C14885 VDD.n384 VSS 0.18876f
C14886 VDD.n386 VSS 0.05314f
C14887 VDD.n387 VSS 0.10976f
C14888 VDD.n389 VSS 0.09945f
C14889 VDD.n390 VSS 0.05177f
C14890 VDD.n391 VSS 0.18807f
C14891 VDD.n392 VSS 0.14305f
C14892 VDD.n393 VSS 0.0101f
C14893 VDD.n394 VSS 0.11421f
C14894 VDD.n395 VSS 0.1331f
C14895 VDD.n396 VSS 0.01039f
C14896 VDD.n397 VSS 0.04241f
C14897 VDD.n398 VSS 0.01919f
C14898 VDD.n399 VSS 0.10798f
C14899 VDD.n401 VSS 0.12957f
C14900 VDD.n403 VSS 0.08595f
C14901 VDD.n405 VSS 0.086f
C14902 VDD.n408 VSS 0.01736f
C14903 VDD.n409 VSS 0.10708f
C14904 VDD.n410 VSS 0.14429f
C14905 VDD.n412 VSS 0.04055f
C14906 VDD.n413 VSS 0.09262f
C14907 VDD.n414 VSS 0.01084f
C14908 VDD.n415 VSS 0.04922f
C14909 VDD.n416 VSS 0.12613f
C14910 VDD.n417 VSS 0.08906f
C14911 VDD.n418 VSS 0.11553f
C14912 VDD.n420 VSS 0.0188f
C14913 VDD.n421 VSS 0.09223f
C14914 VDD.n422 VSS 0.10853f
C14915 VDD.n425 VSS 0.09988f
C14916 VDD.n426 VSS 0.04716f
C14917 VDD.n427 VSS 0.09082f
C14918 VDD.n429 VSS 0.09265f
C14919 VDD.n431 VSS 0.08258f
C14920 VDD.n432 VSS 0.07204f
C14921 VDD.n433 VSS 0.01297f
C14922 VDD.n434 VSS 0.03228f
C14923 VDD.n435 VSS 0.06861f
C14924 VDD.n436 VSS 0.01919f
C14925 VDD.n437 VSS 0.05271f
C14926 VDD.n439 VSS 0.06103f
C14927 VDD.n441 VSS 0.05295f
C14928 VDD.n443 VSS 0.05295f
C14929 VDD.n444 VSS 0.09184f
C14930 VDD.n445 VSS 0.03178f
C14931 VDD.n446 VSS 0.09187f
C14932 VDD.n447 VSS 0.03176f
C14933 VDD.n448 VSS 0.09187f
C14934 VDD.n449 VSS 0.03176f
C14935 VDD.n450 VSS 0.01919f
C14936 VDD.n451 VSS 0.06864f
C14937 VDD.n452 VSS 0.01967f
C14938 VDD.n453 VSS 0.09255f
C14939 VDD.n454 VSS 0.01919f
C14940 VDD.n455 VSS 0.08761f
C14941 VDD.n457 VSS 0.2406f
C14942 VDD.n458 VSS 0.2406f
C14943 VDD.n459 VSS 0.01489f
C14944 VDD.n461 VSS 0.01582f
C14945 VDD.n462 VSS 0.08583f
C14946 VDD.n463 VSS 0.08895f
C14947 VDD.n464 VSS 0.01582f
C14948 VDD.n465 VSS 0.01199f
C14949 VDD.n466 VSS 0.01329f
C14950 VDD.n467 VSS 0.07491f
C14951 VDD.n468 VSS 0.21876f
C14952 VDD.n470 VSS 0.21876f
C14953 VDD.n472 VSS 0.21876f
C14954 VDD.n473 VSS 0.01028f
C14955 VDD.n474 VSS 0.1126f
C14956 VDD.n475 VSS 0.0411f
C14957 VDD.n476 VSS 0.08132f
C14958 VDD.n478 VSS 0.13869f
C14959 VDD.n479 VSS 0.08997f
C14960 VDD.n481 VSS 0.10832f
C14961 VDD.n482 VSS 0.10807f
C14962 VDD.n483 VSS 0.02325f
C14963 VDD.n484 VSS 0.08525f
C14964 VDD.n485 VSS 0.0753f
C14965 VDD.n486 VSS 0.01866f
C14966 VDD.n487 VSS 0.10289f
C14967 VDD.n488 VSS 0.10278f
C14968 VDD.n489 VSS 0.08373f
C14969 VDD.n490 VSS 0.03755f
C14970 VDD.n491 VSS 0.05959f
C14971 VDD.n492 VSS 0.06271f
C14972 VDD.n495 VSS 0.50432f
C14973 VDD.n496 VSS 0.50432f
C14974 VDD.n497 VSS 0.50432f
C14975 VDD.n498 VSS 0.50432f
C14976 VDD.n499 VSS 0.05752f
C14977 VDD.n500 VSS 0.07406f
C14978 VDD.n502 VSS 0.10319f
C14979 VDD.n504 VSS 0.05707f
C14980 VDD.n505 VSS 0.01299f
C14981 VDD.n506 VSS 0.17978f
C14982 VDD.n507 VSS 0.09735f
C14983 VDD.n508 VSS 0.09735f
C14984 VDD.n509 VSS 0.09735f
C14985 VDD.n510 VSS 0.09735f
C14986 VDD.n511 VSS 0.11083f
C14987 VDD.n512 VSS 0.09735f
C14988 VDD.n513 VSS 0.09735f
C14989 VDD.n514 VSS 0.11608f
C14990 VDD.n515 VSS 0.09735f
C14991 VDD.n516 VSS 0.11083f
C14992 VDD.n517 VSS 0.09735f
C14993 VDD.n518 VSS 0.08536f
C14994 VDD.t83 VSS 32.20961f
C14995 VDD.n520 VSS 0.04467f
C14996 VDD.t0 VSS 31.89737f
C14997 VDD.n521 VSS 0.04964f
C14998 VDD.n522 VSS 0.1046f
C14999 VDD.n523 VSS 0.10463f
C15000 VDD.n524 VSS 0.0962f
C15001 VDD.n525 VSS 0.1046f
C15002 VDD.n526 VSS 0.10463f
C15003 VDD.n527 VSS 0.09743f
C15004 VDD.n528 VSS 0.02071f
C15005 VDD.n529 VSS 0.02189f
C15006 VDD.n530 VSS 0.04467f
C15007 VDD.n531 VSS 0.01903f
C15008 VDD.n532 VSS 0.0203f
C15009 VDD.t8 VSS 31.35167f
C15010 VDD.n533 VSS 0.11f
C15011 VDD.t19 VSS 36.2996f
C15012 VDD.n534 VSS 0.02221f
C15013 VDD.n535 VSS 0.03776f
C15014 VDD.t52 VSS 33.47554f
C15015 VDD.n536 VSS 0.11585f
C15016 VDD.n538 VSS 0.03797f
C15017 VDD.n542 VSS 0.01367f
C15018 VDD.n543 VSS 0.10289f
C15019 VDD.t299 VSS 0.45785f
C15020 VDD.t579 VSS 0.39108f
C15021 VDD.t618 VSS 0.24063f
C15022 VDD.t626 VSS 0.05797f
C15023 VDD.t620 VSS 0.17265f
C15024 VDD.t1388 VSS 0.05627f
C15025 VDD.t621 VSS 0.02314f
C15026 VDD.t355 VSS 0.02314f
C15027 VDD.t42 VSS 0.05797f
C15028 VDD.t356 VSS 0.05797f
C15029 VDD.t43 VSS 0.05627f
C15030 VDD.t402 VSS 0.05627f
C15031 VDD.t44 VSS 0.22194f
C15032 VDD.t220 VSS 0.05627f
C15033 VDD.t45 VSS 0.22364f
C15034 VDD.t140 VSS 0.05797f
C15035 VDD.t47 VSS 0.02313f
C15036 VDD.t141 VSS 0.02313f
C15037 VDD.t48 VSS 0.02314f
C15038 VDD.t413 VSS 0.02314f
C15039 VDD.t49 VSS 0.05797f
C15040 VDD.t66 VSS 0.05627f
C15041 VDD.t147 VSS 0.05627f
C15042 VDD.t67 VSS 0.02314f
C15043 VDD.t416 VSS 0.02314f
C15044 VDD.t68 VSS 0.02484f
C15045 VDD.t414 VSS 0.05797f
C15046 VDD.t71 VSS 0.02314f
C15047 VDD.t148 VSS 0.02314f
C15048 VDD.t72 VSS 0.02484f
C15049 VDD.t458 VSS 0.02313f
C15050 VDD.t224 VSS 0.05627f
C15051 VDD.t459 VSS 0.02314f
C15052 VDD.t417 VSS 0.02314f
C15053 VDD.t460 VSS 0.25677f
C15054 VDD.t156 VSS 0.05797f
C15055 VDD.t463 VSS 0.08941f
C15056 VDD.t1398 VSS 0.05627f
C15057 VDD.t464 VSS 0.09111f
C15058 VDD.t1391 VSS 0.05797f
C15059 VDD.t466 VSS 0.02313f
C15060 VDD.t1392 VSS 0.02313f
C15061 VDD.t467 VSS 0.08941f
C15062 VDD.t2023 VSS 0.05627f
C15063 VDD.t468 VSS 0.09111f
C15064 VDD.t1225 VSS 0.05797f
C15065 VDD.t470 VSS 0.02313f
C15066 VDD.t1226 VSS 0.02313f
C15067 VDD.t471 VSS 0.02314f
C15068 VDD.t219 VSS 0.02314f
C15069 VDD.t126 VSS 0.02484f
C15070 VDD.t154 VSS 0.05797f
C15071 VDD.t127 VSS 0.02313f
C15072 VDD.t155 VSS 0.05627f
C15073 VDD.t128 VSS 0.02314f
C15074 VDD.t30 VSS 0.02314f
C15075 VDD.t129 VSS 0.02484f
C15076 VDD.t131 VSS 0.02313f
C15077 VDD.t82 VSS 0.05627f
C15078 VDD.t132 VSS 0.02314f
C15079 VDD.t14 VSS 0.02314f
C15080 VDD.t133 VSS 0.02484f
C15081 VDD.t15 VSS 0.05797f
C15082 VDD.t102 VSS 0.02314f
C15083 VDD.t572 VSS 0.02314f
C15084 VDD.t103 VSS 0.22364f
C15085 VDD.t105 VSS 0.22193f
C15086 VDD.t513 VSS 0.05627f
C15087 VDD.t106 VSS 0.02314f
C15088 VDD.t187 VSS 0.02314f
C15089 VDD.t107 VSS 0.02484f
C15090 VDD.t188 VSS 0.05797f
C15091 VDD.t116 VSS 0.02314f
C15092 VDD.t222 VSS 0.02314f
C15093 VDD.t117 VSS 0.02484f
C15094 VDD.t119 VSS 0.02313f
C15095 VDD.t190 VSS 0.02313f
C15096 VDD.t120 VSS 0.02314f
C15097 VDD.t197 VSS 0.02314f
C15098 VDD.t121 VSS 0.22364f
C15099 VDD.t198 VSS 0.05797f
C15100 VDD.t123 VSS 0.22193f
C15101 VDD.t1340 VSS 0.05627f
C15102 VDD.t93 VSS 0.02314f
C15103 VDD.t1393 VSS 0.02314f
C15104 VDD.t94 VSS 0.05797f
C15105 VDD.t96 VSS 0.05627f
C15106 VDD.t29 VSS 0.05627f
C15107 VDD.t97 VSS 0.02314f
C15108 VDD.t580 VSS 0.02314f
C15109 VDD.t98 VSS 0.05797f
C15110 VDD.t185 VSS 0.05797f
C15111 VDD.t477 VSS 0.02314f
C15112 VDD.t199 VSS 0.05627f
C15113 VDD.t478 VSS 0.02484f
C15114 VDD.t55 VSS 0.05797f
C15115 VDD.t480 VSS 0.02313f
C15116 VDD.t56 VSS 0.02313f
C15117 VDD.t481 VSS 0.02313f
C15118 VDD.t26 VSS 0.02314f
C15119 VDD.t482 VSS 0.02223f
C15120 VDD.t27 VSS 0.05797f
C15121 VDD.t529 VSS 0.05627f
C15122 VDD.t841 VSS 0.05627f
C15123 VDD.t2288 VSS 0.0796f
C15124 VDD.t2286 VSS 0.02589f
C15125 VDD.t439 VSS 0.02313f
C15126 VDD.t1108 VSS 0.312f
C15127 VDD.t1010 VSS 0.02577f
C15128 VDD.t775 VSS 0.02577f
C15129 VDD.t849 VSS 0.02773f
C15130 VDD.t991 VSS 0.02773f
C15131 VDD.t1167 VSS 0.26753f
C15132 VDD.t926 VSS 0.02773f
C15133 VDD.t1103 VSS 0.63679f
C15134 VDD.t675 VSS 0.05737f
C15135 VDD.t2139 VSS 0.24928f
C15136 VDD.t812 VSS 0.10776f
C15137 VDD.t797 VSS 0.23483f
C15138 VDD.t789 VSS 0.34129f
C15139 VDD.t1174 VSS 0.02773f
C15140 VDD.t721 VSS 1.73559f
C15141 VDD.t732 VSS 0.06163f
C15142 VDD.t720 VSS 0.21944f
C15143 VDD.t1430 VSS 0.14109f
C15144 VDD.t2110 VSS 0.37313f
C15145 VDD.t1200 VSS 0.16841f
C15146 VDD.n545 VSS 0.07711f
C15147 VDD.t825 VSS 0.2721f
C15148 VDD.t1009 VSS 0.33726f
C15149 VDD.t438 VSS 0.05797f
C15150 VDD.t172 VSS 0.05627f
C15151 VDD.t186 VSS 0.05627f
C15152 VDD.t28 VSS 0.05797f
C15153 VDD.t189 VSS 0.02484f
C15154 VDD.t109 VSS 0.02313f
C15155 VDD.t1987 VSS 0.05627f
C15156 VDD.t1347 VSS 0.02911f
C15157 VDD.t1179 VSS 0.02498f
C15158 VDD.t850 VSS 0.1641f
C15159 VDD.t760 VSS 0.41796f
C15160 VDD.t1360 VSS 0.03722f
C15161 VDD.t662 VSS 0.03459f
C15162 VDD.t1271 VSS 0.17886f
C15163 VDD.t1116 VSS 0.02791f
C15164 VDD.t1753 VSS 0.30588f
C15165 VDD.t1115 VSS 0.02443f
C15166 VDD.t857 VSS 0.29878f
C15167 VDD.t2096 VSS 0.02577f
C15168 VDD.t1423 VSS 0.15679f
C15169 VDD.t730 VSS 0.04737f
C15170 VDD.t1176 VSS 0.20519f
C15171 VDD.t1992 VSS 0.54633f
C15172 VDD.t1180 VSS 0.34139f
C15173 VDD.t792 VSS 0.16831f
C15174 VDD.n546 VSS 0.06757f
C15175 VDD.t2019 VSS 0.256f
C15176 VDD.t1250 VSS 0.14554f
C15177 VDD.t2200 VSS 0.02813f
C15178 VDD.t1134 VSS 0.16297f
C15179 VDD.t1363 VSS 0.02569f
C15180 VDD.t981 VSS 0.02616f
C15181 VDD.t1991 VSS 0.04852f
C15182 VDD.t376 VSS 0.04737f
C15183 VDD.t982 VSS 0.02818f
C15184 VDD.t984 VSS 0.02818f
C15185 VDD.t360 VSS 0.52341f
C15186 VDD.t986 VSS 0.02818f
C15187 VDD.t988 VSS 0.02818f
C15188 VDD.n547 VSS 0.03407f
C15189 VDD.n548 VSS 0.01117f
C15190 VDD.t1744 VSS 0.02818f
C15191 VDD.n549 VSS 0.04383f
C15192 VDD.n550 VSS 0.01789f
C15193 VDD.t807 VSS 0.32789f
C15194 VDD.n551 VSS 0.05752f
C15195 VDD.n552 VSS 0.02189f
C15196 VDD.t781 VSS 0.1433f
C15197 VDD.n553 VSS 0.05876f
C15198 VDD.n554 VSS 0.03198f
C15199 VDD.t1119 VSS 0.23156f
C15200 VDD.n555 VSS 0.05143f
C15201 VDD.t1282 VSS 0.39808f
C15202 VDD.n557 VSS 0.05479f
C15203 VDD.t980 VSS 0.14445f
C15204 VDD.t655 VSS 0.02791f
C15205 VDD.t765 VSS 0.25722f
C15206 VDD.n558 VSS 0.04028f
C15207 VDD.t364 VSS 0.09607f
C15208 VDD.n560 VSS 0.01919f
C15209 VDD.n561 VSS 0.02532f
C15210 VDD.n562 VSS 0.01486f
C15211 VDD.t1011 VSS 0.26949f
C15212 VDD.n563 VSS 0.03892f
C15213 VDD.n564 VSS 0.0148f
C15214 VDD.t377 VSS 0.06551f
C15215 VDD.n565 VSS 0.02533f
C15216 VDD.t1163 VSS 0.1126f
C15217 VDD.n567 VSS 0.04821f
C15218 VDD.n568 VSS 0.02189f
C15219 VDD.t1069 VSS 0.14567f
C15220 VDD.n569 VSS 0.05582f
C15221 VDD.n570 VSS 0.01906f
C15222 VDD.t958 VSS 0.06527f
C15223 VDD.n571 VSS 0.05314f
C15224 VDD.n572 VSS 0.01618f
C15225 VDD.t1166 VSS 0.34377f
C15226 VDD.n573 VSS 0.06189f
C15227 VDD.t1246 VSS 0.16695f
C15228 VDD.t1290 VSS 0.33573f
C15229 VDD.t74 VSS 0.30675f
C15230 VDD.t73 VSS 0.30765f
C15231 VDD.t230 VSS 0.79477f
C15232 VDD.t2134 VSS 0.17095f
C15233 VDD.t229 VSS 0.79567f
C15234 VDD.t1117 VSS 0.01903f
C15235 VDD.t1159 VSS 0.33892f
C15236 VDD.t2095 VSS 0.3836f
C15237 VDD.t1382 VSS 0.0929f
C15238 VDD.t1112 VSS 0.16201f
C15239 VDD.t1249 VSS 0.30206f
C15240 VDD.t1288 VSS 0.02498f
C15241 VDD.t940 VSS 0.10946f
C15242 VDD.t1979 VSS 0.02911f
C15243 VDD.t2238 VSS 0.02498f
C15244 VDD.t1007 VSS 0.36519f
C15245 VDD.t1185 VSS 0.14861f
C15246 VDD.t1012 VSS 0.32429f
C15247 VDD.t2251 VSS 0.23555f
C15248 VDD.t686 VSS 0.33466f
C15249 VDD.t1564 VSS 1.58202f
C15250 VDD.n574 VSS 0.01919f
C15251 VDD.t1433 VSS 0.02577f
C15252 VDD.t1434 VSS 0.06903f
C15253 VDD.t1566 VSS 3.30099f
C15254 VDD.t1164 VSS 0.02498f
C15255 VDD.t2241 VSS 0.02596f
C15256 VDD.t1213 VSS 0.02596f
C15257 VDD.t1239 VSS 0.50995f
C15258 VDD.t2026 VSS 0.25501f
C15259 VDD.t786 VSS 0.02596f
C15260 VDD.t763 VSS 0.13056f
C15261 VDD.t2235 VSS 0.02596f
C15262 VDD.t547 VSS 0.02223f
C15263 VDD.t523 VSS 0.07176f
C15264 VDD.t546 VSS 0.02313f
C15265 VDD.t522 VSS 0.07266f
C15266 VDD.t484 VSS 0.0894f
C15267 VDD.t515 VSS 0.02313f
C15268 VDD.t262 VSS 0.09111f
C15269 VDD.t514 VSS 0.02484f
C15270 VDD.t261 VSS 0.02314f
C15271 VDD.t839 VSS 0.02314f
C15272 VDD.t260 VSS 0.05627f
C15273 VDD.t2028 VSS 0.02313f
C15274 VDD.t259 VSS 0.05797f
C15275 VDD.t944 VSS 0.02484f
C15276 VDD.t1832 VSS 0.02314f
C15277 VDD.t943 VSS 0.02314f
C15278 VDD.t1836 VSS 0.02313f
C15279 VDD.t1995 VSS 0.02313f
C15280 VDD.t1835 VSS 0.09111f
C15281 VDD.t1395 VSS 0.02484f
C15282 VDD.t1989 VSS 0.08941f
C15283 VDD.t1394 VSS 0.02314f
C15284 VDD.t1910 VSS 0.05627f
C15285 VDD.t1894 VSS 0.02313f
C15286 VDD.t568 VSS 0.09111f
C15287 VDD.t4 VSS 0.02484f
C15288 VDD.t567 VSS 0.05627f
C15289 VDD.t3 VSS 0.02314f
C15290 VDD.t571 VSS 0.05627f
C15291 VDD.t582 VSS 0.02313f
C15292 VDD.t12 VSS 0.05797f
C15293 VDD.t581 VSS 0.02484f
C15294 VDD.t11 VSS 0.02314f
C15295 VDD.t585 VSS 0.02314f
C15296 VDD.t25 VSS 0.02313f
C15297 VDD.t588 VSS 0.02313f
C15298 VDD.t24 VSS 0.05797f
C15299 VDD.t519 VSS 0.02484f
C15300 VDD.t33 VSS 0.05627f
C15301 VDD.t518 VSS 0.02314f
C15302 VDD.t634 VSS 0.05627f
C15303 VDD.t1400 VSS 0.02313f
C15304 VDD.t176 VSS 0.09111f
C15305 VDD.t1399 VSS 0.02484f
C15306 VDD.t175 VSS 0.05627f
C15307 VDD.t1403 VSS 0.02314f
C15308 VDD.t196 VSS 0.0894f
C15309 VDD.t826 VSS 0.17831f
C15310 VDD.t2195 VSS 0.23236f
C15311 VDD.n575 VSS 0.06651f
C15312 VDD.n576 VSS 0.02145f
C15313 VDD.t883 VSS 0.02577f
C15314 VDD.n577 VSS 0.05783f
C15315 VDD.n578 VSS 0.01931f
C15316 VDD.t824 VSS 0.41765f
C15317 VDD.n579 VSS 0.05135f
C15318 VDD.t995 VSS 0.10832f
C15319 VDD.t2126 VSS 0.52241f
C15320 VDD.n580 VSS 0.03743f
C15321 VDD.t1008 VSS 0.28826f
C15322 VDD.n582 VSS 0.04824f
C15323 VDD.n583 VSS 0.02187f
C15324 VDD.n584 VSS 0.02941f
C15325 VDD.t2132 VSS 0.02983f
C15326 VDD.t1466 VSS 0.02818f
C15327 VDD.n585 VSS 0.03764f
C15328 VDD.t1262 VSS 0.02818f
C15329 VDD.t1333 VSS 0.03459f
C15330 VDD.t1260 VSS 6.63245f
C15331 VDD.t1136 VSS 2.44525f
C15332 VDD.t1110 VSS 0.10377f
C15333 VDD.t87 VSS 0.08849f
C15334 VDD.t1604 VSS 0.02616f
C15335 VDD.n586 VSS 0.0302f
C15336 VDD.t1296 VSS 0.07019f
C15337 VDD.n587 VSS 0.04272f
C15338 VDD.t1584 VSS 1.23083f
C15339 VDD.t1686 VSS 0.59282f
C15340 VDD.t904 VSS 0.66366f
C15341 VDD.t1545 VSS 0.02813f
C15342 VDD.t977 VSS 0.06942f
C15343 VDD.t1714 VSS 0.06448f
C15344 VDD.t749 VSS 0.02813f
C15345 VDD.t1713 VSS 0.0252f
C15346 VDD.t972 VSS 0.02569f
C15347 VDD.t1582 VSS 1.19586f
C15348 VDD.t971 VSS 0.63437f
C15349 VDD.n588 VSS 0.03815f
C15350 VDD.t1073 VSS 0.02791f
C15351 VDD.n590 VSS 0.02843f
C15352 VDD.n591 VSS 0.01031f
C15353 VDD.t1549 VSS 0.4599f
C15354 VDD.n592 VSS 0.02843f
C15355 VDD.n593 VSS 0.01075f
C15356 VDD.t938 VSS 0.10723f
C15357 VDD.n594 VSS 0.03658f
C15358 VDD.t1143 VSS 0.02596f
C15359 VDD.t1711 VSS 0.01903f
C15360 VDD.t1020 VSS 0.1758f
C15361 VDD.t819 VSS 0.01903f
C15362 VDD.t818 VSS 0.02577f
C15363 VDD.t2368 VSS 0.02616f
C15364 VDD.t2361 VSS 0.02818f
C15365 VDD.t2365 VSS 0.02818f
C15366 VDD.t794 VSS 0.29776f
C15367 VDD.t696 VSS 0.02007f
C15368 VDD.t1138 VSS 0.02818f
C15369 VDD.t2363 VSS 0.02818f
C15370 VDD.t757 VSS 0.07646f
C15371 VDD.t694 VSS 0.02498f
C15372 VDD.t1762 VSS 0.02596f
C15373 VDD.t1449 VSS 0.02529f
C15374 VDD.t758 VSS 0.02596f
C15375 VDD.t1805 VSS 0.02596f
C15376 VDD.t882 VSS 0.23553f
C15377 VDD.t1144 VSS 0.02596f
C15378 VDD.t2271 VSS 0.02596f
C15379 VDD.t1344 VSS 0.07778f
C15380 VDD.t1594 VSS 0.10635f
C15381 VDD.t693 VSS 0.07034f
C15382 VDD.t1446 VSS 0.02813f
C15383 VDD.t1724 VSS 0.06572f
C15384 VDD.t1284 VSS 0.31099f
C15385 VDD.t747 VSS 0.15266f
C15386 VDD.t705 VSS 0.06698f
C15387 VDD.t1715 VSS 0.0252f
C15388 VDD.t1368 VSS 0.02773f
C15389 VDD.t1638 VSS 0.16738f
C15390 VDD.t1323 VSS 0.151f
C15391 VDD.t1438 VSS 0.09901f
C15392 VDD.t1427 VSS 0.10277f
C15393 VDD.t1687 VSS 0.27431f
C15394 VDD.t708 VSS 0.09534f
C15395 VDD.t844 VSS 0.59626f
C15396 VDD.t1028 VSS 0.20971f
C15397 VDD.t702 VSS 0.16714f
C15398 VDD.n595 VSS 0.05728f
C15399 VDD.n596 VSS 0.01698f
C15400 VDD.t2353 VSS 0.02818f
C15401 VDD.n597 VSS 0.04383f
C15402 VDD.n598 VSS 0.01117f
C15403 VDD.t1597 VSS 0.31377f
C15404 VDD.n599 VSS 0.03407f
C15405 VDD.n600 VSS 0.01133f
C15406 VDD.t1598 VSS 0.02818f
C15407 VDD.n601 VSS 0.03394f
C15408 VDD.t1600 VSS 0.02818f
C15409 VDD.n602 VSS 0.03501f
C15410 VDD.n603 VSS 0.01139f
C15411 VDD.t1602 VSS 0.02818f
C15412 VDD.n604 VSS 0.03946f
C15413 VDD.t1275 VSS 0.02887f
C15414 VDD.t429 VSS 0.02314f
C15415 VDD.t1350 VSS 0.02007f
C15416 VDD.n605 VSS 0.02183f
C15417 VDD.n606 VSS 0.01371f
C15418 VDD.t525 VSS 0.05627f
C15419 VDD.t144 VSS 0.1222f
C15420 VDD.t1385 VSS 0.08941f
C15421 VDD.t488 VSS 0.02313f
C15422 VDD.t2316 VSS 0.02313f
C15423 VDD.t290 VSS 0.02314f
C15424 VDD.t284 VSS 0.02314f
C15425 VDD.t399 VSS 0.02314f
C15426 VDD.t264 VSS 0.08941f
C15427 VDD.t340 VSS 0.02313f
C15428 VDD.t494 VSS 0.02313f
C15429 VDD.t631 VSS 0.02314f
C15430 VDD.t489 VSS 0.08941f
C15431 VDD.t339 VSS 0.02484f
C15432 VDD.t490 VSS 0.09111f
C15433 VDD.t400 VSS 0.02484f
C15434 VDD.t265 VSS 0.09111f
C15435 VDD.t624 VSS 0.02313f
C15436 VDD.t404 VSS 0.02313f
C15437 VDD.t283 VSS 0.02314f
C15438 VDD.t411 VSS 0.02314f
C15439 VDD.t280 VSS 0.02484f
C15440 VDD.t407 VSS 0.09111f
C15441 VDD.t302 VSS 0.02484f
C15442 VDD.t873 VSS 0.16541f
C15443 VDD.t1169 VSS 0.02838f
C15444 VDD.n607 VSS 0.04304f
C15445 VDD.t1821 VSS 0.03018f
C15446 VDD.n609 VSS 0.04184f
C15447 VDD.n610 VSS 0.01388f
C15448 VDD.t711 VSS 0.02596f
C15449 VDD.t2053 VSS 0.02581f
C15450 VDD.t1777 VSS 0.02569f
C15451 VDD.t691 VSS 0.02813f
C15452 VDD.t930 VSS 0.06507f
C15453 VDD.t707 VSS 0.04737f
C15454 VDD.t301 VSS 0.02313f
C15455 VDD.t801 VSS 0.22837f
C15456 VDD.t304 VSS 0.02314f
C15457 VDD.t226 VSS 0.02484f
C15458 VDD.t225 VSS 0.02313f
C15459 VDD.t2048 VSS 0.02726f
C15460 VDD.t1426 VSS 0.49817f
C15461 VDD.t1336 VSS 0.02053f
C15462 VDD.t1140 VSS 0.25611f
C15463 VDD.t2054 VSS 0.02726f
C15464 VDD.n611 VSS 0.04942f
C15465 VDD.t1688 VSS 0.02564f
C15466 VDD.t1230 VSS 0.19147f
C15467 VDD.t1815 VSS 0.17686f
C15468 VDD.n612 VSS 0.03383f
C15469 VDD.t1327 VSS 0.07113f
C15470 VDD.t1664 VSS 0.02518f
C15471 VDD.t1355 VSS 0.02564f
C15472 VDD.t877 VSS 0.16944f
C15473 VDD.t1017 VSS 0.02518f
C15474 VDD.t1236 VSS 0.02564f
C15475 VDD.t1543 VSS 0.29046f
C15476 VDD.t862 VSS 0.02564f
C15477 VDD.t809 VSS 0.02791f
C15478 VDD.t870 VSS 0.02726f
C15479 VDD.t808 VSS 0.02525f
C15480 VDD.t1544 VSS 0.05205f
C15481 VDD.t810 VSS 0.03816f
C15482 VDD.n613 VSS 0.04795f
C15483 VDD.t681 VSS 0.61944f
C15484 VDD.t17 VSS 0.02313f
C15485 VDD.t385 VSS 0.09927f
C15486 VDD.t1773 VSS 0.02817f
C15487 VDD.t18 VSS 0.02223f
C15488 VDD.t1341 VSS 0.02577f
C15489 VDD.t390 VSS 0.02964f
C15490 VDD.t1480 VSS 0.02773f
C15491 VDD.t1349 VSS 0.40332f
C15492 VDD.t1903 VSS 0.06789f
C15493 VDD.t387 VSS 0.02577f
C15494 VDD.t1348 VSS 1.03675f
C15495 VDD.n614 VSS 0.04302f
C15496 VDD.n615 VSS 0.01046f
C15497 VDD.t650 VSS 0.02726f
C15498 VDD.n616 VSS 0.03919f
C15499 VDD.t726 VSS 0.61121f
C15500 VDD.t1358 VSS 0.02726f
C15501 VDD.t651 VSS 0.02564f
C15502 VDD.t1060 VSS 0.21339f
C15503 VDD.t1839 VSS 0.02773f
C15504 VDD.t1235 VSS 0.02564f
C15505 VDD.n617 VSS 0.04566f
C15506 VDD.t1520 VSS 0.02887f
C15507 VDD.t1045 VSS 0.44515f
C15508 VDD.t1228 VSS 0.08944f
C15509 VDD.n618 VSS 0.02852f
C15510 VDD.n619 VSS 0.02234f
C15511 VDD.t1532 VSS 0.37347f
C15512 VDD.n620 VSS 0.0409f
C15513 VDD.n621 VSS 0.01762f
C15514 VDD.n622 VSS 0.02023f
C15515 VDD.n623 VSS 0.0259f
C15516 VDD.t1774 VSS 0.21118f
C15517 VDD.t1757 VSS 0.04737f
C15518 VDD.t1479 VSS 0.02577f
C15519 VDD.n624 VSS 0.02069f
C15520 VDD.t798 VSS 0.34353f
C15521 VDD.n625 VSS 0.06191f
C15522 VDD.t1147 VSS 0.20821f
C15523 VDD.n626 VSS 0.06256f
C15524 VDD.n627 VSS 0.0139f
C15525 VDD.t1507 VSS 0.11988f
C15526 VDD.n629 VSS 0.02533f
C15527 VDD.n630 VSS 0.01253f
C15528 VDD.t1312 VSS 0.46384f
C15529 VDD.n631 VSS 0.03711f
C15530 VDD.n632 VSS 0.01736f
C15531 VDD.t1649 VSS 0.02564f
C15532 VDD.t1609 VSS 0.02983f
C15533 VDD.n633 VSS 0.05477f
C15534 VDD.n634 VSS 0.01618f
C15535 VDD.t1657 VSS 0.11156f
C15536 VDD.n635 VSS 0.05556f
C15537 VDD.n636 VSS 0.01773f
C15538 VDD.n637 VSS 0.0139f
C15539 VDD.t1628 VSS 0.35281f
C15540 VDD.t1484 VSS 0.16757f
C15541 VDD.t1490 VSS 0.19877f
C15542 VDD.n638 VSS 0.05425f
C15543 VDD.t1489 VSS 0.1094f
C15544 VDD.t1498 VSS 0.04737f
C15545 VDD.n639 VSS 0.01919f
C15546 VDD.n640 VSS 0.03931f
C15547 VDD.t1501 VSS 0.02053f
C15548 VDD.n641 VSS 0.05323f
C15549 VDD.n642 VSS 0.02893f
C15550 VDD.t1505 VSS 0.54588f
C15551 VDD.n643 VSS 0.05326f
C15552 VDD.n644 VSS 0.02893f
C15553 VDD.t1614 VSS 0.15693f
C15554 VDD.t1506 VSS 0.08901f
C15555 VDD.n645 VSS 0.01919f
C15556 VDD.n646 VSS 0.03451f
C15557 VDD.t2223 VSS 0.02577f
C15558 VDD.n648 VSS 0.04835f
C15559 VDD.t1758 VSS 0.11265f
C15560 VDD.n649 VSS 0.0649f
C15561 VDD.n650 VSS 0.02145f
C15562 VDD.t1778 VSS 0.24464f
C15563 VDD.t2172 VSS 0.19726f
C15564 VDD.t1502 VSS 0.04737f
C15565 VDD.t2032 VSS 0.02616f
C15566 VDD.t2033 VSS 0.41391f
C15567 VDD.t1503 VSS 0.08666f
C15568 VDD.t2035 VSS 0.02818f
C15569 VDD.t2037 VSS 0.17148f
C15570 VDD.t1740 VSS 0.02818f
C15571 VDD.t1741 VSS 0.02818f
C15572 VDD.n651 VSS 0.05203f
C15573 VDD.t1923 VSS 0.02577f
C15574 VDD.n652 VSS 0.05317f
C15575 VDD.n653 VSS 0.01626f
C15576 VDD.t670 VSS 0.41287f
C15577 VDD.t1527 VSS 0.22496f
C15578 VDD.t669 VSS 0.31044f
C15579 VDD.t2184 VSS 0.29551f
C15580 VDD.t713 VSS 0.02983f
C15581 VDD.t1522 VSS 0.19306f
C15582 VDD.n654 VSS 0.03579f
C15583 VDD.t1620 VSS 0.15256f
C15584 VDD.t1508 VSS 0.24606f
C15585 VDD.n655 VSS 0.01919f
C15586 VDD.n656 VSS 0.02531f
C15587 VDD.t1639 VSS 0.31656f
C15588 VDD.n658 VSS 0.04634f
C15589 VDD.t1653 VSS 0.15976f
C15590 VDD.n659 VSS 0.05294f
C15591 VDD.n660 VSS 0.02187f
C15592 VDD.t1523 VSS 0.17547f
C15593 VDD.t894 VSS 0.04737f
C15594 VDD.n661 VSS 0.01919f
C15595 VDD.n662 VSS 0.04959f
C15596 VDD.t893 VSS 1.26349f
C15597 VDD.t1146 VSS 0.25995f
C15598 VDD.t1786 VSS 0.02616f
C15599 VDD.t1787 VSS 0.02818f
C15600 VDD.t2261 VSS 0.12671f
C15601 VDD.t1789 VSS 0.02818f
C15602 VDD.t1791 VSS 0.02818f
C15603 VDD.t2275 VSS 0.39579f
C15604 VDD.t1793 VSS 0.02818f
C15605 VDD.t2351 VSS 0.31479f
C15606 VDD.t2263 VSS 0.19386f
C15607 VDD.t1776 VSS 0.15139f
C15608 VDD.t896 VSS 0.52444f
C15609 VDD.t2262 VSS 0.12828f
C15610 VDD.n663 VSS 0.04856f
C15611 VDD.t799 VSS 0.1925f
C15612 VDD.t897 VSS 0.99166f
C15613 VDD.t1612 VSS 0.11266f
C15614 VDD.n664 VSS 0.06673f
C15615 VDD.t842 VSS 0.82251f
C15616 VDD.t1311 VSS 0.232f
C15617 VDD.t859 VSS 0.12669f
C15618 VDD.t1796 VSS 0.23394f
C15619 VDD.t657 VSS 0.17809f
C15620 VDD.t1756 VSS 1.18135f
C15621 VDD.t881 VSS 0.02983f
C15622 VDD.t671 VSS 0.30923f
C15623 VDD.n665 VSS 0.06191f
C15624 VDD.t1769 VSS 0.4286f
C15625 VDD.n666 VSS 0.05192f
C15626 VDD.n667 VSS 0.01799f
C15627 VDD.t672 VSS 0.19503f
C15628 VDD.n668 VSS 0.07242f
C15629 VDD.t1475 VSS 0.49836f
C15630 VDD.n669 VSS 0.06776f
C15631 VDD.t1771 VSS 0.1021f
C15632 VDD.n670 VSS 0.05583f
C15633 VDD.n671 VSS 0.02187f
C15634 VDD.t1531 VSS 0.13808f
C15635 VDD.n672 VSS 0.05756f
C15636 VDD.n673 VSS 0.02309f
C15637 VDD.t1616 VSS 0.19236f
C15638 VDD.n674 VSS 0.04344f
C15639 VDD.t1255 VSS 1.20139f
C15640 VDD.n675 VSS 0.03f
C15641 VDD.t511 VSS 0.03271f
C15642 VDD.t498 VSS 0.02223f
C15643 VDD.t497 VSS 0.02313f
C15644 VDD.t277 VSS 0.10054f
C15645 VDD.t2020 VSS 0.05627f
C15646 VDD.t276 VSS 0.08941f
C15647 VDD.t321 VSS 0.09111f
C15648 VDD.t275 VSS 0.02313f
C15649 VDD.t320 VSS 0.05627f
C15650 VDD.t235 VSS 0.18497f
C15651 VDD.t472 VSS 0.02313f
C15652 VDD.t234 VSS 0.18327f
C15653 VDD.t423 VSS 0.05797f
C15654 VDD.t233 VSS 0.02313f
C15655 VDD.t422 VSS 0.05627f
C15656 VDD.t232 VSS 0.02484f
C15657 VDD.t426 VSS 0.0894f
C15658 VDD.t501 VSS 0.02314f
C15659 VDD.t309 VSS 0.09111f
C15660 VDD.t1122 VSS 0.42103f
C15661 VDD.t308 VSS 0.02345f
C15662 VDD.n677 VSS 0.04062f
C15663 VDD.t929 VSS 0.50667f
C15664 VDD.n678 VSS 0.05117f
C15665 VDD.t509 VSS 0.61056f
C15666 VDD.n680 VSS 0.04479f
C15667 VDD.n681 VSS 0.02173f
C15668 VDD.t2180 VSS 0.12858f
C15669 VDD.n682 VSS 0.04752f
C15670 VDD.n683 VSS 0.019f
C15671 VDD.t2071 VSS 0.11432f
C15672 VDD.n684 VSS 0.04284f
C15673 VDD.n685 VSS 0.01305f
C15674 VDD.n686 VSS 0.01069f
C15675 VDD.t665 VSS 0.52583f
C15676 VDD.n687 VSS 0.04182f
C15677 VDD.n688 VSS 0.01977f
C15678 VDD.t1293 VSS 0.11822f
C15679 VDD.n689 VSS 0.04284f
C15680 VDD.n690 VSS 0.01078f
C15681 VDD.n691 VSS 0.02893f
C15682 VDD.n692 VSS 0.02264f
C15683 VDD.t1412 VSS 0.1106f
C15684 VDD.n693 VSS 0.05756f
C15685 VDD.n694 VSS 0.02187f
C15686 VDD.n695 VSS 0.02068f
C15687 VDD.t1538 VSS 0.02983f
C15688 VDD.n696 VSS 0.05756f
C15689 VDD.n697 VSS 0.02187f
C15690 VDD.t1919 VSS 0.02686f
C15691 VDD.n698 VSS 0.07158f
C15692 VDD.t1436 VSS 0.42675f
C15693 VDD.n699 VSS 0.05506f
C15694 VDD.n700 VSS 0.02187f
C15695 VDD.t1534 VSS 0.16048f
C15696 VDD.n701 VSS 0.05756f
C15697 VDD.t1488 VSS 0.5458f
C15698 VDD.n702 VSS 0.05583f
C15699 VDD.n703 VSS 0.02068f
C15700 VDD.t1775 VSS 0.40465f
C15701 VDD.n704 VSS 0.05583f
C15702 VDD.n705 VSS 0.02187f
C15703 VDD.t1800 VSS 0.11109f
C15704 VDD.n706 VSS 0.05756f
C15705 VDD.t1779 VSS 0.37509f
C15706 VDD.n707 VSS 0.05583f
C15707 VDD.n708 VSS 0.02068f
C15708 VDD.t892 VSS 0.02053f
C15709 VDD.n709 VSS 0.11582f
C15710 VDD.t1413 VSS 0.57807f
C15711 VDD.n710 VSS 0.13371f
C15712 VDD.t891 VSS 0.04737f
C15713 VDD.n711 VSS 0.01919f
C15714 VDD.n712 VSS 0.03932f
C15715 VDD.t1431 VSS 0.33842f
C15716 VDD.n713 VSS 0.12915f
C15717 VDD.n714 VSS 0.01347f
C15718 VDD.t889 VSS 1.54295f
C15719 VDD.t664 VSS 0.46337f
C15720 VDD.n715 VSS 0.01919f
C15721 VDD.n716 VSS 0.03932f
C15722 VDD.n717 VSS 0.02893f
C15723 VDD.n718 VSS 0.01243f
C15724 VDD.t1207 VSS 0.11105f
C15725 VDD.n719 VSS 0.04826f
C15726 VDD.t2068 VSS 0.02577f
C15727 VDD.n720 VSS 0.05317f
C15728 VDD.n721 VSS 0.02144f
C15729 VDD.t2176 VSS 0.25192f
C15730 VDD.n722 VSS 0.13371f
C15731 VDD.t1536 VSS 0.07743f
C15732 VDD.n723 VSS 0.12507f
C15733 VDD.t1535 VSS 0.04737f
C15734 VDD.t2051 VSS 0.02726f
C15735 VDD.t2220 VSS 0.53877f
C15736 VDD.t2216 VSS 0.15824f
C15737 VDD.t2173 VSS 0.76939f
C15738 VDD.t2169 VSS 0.02983f
C15739 VDD.t2171 VSS 0.25426f
C15740 VDD.t2213 VSS 0.11141f
C15741 VDD.t2214 VSS 0.54066f
C15742 VDD.t851 VSS 0.112f
C15743 VDD.t852 VSS 0.59288f
C15744 VDD.t927 VSS 0.62906f
C15745 VDD.t508 VSS 0.60966f
C15746 VDD.n724 VSS 0.06271f
C15747 VDD.n725 VSS 0.06243f
C15748 VDD.n726 VSS 0.04749f
C15749 VDD.n727 VSS 0.04749f
C15750 VDD.n728 VSS 0.05581f
C15751 VDD.n729 VSS 0.05803f
C15752 VDD.t273 VSS 0.02313f
C15753 VDD.t272 VSS 0.05627f
C15754 VDD.t1366 VSS 0.76125f
C15755 VDD.t1243 VSS 0.42603f
C15756 VDD.t872 VSS 0.12084f
C15757 VDD.n730 VSS 0.08489f
C15758 VDD.n731 VSS 0.0601f
C15759 VDD.n732 VSS 0.01977f
C15760 VDD.n733 VSS 0.05102f
C15761 VDD.t271 VSS 0.05797f
C15762 VDD.n734 VSS 0.76318f
C15763 VDD.n735 VSS 0.76318f
C15764 VDD.t1064 VSS 0.02518f
C15765 VDD.t1483 VSS 0.24482f
C15766 VDD.t1102 VSS 0.19508f
C15767 VDD.n736 VSS 0.02354f
C15768 VDD.n737 VSS 0.01862f
C15769 VDD.n738 VSS 0.02023f
C15770 VDD.n739 VSS 0.01337f
C15771 VDD.t1783 VSS 0.17188f
C15772 VDD.n740 VSS 0.02189f
C15773 VDD.t1577 VSS 0.19829f
C15774 VDD.t1087 VSS 0.10926f
C15775 VDD.t1648 VSS 0.02564f
C15776 VDD.t1872 VSS 0.07129f
C15777 VDD.t1729 VSS 0.35805f
C15778 VDD.t1326 VSS 0.10924f
C15779 VDD.t1352 VSS 0.02726f
C15780 VDD.t388 VSS 0.02569f
C15781 VDD.t791 VSS 0.02518f
C15782 VDD.t2070 VSS 0.32143f
C15783 VDD.t357 VSS 0.10946f
C15784 VDD.t956 VSS 0.14569f
C15785 VDD.t1211 VSS 0.20577f
C15786 VDD.t1510 VSS 0.13898f
C15787 VDD.n741 VSS 0.01919f
C15788 VDD.n742 VSS 0.02903f
C15789 VDD.n743 VSS 0.01043f
C15790 VDD.t1517 VSS 0.02564f
C15791 VDD.t322 VSS 0.02314f
C15792 VDD.t333 VSS 0.02314f
C15793 VDD.t474 VSS 0.05627f
C15794 VDD.t352 VSS 0.05627f
C15795 VDD.t311 VSS 0.02314f
C15796 VDD.t313 VSS 0.05627f
C15797 VDD.t312 VSS 0.02484f
C15798 VDD.t314 VSS 0.05797f
C15799 VDD.t428 VSS 0.02313f
C15800 VDD.t318 VSS 0.02313f
C15801 VDD.t424 VSS 0.02314f
C15802 VDD.t324 VSS 0.02314f
C15803 VDD.t425 VSS 0.05797f
C15804 VDD.t325 VSS 0.05797f
C15805 VDD.t323 VSS 0.02484f
C15806 VDD.t334 VSS 0.02484f
C15807 VDD.t2022 VSS 0.02313f
C15808 VDD.t350 VSS 0.02313f
C15809 VDD.t499 VSS 0.02314f
C15810 VDD.t874 VSS 0.10461f
C15811 VDD.t500 VSS 0.11445f
C15812 VDD.t574 VSS 0.11274f
C15813 VDD.t2170 VSS 0.37925f
C15814 VDD.t928 VSS 0.02518f
C15815 VDD.t1233 VSS 0.02564f
C15816 VDD.t861 VSS 0.56582f
C15817 VDD.t1509 VSS 0.5718f
C15818 VDD.t646 VSS 0.10936f
C15819 VDD.n744 VSS 0.04639f
C15820 VDD.t645 VSS 0.10862f
C15821 VDD.t1704 VSS 0.25623f
C15822 VDD.t1607 VSS 0.33467f
C15823 VDD.t1663 VSS 0.05688f
C15824 VDD.t1626 VSS 0.02007f
C15825 VDD.t855 VSS 0.07417f
C15826 VDD.t1367 VSS 0.02518f
C15827 VDD.t394 VSS 0.30115f
C15828 VDD.t1231 VSS 0.02564f
C15829 VDD.t1210 VSS 0.02518f
C15830 VDD.t2167 VSS 0.21506f
C15831 VDD.t1232 VSS 0.02564f
C15832 VDD.t1720 VSS 0.02564f
C15833 VDD.t1675 VSS 0.02726f
C15834 VDD.t389 VSS 0.02964f
C15835 VDD.t2050 VSS 0.02726f
C15836 VDD.t384 VSS 0.13104f
C15837 VDD.t1689 VSS 0.02564f
C15838 VDD.t396 VSS 0.37418f
C15839 VDD.t1647 VSS 0.02518f
C15840 VDD.t1021 VSS 0.10909f
C15841 VDD.t1690 VSS 0.02564f
C15842 VDD.t2049 VSS 0.97768f
C15843 VDD.t383 VSS 0.06892f
C15844 VDD.t1516 VSS 0.17827f
C15845 VDD.t2057 VSS 0.24798f
C15846 VDD.t1357 VSS 0.02726f
C15847 VDD.t860 VSS 0.3858f
C15848 VDD.t1292 VSS 0.02518f
C15849 VDD.t1356 VSS 0.99462f
C15850 VDD.t1092 VSS 0.31653f
C15851 VDD.t1651 VSS 0.02564f
C15852 VDD.t1308 VSS 0.77997f
C15853 VDD.n745 VSS 0.01919f
C15854 VDD.n746 VSS 0.02804f
C15855 VDD.t1542 VSS 0.02007f
C15856 VDD.t1309 VSS 0.65716f
C15857 VDD.t1650 VSS 0.02564f
C15858 VDD.t2264 VSS 0.06552f
C15859 VDD.n747 VSS 0.04432f
C15860 VDD.n748 VSS 0.01119f
C15861 VDD.t1099 VSS 0.74479f
C15862 VDD.n749 VSS 0.04835f
C15863 VDD.t902 VSS 0.28849f
C15864 VDD.n750 VSS 0.05752f
C15865 VDD.n751 VSS 0.02145f
C15866 VDD.t1540 VSS 0.21256f
C15867 VDD.n752 VSS 0.06769f
C15868 VDD.t1591 VSS 0.0252f
C15869 VDD.t1595 VSS 0.12614f
C15870 VDD.t885 VSS 0.38245f
C15871 VDD.t964 VSS 0.02569f
C15872 VDD.n753 VSS 0.04404f
C15873 VDD.t1590 VSS 0.0252f
C15874 VDD.t712 VSS 0.02791f
C15875 VDD.t1708 VSS 0.02813f
C15876 VDD.t963 VSS 0.02569f
C15877 VDD.t1670 VSS 0.02791f
C15878 VDD.t1592 VSS 0.0252f
C15879 VDD.t1637 VSS 0.68197f
C15880 VDD.t1610 VSS 0.02791f
C15881 VDD.t965 VSS 0.02569f
C15882 VDD.t1589 VSS 0.0252f
C15883 VDD.t710 VSS 0.02983f
C15884 VDD.t1546 VSS 0.02813f
C15885 VDD.t962 VSS 0.02569f
C15886 VDD.t1864 VSS 0.06922f
C15887 VDD.t1062 VSS 0.08838f
C15888 VDD.t1019 VSS 0.14514f
C15889 VDD.n754 VSS 0.05303f
C15890 VDD.t1254 VSS 0.54404f
C15891 VDD.t1746 VSS 0.02818f
C15892 VDD.t912 VSS 0.45697f
C15893 VDD.n755 VSS 0.03917f
C15894 VDD.n756 VSS 0.01133f
C15895 VDD.t913 VSS 0.02818f
C15896 VDD.n757 VSS 0.03394f
C15897 VDD.n758 VSS 0.01139f
C15898 VDD.t915 VSS 0.02818f
C15899 VDD.n759 VSS 0.03392f
C15900 VDD.n760 VSS 0.01136f
C15901 VDD.t917 VSS 0.41543f
C15902 VDD.n761 VSS 0.03401f
C15903 VDD.t919 VSS 0.02616f
C15904 VDD.n762 VSS 0.04428f
C15905 VDD.n763 VSS 0.01124f
C15906 VDD.t1454 VSS 0.11977f
C15907 VDD.n764 VSS 0.06318f
C15908 VDD.t1377 VSS 0.40262f
C15909 VDD.n765 VSS 0.06776f
C15910 VDD.t1897 VSS 0.02007f
C15911 VDD.n766 VSS 0.05583f
C15912 VDD.t901 VSS 0.23386f
C15913 VDD.n767 VSS 0.07108f
C15914 VDD.n768 VSS 0.02187f
C15915 VDD.t1030 VSS 0.10883f
C15916 VDD.t1325 VSS 1.25377f
C15917 VDD.t922 VSS 0.77318f
C15918 VDD.n769 VSS 0.04451f
C15919 VDD.n770 VSS 0.50432f
C15920 VDD.n771 VSS 0.50432f
C15921 VDD.t729 VSS 0.10709f
C15922 VDD.t1863 VSS 0.25312f
C15923 VDD.t887 VSS 0.82597f
C15924 VDD.t1754 VSS 0.68379f
C15925 VDD.t888 VSS 0.609f
C15926 VDD.t1071 VSS 0.17207f
C15927 VDD.t1031 VSS 0.06956f
C15928 VDD.t1195 VSS 0.04737f
C15929 VDD.n772 VSS 0.02354f
C15930 VDD.n773 VSS 0.01835f
C15931 VDD.t1072 VSS 0.08589f
C15932 VDD.t1632 VSS 1.08087f
C15933 VDD.t725 VSS 0.29131f
C15934 VDD.t950 VSS 0.28687f
C15935 VDD.n774 VSS 0.06394f
C15936 VDD.n775 VSS 0.01618f
C15937 VDD.t2062 VSS 0.02577f
C15938 VDD.n776 VSS 0.05314f
C15939 VDD.n777 VSS 0.01906f
C15940 VDD.t647 VSS 0.47763f
C15941 VDD.t1013 VSS 0.21181f
C15942 VDD.t823 VSS 0.16272f
C15943 VDD.t1070 VSS 0.30627f
C15944 VDD.t1362 VSS 0.58922f
C15945 VDD.t969 VSS 0.15095f
C15946 VDD.t715 VSS 0.15164f
C15947 VDD.t1127 VSS 0.52113f
C15948 VDD.t955 VSS 0.02887f
C15949 VDD.t682 VSS 0.18168f
C15950 VDD.n778 VSS 0.07575f
C15951 VDD.n779 VSS 0.01561f
C15952 VDD.t1593 VSS 0.0252f
C15953 VDD.n780 VSS 0.03763f
C15954 VDD.n781 VSS 0.01139f
C15955 VDD.t966 VSS 0.02569f
C15956 VDD.n782 VSS 0.03815f
C15957 VDD.t2047 VSS 0.02813f
C15958 VDD.n783 VSS 0.03278f
C15959 VDD.n784 VSS 0.01137f
C15960 VDD.t960 VSS 0.02569f
C15961 VDD.t748 VSS 0.76928f
C15962 VDD.t1587 VSS 0.0252f
C15963 VDD.t864 VSS 0.62048f
C15964 VDD.t683 VSS 0.02791f
C15965 VDD.t1672 VSS 0.13361f
C15966 VDD.t684 VSS 0.18384f
C15967 VDD.t679 VSS 0.21329f
C15968 VDD.t1191 VSS 0.02773f
C15969 VDD.t1781 VSS 0.03451f
C15970 VDD.t961 VSS 0.02569f
C15971 VDD.t1077 VSS 0.02773f
C15972 VDD.t1301 VSS 0.10688f
C15973 VDD.t854 VSS 0.02887f
C15974 VDD.t727 VSS 0.48819f
C15975 VDD.t1353 VSS 0.02726f
C15976 VDD.n785 VSS 0.0715f
C15977 VDD.t1450 VSS 0.70838f
C15978 VDD.n786 VSS 0.12132f
C15979 VDD.n787 VSS 0.03572f
C15980 VDD.t335 VSS 0.07176f
C15981 VDD.t345 VSS 0.02329f
C15982 VDD.t326 VSS 0.02314f
C15983 VDD.t316 VSS 0.02411f
C15984 VDD.t315 VSS 0.02484f
C15985 VDD.t1059 VSS 0.34289f
C15986 VDD.t746 VSS 0.37727f
C15987 VDD.t319 VSS 0.02313f
C15988 VDD.t908 VSS 0.02314f
C15989 VDD.t327 VSS 0.02484f
C15990 VDD.t353 VSS 0.02313f
C15991 VDD.t343 VSS 0.05797f
C15992 VDD.t336 VSS 0.07266f
C15993 VDD.t342 VSS 0.05627f
C15994 VDD.n788 VSS 0.50432f
C15995 VDD.t278 VSS 0.02313f
C15996 VDD.t676 VSS 0.23506f
C15997 VDD.n789 VSS 0.05725f
C15998 VDD.n790 VSS 0.02189f
C15999 VDD.t1078 VSS 0.07056f
C16000 VDD.t143 VSS 0.02313f
C16001 VDD.t288 VSS 0.02314f
C16002 VDD.t305 VSS 0.19051f
C16003 VDD.t629 VSS 0.05797f
C16004 VDD.t397 VSS 0.08941f
C16005 VDD.t337 VSS 0.0894f
C16006 VDD.t630 VSS 0.02345f
C16007 VDD.t803 VSS 0.48845f
C16008 VDD.n791 VSS 0.02767f
C16009 VDD.n792 VSS 0.04062f
C16010 VDD.t628 VSS 0.05627f
C16011 VDD.t338 VSS 0.09111f
C16012 VDD.t398 VSS 0.09111f
C16013 VDD.t910 VSS 0.02313f
C16014 VDD.t911 VSS 0.02314f
C16015 VDD.t622 VSS 0.02313f
C16016 VDD.t282 VSS 0.08941f
C16017 VDD.t346 VSS 0.02484f
C16018 VDD.t347 VSS 0.02313f
C16019 VDD.t348 VSS 0.08941f
C16020 VDD.t279 VSS 0.09111f
C16021 VDD.t289 VSS 0.09111f
C16022 VDD.t306 VSS 0.12253f
C16023 VDD.t341 VSS 0.08941f
C16024 VDD.t296 VSS 0.0894f
C16025 VDD.t292 VSS 0.02314f
C16026 VDD.t227 VSS 0.09111f
C16027 VDD.t228 VSS 0.02326f
C16028 VDD.t293 VSS 0.02484f
C16029 VDD.t1496 VSS 0.26978f
C16030 VDD.t486 VSS 0.02313f
C16031 VDD.t1513 VSS 0.06285f
C16032 VDD.t142 VSS 0.02223f
C16033 VDD.t1061 VSS 0.17127f
C16034 VDD.n793 VSS 0.05084f
C16035 VDD.n794 VSS 0.01712f
C16036 VDD.t736 VSS 0.02564f
C16037 VDD.n795 VSS 0.04779f
C16038 VDD.t953 VSS 0.19381f
C16039 VDD.n796 VSS 0.05289f
C16040 VDD.n797 VSS 0.01205f
C16041 VDD.t1764 VSS 0.30247f
C16042 VDD.n798 VSS 0.0697f
C16043 VDD.t1198 VSS 0.12707f
C16044 VDD.t900 VSS 0.2553f
C16045 VDD.t717 VSS 0.02007f
C16046 VDD.t698 VSS 0.02519f
C16047 VDD.t925 VSS 0.15142f
C16048 VDD.t690 VSS 0.02596f
C16049 VDD.t1676 VSS 0.02596f
C16050 VDD.t677 VSS 0.11926f
C16051 VDD.t643 VSS 0.21754f
C16052 VDD.t1234 VSS 0.02596f
C16053 VDD.t503 VSS 0.44332f
C16054 VDD.t1057 VSS 0.02579f
C16055 VDD.t1026 VSS 0.0927f
C16056 VDD.t868 VSS 0.54339f
C16057 VDD.t2082 VSS 0.16599f
C16058 VDD.t1190 VSS 0.21313f
C16059 VDD.t680 VSS 0.02773f
C16060 VDD.t687 VSS 0.18536f
C16061 VDD.n799 VSS 0.0137f
C16062 VDD.t816 VSS 0.5675f
C16063 VDD.n800 VSS 0.03743f
C16064 VDD.t753 VSS 0.10699f
C16065 VDD.n801 VSS 0.05323f
C16066 VDD.n802 VSS 0.019f
C16067 VDD.t845 VSS 0.49282f
C16068 VDD.n803 VSS 0.04752f
C16069 VDD.n804 VSS 0.019f
C16070 VDD.t1342 VSS 0.37952f
C16071 VDD.n805 VSS 0.05178f
C16072 VDD.t1482 VSS 0.12807f
C16073 VDD.n806 VSS 0.03429f
C16074 VDD.t1229 VSS 0.02911f
C16075 VDD.t1905 VSS 0.86409f
C16076 VDD.t644 VSS 0.10852f
C16077 VDD.t2081 VSS 0.02577f
C16078 VDD.n808 VSS 0.05288f
C16079 VDD.n809 VSS 0.01979f
C16080 VDD.t1055 VSS 0.50984f
C16081 VDD.n810 VSS 0.04835f
C16082 VDD.n811 VSS 0.01085f
C16083 VDD.t1079 VSS 0.02579f
C16084 VDD.n812 VSS 0.05106f
C16085 VDD.t931 VSS 0.02123f
C16086 VDD.n813 VSS 0.01125f
C16087 VDD.t1054 VSS 0.01903f
C16088 VDD.n814 VSS 0.034f
C16089 VDD.n815 VSS 0.01252f
C16090 VDD.t1084 VSS 0.02579f
C16091 VDD.n816 VSS 0.06044f
C16092 VDD.t1081 VSS 0.02579f
C16093 VDD.t20 VSS 0.02484f
C16094 VDD.t504 VSS 0.44241f
C16095 VDD.t1067 VSS 0.14857f
C16096 VDD.t924 VSS 0.02577f
C16097 VDD.t505 VSS 0.02314f
C16098 VDD.t723 VSS 0.15477f
C16099 VDD.t1083 VSS 0.777f
C16100 VDD.t21 VSS 0.02313f
C16101 VDD.t802 VSS 0.02708f
C16102 VDD.t1082 VSS 0.02579f
C16103 VDD.t2356 VSS 0.02596f
C16104 VDD.t700 VSS 0.19836f
C16105 VDD.t692 VSS 0.02596f
C16106 VDD.t1306 VSS 0.66999f
C16107 VDD.t1752 VSS 0.10705f
C16108 VDD.t1798 VSS 0.14528f
C16109 VDD.t1247 VSS 0.82226f
C16110 VDD.n817 VSS 0.01919f
C16111 VDD.n818 VSS 0.02545f
C16112 VDD.t1448 VSS 0.81924f
C16113 VDD.n819 VSS 0.03971f
C16114 VDD.t1703 VSS 0.02773f
C16115 VDD.t688 VSS 0.15125f
C16116 VDD.t973 VSS 0.02569f
C16117 VDD.n821 VSS 0.04384f
C16118 VDD.t1707 VSS 0.02813f
C16119 VDD.n822 VSS 0.01137f
C16120 VDD.t905 VSS 0.11518f
C16121 VDD.t1683 VSS 0.0252f
C16122 VDD.t970 VSS 0.02569f
C16123 VDD.t685 VSS 0.34055f
C16124 VDD.t1723 VSS 0.02813f
C16125 VDD.t1681 VSS 0.0252f
C16126 VDD.t1244 VSS 0.33006f
C16127 VDD.t975 VSS 0.02569f
C16128 VDD.t884 VSS 0.02813f
C16129 VDD.t1685 VSS 0.06451f
C16130 VDD.t703 VSS 0.02791f
C16131 VDD.t1721 VSS 0.02813f
C16132 VDD.t1679 VSS 0.0252f
C16133 VDD.t1803 VSS 0.23367f
C16134 VDD.t1680 VSS 0.0252f
C16135 VDD.t1636 VSS 0.02813f
C16136 VDD.t974 VSS 0.02569f
C16137 VDD.t967 VSS 0.02569f
C16138 VDD.t976 VSS 0.02569f
C16139 VDD.t1726 VSS 0.20293f
C16140 VDD.t1581 VSS 0.69497f
C16141 VDD.t1712 VSS 0.3216f
C16142 VDD.t1684 VSS 0.0252f
C16143 VDD.t1694 VSS 0.02791f
C16144 VDD.t899 VSS 0.1063f
C16145 VDD.t1025 VSS 0.06892f
C16146 VDD.t1066 VSS 0.1917f
C16147 VDD.t2290 VSS 0.16648f
C16148 VDD.t869 VSS 0.08825f
C16149 VDD.t1135 VSS 0.33809f
C16150 VDD.t735 VSS 0.13491f
C16151 VDD.n823 VSS 0.17761f
C16152 VDD.n824 VSS 0.50432f
C16153 VDD.n825 VSS 0.50432f
C16154 VDD.t281 VSS 0.02313f
C16155 VDD.t408 VSS 0.0894f
C16156 VDD.t291 VSS 0.02484f
C16157 VDD.t285 VSS 0.09111f
C16158 VDD.t298 VSS 0.02313f
C16159 VDD.t419 VSS 0.0894f
C16160 VDD.t294 VSS 0.02314f
C16161 VDD.t328 VSS 0.02314f
C16162 VDD.t295 VSS 0.02484f
C16163 VDD.t329 VSS 0.02484f
C16164 VDD.t145 VSS 0.16622f
C16165 VDD.t635 VSS 0.09111f
C16166 VDD.t545 VSS 0.06545f
C16167 VDD.t636 VSS 0.02313f
C16168 VDD.t576 VSS 0.02314f
C16169 VDD.t530 VSS 0.02484f
C16170 VDD.t1586 VSS 0.09151f
C16171 VDD.t1492 VSS 0.04737f
C16172 VDD.t1514 VSS 0.02053f
C16173 VDD.t531 VSS 0.02313f
C16174 VDD.t252 VSS 0.19149f
C16175 VDD.t253 VSS 0.15665f
C16176 VDD.t254 VSS 0.02314f
C16177 VDD.t255 VSS 0.02484f
C16178 VDD.t507 VSS 0.02313f
C16179 VDD.n826 VSS 0.04568f
C16180 VDD.t1090 VSS 0.71795f
C16181 VDD.n827 VSS 0.06184f
C16182 VDD.n828 VSS 0.01262f
C16183 VDD.t1705 VSS 0.40606f
C16184 VDD.t2014 VSS 0.0332f
C16185 VDD.t1172 VSS 0.23651f
C16186 VDD.t1056 VSS 0.01903f
C16187 VDD.t933 VSS 0.62714f
C16188 VDD.t738 VSS 0.0332f
C16189 VDD.t923 VSS 0.02708f
C16190 VDD.t1052 VSS 0.2867f
C16191 VDD.n829 VSS 0.05455f
C16192 VDD.t932 VSS 0.02911f
C16193 VDD.t1913 VSS 0.18512f
C16194 VDD.t1557 VSS 0.04737f
C16195 VDD.t1596 VSS 0.11015f
C16196 VDD.t1058 VSS 0.02581f
C16197 VDD.n830 VSS 0.04369f
C16198 VDD.t1558 VSS 0.02053f
C16199 VDD.n831 VSS 0.03937f
C16200 VDD.n832 VSS 0.01244f
C16201 VDD.t804 VSS 0.26738f
C16202 VDD.n833 VSS 0.06125f
C16203 VDD.n834 VSS 0.02671f
C16204 VDD.t1080 VSS 0.02581f
C16205 VDD.n835 VSS 0.07604f
C16206 VDD.t1373 VSS 0.10401f
C16207 VDD.t667 VSS 0.02887f
C16208 VDD.t84 VSS 0.02484f
C16209 VDD.t85 VSS 0.02313f
C16210 VDD.t1691 VSS 0.86254f
C16211 VDD.t86 VSS 0.0894f
C16212 VDD.n836 VSS 0.50432f
C16213 VDD.t654 VSS 0.02726f
C16214 VDD.t649 VSS 0.1514f
C16215 VDD.n837 VSS 0.07128f
C16216 VDD.t947 VSS 0.25476f
C16217 VDD.t1273 VSS 0.02887f
C16218 VDD.n838 VSS 0.01946f
C16219 VDD.t358 VSS 0.15463f
C16220 VDD.n839 VSS 0.08267f
C16221 VDD.t743 VSS 0.25185f
C16222 VDD.n840 VSS 0.04632f
C16223 VDD.t1709 VSS 0.02596f
C16224 VDD.t1343 VSS 0.02596f
C16225 VDD.t741 VSS 0.05175f
C16226 VDD.t1804 VSS 0.01903f
C16227 VDD.t1332 VSS 0.07507f
C16228 VDD.t1410 VSS 0.15227f
C16229 VDD.t1710 VSS 0.02813f
C16230 VDD.t1000 VSS 0.02569f
C16231 VDD.t934 VSS 0.02911f
C16232 VDD.t166 VSS 0.17786f
C16233 VDD.t814 VSS 0.21703f
C16234 VDD.t208 VSS 0.02313f
C16235 VDD.t577 VSS 0.02314f
C16236 VDD.t536 VSS 2.95838f
C16237 VDD.t638 VSS 0.02313f
C16238 VDD.t535 VSS 0.16503f
C16239 VDD.t330 VSS 0.02314f
C16240 VDD.t502 VSS 0.15801f
C16241 VDD.t421 VSS 0.02313f
C16242 VDD.t218 VSS 0.02313f
C16243 VDD.t412 VSS 0.02314f
C16244 VDD.t177 VSS 0.02314f
C16245 VDD.t406 VSS 0.02313f
C16246 VDD.t182 VSS 0.02313f
C16247 VDD.t491 VSS 0.02314f
C16248 VDD.t75 VSS 0.08941f
C16249 VDD.t492 VSS 0.02484f
C16250 VDD.t76 VSS 0.09111f
C16251 VDD.t496 VSS 0.02313f
C16252 VDD.t640 VSS 0.02313f
C16253 VDD.t266 VSS 0.02314f
C16254 VDD.t50 VSS 0.08941f
C16255 VDD.t267 VSS 0.02484f
C16256 VDD.t51 VSS 0.09111f
C16257 VDD.t409 VSS 0.02484f
C16258 VDD.t178 VSS 0.02484f
C16259 VDD.t410 VSS 0.02313f
C16260 VDD.t194 VSS 0.02313f
C16261 VDD.t286 VSS 0.02314f
C16262 VDD.t191 VSS 0.05627f
C16263 VDD.t287 VSS 0.02484f
C16264 VDD.t192 VSS 0.05797f
C16265 VDD.t331 VSS 0.02484f
C16266 VDD.t209 VSS 0.15971f
C16267 VDD.t2318 VSS 0.02313f
C16268 VDD.t210 VSS 0.02313f
C16269 VDD.t1386 VSS 0.02314f
C16270 VDD.t211 VSS 0.02314f
C16271 VDD.t637 VSS 0.02484f
C16272 VDD.t212 VSS 0.16674f
C16273 VDD.t532 VSS 0.02484f
C16274 VDD.t537 VSS 2.96008f
C16275 VDD.t533 VSS 0.02313f
C16276 VDD.t539 VSS 0.02313f
C16277 VDD.t526 VSS 0.02313f
C16278 VDD.t541 VSS 0.05626f
C16279 VDD.t527 VSS 0.02223f
C16280 VDD.t540 VSS 0.05536f
C16281 VDD.t2152 VSS 0.02616f
C16282 VDD.t1091 VSS 0.22811f
C16283 VDD.t391 VSS 0.04737f
C16284 VDD.t2153 VSS 0.02818f
C16285 VDD.t2155 VSS 0.02818f
C16286 VDD.n841 VSS 0.045f
C16287 VDD.t1560 VSS 0.12091f
C16288 VDD.t2157 VSS 0.02818f
C16289 VDD.t1406 VSS 0.02818f
C16290 VDD.n842 VSS 0.03407f
C16291 VDD.n843 VSS 0.01117f
C16292 VDD.t1407 VSS 0.02818f
C16293 VDD.n844 VSS 0.04378f
C16294 VDD.n845 VSS 0.01791f
C16295 VDD.t1949 VSS 0.20245f
C16296 VDD.n846 VSS 0.07056f
C16297 VDD.t1954 VSS 0.31352f
C16298 VDD.t990 VSS 0.08706f
C16299 VDD.t783 VSS 0.01903f
C16300 VDD.t716 VSS 0.12626f
C16301 VDD.t575 VSS 0.17309f
C16302 VDD.t1904 VSS 0.11558f
C16303 VDD.t207 VSS 0.17479f
C16304 VDD.t167 VSS 0.20394f
C16305 VDD.t386 VSS 0.10817f
C16306 VDD.t169 VSS 0.04751f
C16307 VDD.t1828 VSS 0.02773f
C16308 VDD.t1022 VSS 0.11988f
C16309 VDD.t1354 VSS 0.02564f
C16310 VDD.t79 VSS 0.02314f
C16311 VDD.t80 VSS 0.02484f
C16312 VDD.t999 VSS 0.02524f
C16313 VDD.t437 VSS 0.02313f
C16314 VDD.t663 VSS 0.02773f
C16315 VDD.t697 VSS 0.02596f
C16316 VDD.t952 VSS 0.02596f
C16317 VDD.t722 VSS 0.02577f
C16318 VDD.t1838 VSS 0.34951f
C16319 VDD.t827 VSS 0.07732f
C16320 VDD.t1329 VSS 0.02726f
C16321 VDD.t756 VSS 0.07929f
C16322 VDD.t1048 VSS 0.1537f
C16323 VDD.t817 VSS 0.02596f
C16324 VDD.t1086 VSS 0.02964f
C16325 VDD.t759 VSS 0.02813f
C16326 VDD.t695 VSS 0.77912f
C16327 VDD.t740 VSS 0.11847f
C16328 VDD.t997 VSS 0.02569f
C16329 VDD.t1068 VSS 0.02577f
C16330 VDD.t1389 VSS 0.67075f
C16331 VDD.t744 VSS 0.14925f
C16332 VDD.t2018 VSS 0.24959f
C16333 VDD.t742 VSS 0.1126f
C16334 VDD.t790 VSS 0.07465f
C16335 VDD.t968 VSS 0.15132f
C16336 VDD.t1277 VSS 0.02518f
C16337 VDD.t2107 VSS 0.02596f
C16338 VDD.t1701 VSS 0.36501f
C16339 VDD.t1361 VSS 0.02596f
C16340 VDD.t706 VSS 0.30122f
C16341 VDD.t2285 VSS 0.09231f
C16342 VDD.t1039 VSS 0.04737f
C16343 VDD.t1040 VSS 0.02053f
C16344 VDD.t920 VSS 0.23984f
C16345 VDD.t701 VSS 0.02577f
C16346 VDD.t1036 VSS 0.19932f
C16347 VDD.t1041 VSS 0.64764f
C16348 VDD.n847 VSS 0.0796f
C16349 VDD.t392 VSS 0.34406f
C16350 VDD.n848 VSS 0.04288f
C16351 VDD.t709 VSS 0.04599f
C16352 VDD.t368 VSS 0.04737f
C16353 VDD.n849 VSS 0.01919f
C16354 VDD.n850 VSS 0.04771f
C16355 VDD.n851 VSS 0.01301f
C16356 VDD.t363 VSS 0.02053f
C16357 VDD.t1004 VSS 0.26494f
C16358 VDD.t871 VSS 0.52568f
C16359 VDD.t1948 VSS 0.28865f
C16360 VDD.n852 VSS 0.50432f
C16361 VDD.n853 VSS 0.50432f
C16362 VDD.t2277 VSS 0.54292f
C16363 VDD.t1202 VSS 0.27083f
C16364 VDD.n854 VSS 0.013f
C16365 VDD.t847 VSS 0.19829f
C16366 VDD.t1569 VSS 0.0883f
C16367 VDD.n855 VSS 0.01919f
C16368 VDD.n856 VSS 0.02547f
C16369 VDD.t2348 VSS 0.15746f
C16370 VDD.n858 VSS 0.01125f
C16371 VDD.t863 VSS 0.4153f
C16372 VDD.n859 VSS 0.04405f
C16373 VDD.n860 VSS 0.016f
C16374 VDD.t718 VSS 0.12237f
C16375 VDD.n861 VSS 0.05584f
C16376 VDD.n862 VSS 0.02189f
C16377 VDD.t846 VSS 0.04737f
C16378 VDD.t1985 VSS 0.02887f
C16379 VDD.t596 VSS 0.59916f
C16380 VDD.t542 VSS 0.19716f
C16381 VDD.t162 VSS 0.02314f
C16382 VDD.t1217 VSS 0.11835f
C16383 VDD.t159 VSS 0.05627f
C16384 VDD.t179 VSS 0.02314f
C16385 VDD.t243 VSS 0.02313f
C16386 VDD.t244 VSS 0.05797f
C16387 VDD.t184 VSS 0.02313f
C16388 VDD.t54 VSS 0.02484f
C16389 VDD.t77 VSS 0.02411f
C16390 VDD.t1944 VSS 0.16077f
C16391 VDD.t78 VSS 0.02484f
C16392 VDD.t642 VSS 0.02313f
C16393 VDD.t656 VSS 0.02007f
C16394 VDD.t53 VSS 0.02314f
C16395 VDD.t249 VSS 0.05627f
C16396 VDD.t245 VSS 0.02314f
C16397 VDD.t180 VSS 0.09111f
C16398 VDD.t237 VSS 0.02484f
C16399 VDD.t236 VSS 0.02313f
C16400 VDD.t238 VSS 0.05627f
C16401 VDD.t1186 VSS 0.76531f
C16402 VDD.t158 VSS 0.09111f
C16403 VDD.t213 VSS 0.0564f
C16404 VDD.t163 VSS 0.02484f
C16405 VDD.t214 VSS 0.05797f
C16406 VDD.t445 VSS 0.02326f
C16407 VDD.t216 VSS 0.02313f
C16408 VDD.t2103 VSS 0.04942f
C16409 VDD.t1555 VSS 0.04737f
C16410 VDD.n863 VSS 0.01919f
C16411 VDD.n864 VSS 0.01572f
C16412 VDD.n865 VSS 0.03853f
C16413 VDD.t2024 VSS 3.05546f
C16414 VDD.n867 VSS 0.03346f
C16415 VDD.n868 VSS 0.01395f
C16416 VDD.t724 VSS 0.52393f
C16417 VDD.n869 VSS 0.02533f
C16418 VDD.t1437 VSS 0.07408f
C16419 VDD.n870 VSS 0.04202f
C16420 VDD.t543 VSS 0.21426f
C16421 VDD.t592 VSS 0.03854f
C16422 VDD.t593 VSS 0.02314f
C16423 VDD.t594 VSS 0.60087f
C16424 VDD.t1414 VSS 0.3547f
C16425 VDD.t1187 VSS 0.54391f
C16426 VDD.t784 VSS 0.31979f
C16427 VDD.t1291 VSS 0.23421f
C16428 VDD.t1968 VSS 0.10973f
C16429 VDD.n872 VSS 0.02966f
C16430 VDD.t1977 VSS 0.02596f
C16431 VDD.t1158 VSS 0.02887f
C16432 VDD.t1160 VSS 0.11286f
C16433 VDD.n873 VSS 0.05272f
C16434 VDD.t1015 VSS 0.29041f
C16435 VDD.t1568 VSS 0.02053f
C16436 VDD.t1425 VSS 0.02589f
C16437 VDD.t2091 VSS 0.14928f
C16438 VDD.n874 VSS 0.05703f
C16439 VDD.n875 VSS 0.01602f
C16440 VDD.t1318 VSS 0.02577f
C16441 VDD.n876 VSS 0.05783f
C16442 VDD.n877 VSS 0.02026f
C16443 VDD.t1269 VSS 1.2616f
C16444 VDD.n878 VSS 0.04336f
C16445 VDD.n879 VSS 0.01132f
C16446 VDD.t1819 VSS 0.01903f
C16447 VDD.t1014 VSS 0.15524f
C16448 VDD.t1130 VSS 0.02817f
C16449 VDD.t1468 VSS 0.33032f
C16450 VDD.t1049 VSS 0.45844f
C16451 VDD.t1470 VSS 0.02818f
C16452 VDD.t1472 VSS 0.02616f
C16453 VDD.t1093 VSS 0.18088f
C16454 VDD.t979 VSS 0.45883f
C16455 VDD.t1175 VSS 1.08144f
C16456 VDD.t989 VSS 0.18506f
C16457 VDD.t1264 VSS 0.02887f
C16458 VDD.n880 VSS 0.05347f
C16459 VDD.t674 VSS 0.24559f
C16460 VDD.n881 VSS 0.05932f
C16461 VDD.t689 VSS 0.02791f
C16462 VDD.n883 VSS 0.06033f
C16463 VDD.t1942 VSS 0.21191f
C16464 VDD.n884 VSS 0.06044f
C16465 VDD.n885 VSS 0.02259f
C16466 VDD.t2206 VSS 0.26657f
C16467 VDD.t2338 VSS 0.15464f
C16468 VDD.t2089 VSS 0.44614f
C16469 VDD.t1220 VSS 0.68976f
C16470 VDD.t1272 VSS 0.12589f
C16471 VDD.t653 VSS 0.02007f
C16472 VDD.t1006 VSS 0.15398f
C16473 VDD.t731 VSS 0.78113f
C16474 VDD.n886 VSS 0.0812f
C16475 VDD.t994 VSS 0.02007f
C16476 VDD.t1964 VSS 0.33014f
C16477 VDD.t1937 VSS 0.02983f
C16478 VDD.t1458 VSS 0.34607f
C16479 VDD.t1749 VSS 0.02818f
C16480 VDD.t830 VSS 0.02818f
C16481 VDD.t1037 VSS 0.08714f
C16482 VDD.t831 VSS 0.02818f
C16483 VDD.t833 VSS 0.02818f
C16484 VDD.t1034 VSS 0.57217f
C16485 VDD.t835 VSS 0.17098f
C16486 VDD.t837 VSS 0.02616f
C16487 VDD.t996 VSS 0.13433f
C16488 VDD.n887 VSS 0.50432f
C16489 VDD.t569 VSS 0.02313f
C16490 VDD.t433 VSS 0.46556f
C16491 VDD.t432 VSS 0.46386f
C16492 VDD.t1184 VSS 0.07712f
C16493 VDD.t1182 VSS 0.02838f
C16494 VDD.t1214 VSS 0.02565f
C16495 VDD.t1267 VSS 0.29457f
C16496 VDD.t1370 VSS 0.24618f
C16497 VDD.t1369 VSS 0.27651f
C16498 VDD.t205 VSS 0.02313f
C16499 VDD.t206 VSS 0.04611f
C16500 VDD.t161 VSS 0.12424f
C16501 VDD.t1831 VSS 0.02313f
C16502 VDD.t1833 VSS 0.02313f
C16503 VDD.t565 VSS 0.02314f
C16504 VDD.t239 VSS 0.02484f
C16505 VDD.t242 VSS 0.02484f
C16506 VDD.t32 VSS 0.02314f
C16507 VDD.t632 VSS 0.02313f
C16508 VDD.t173 VSS 0.02345f
C16509 VDD.t1295 VSS 0.46354f
C16510 VDD.n888 VSS 0.02767f
C16511 VDD.n889 VSS 0.04062f
C16512 VDD.t241 VSS 0.02314f
C16513 VDD.t174 VSS 0.02484f
C16514 VDD.t23 VSS 0.02484f
C16515 VDD.t251 VSS 0.02313f
C16516 VDD.t256 VSS 0.05627f
C16517 VDD.t22 VSS 0.02313f
C16518 VDD.t9 VSS 0.02314f
C16519 VDD.t246 VSS 0.15737f
C16520 VDD.t247 VSS 0.12253f
C16521 VDD.t248 VSS 0.02314f
C16522 VDD.t10 VSS 0.02484f
C16523 VDD.t566 VSS 0.02484f
C16524 VDD.t240 VSS 0.02313f
C16525 VDD.t200 VSS 0.05627f
C16526 VDD.t1908 VSS 0.02313f
C16527 VDD.t1988 VSS 0.02314f
C16528 VDD.t164 VSS 0.05797f
C16529 VDD.t165 VSS 0.02313f
C16530 VDD.t160 VSS 0.05627f
C16531 VDD.t1834 VSS 0.02484f
C16532 VDD.t446 VSS 0.08955f
C16533 VDD.t1830 VSS 0.02223f
C16534 VDD.t447 VSS 0.04441f
C16535 VDD.t2283 VSS 0.3005f
C16536 VDD.t993 VSS 0.14029f
C16537 VDD.t659 VSS 0.06699f
C16538 VDD.t2191 VSS 0.02581f
C16539 VDD.t766 VSS 0.10963f
C16540 VDD.n890 VSS 0.07334f
C16541 VDD.t1124 VSS 0.26668f
C16542 VDD.n891 VSS 0.05937f
C16543 VDD.n892 VSS 0.02189f
C16544 VDD.t1183 VSS 0.0252f
C16545 VDD.t2233 VSS 0.02569f
C16546 VDD.t1125 VSS 0.02887f
C16547 VDD.t1936 VSS 0.29229f
C16548 VDD.t2044 VSS 0.12782f
C16549 VDD.t1223 VSS 0.34376f
C16550 VDD.t2111 VSS 0.12409f
C16551 VDD.t2234 VSS 0.02569f
C16552 VDD.t1001 VSS 0.05014f
C16553 VDD.t1199 VSS 0.02596f
C16554 VDD.t2239 VSS 0.02596f
C16555 VDD.t1372 VSS 0.02577f
C16556 VDD.t203 VSS 0.6463f
C16557 VDD.t257 VSS 0.38806f
C16558 VDD.t258 VSS 0.38716f
C16559 VDD.t2240 VSS 0.02596f
C16560 VDD.t204 VSS 0.648f
C16561 VDD.t1451 VSS 0.02596f
C16562 VDD.t431 VSS 0.02313f
C16563 VDD.t1379 VSS 0.36579f
C16564 VDD.t435 VSS 0.02313f
C16565 VDD.t442 VSS 0.04781f
C16566 VDD.t1170 VSS 0.18884f
C16567 VDD.t1094 VSS 0.34122f
C16568 VDD.n893 VSS 0.08734f
C16569 VDD.t782 VSS 0.1554f
C16570 VDD.t2060 VSS 0.02887f
C16571 VDD.t374 VSS 0.62334f
C16572 VDD.n894 VSS 0.0552f
C16573 VDD.n895 VSS 0.02893f
C16574 VDD.t1043 VSS 0.57063f
C16575 VDD.t1374 VSS 0.10783f
C16576 VDD.n896 VSS 0.02187f
C16577 VDD.t2202 VSS 0.10917f
C16578 VDD.t2146 VSS 0.01903f
C16579 VDD.t780 VSS 0.42708f
C16580 VDD.t2147 VSS 0.02565f
C16581 VDD.t942 VSS 0.29668f
C16582 VDD.t1132 VSS 0.02596f
C16583 VDD.t1263 VSS 0.14646f
C16584 VDD.t1165 VSS 0.02565f
C16585 VDD.t1429 VSS 0.14937f
C16586 VDD.t2137 VSS 0.15963f
C16587 VDD.t1381 VSS 0.02596f
C16588 VDD.t443 VSS 0.04691f
C16589 VDD.n897 VSS 0.0627f
C16590 VDD.t1050 VSS 0.02577f
C16591 VDD.t2311 VSS 0.02579f
C16592 VDD.t1974 VSS 0.30323f
C16593 VDD.t1452 VSS 0.02596f
C16594 VDD.t1390 VSS 0.02596f
C16595 VDD.t906 VSS 0.25422f
C16596 VDD.t821 VSS 0.19799f
C16597 VDD.t941 VSS 0.02544f
C16598 VDD.t1346 VSS 0.02564f
C16599 VDD.t1818 VSS 0.20295f
C16600 VDD.n898 VSS 0.04411f
C16601 VDD.t1345 VSS 0.02726f
C16602 VDD.t1173 VSS 0.02577f
C16603 VDD.t660 VSS 0.54478f
C16604 VDD.t661 VSS 0.2649f
C16605 VDD.t815 VSS 0.55755f
C16606 VDD.t788 VSS 0.02577f
C16607 VDD.n899 VSS 0.06612f
C16608 VDD.t652 VSS 0.02007f
C16609 VDD.n900 VSS 0.05115f
C16610 VDD.n901 VSS 0.01382f
C16611 VDD.t1297 VSS 0.52423f
C16612 VDD.t1044 VSS 0.24675f
C16613 VDD.t796 VSS 0.11067f
C16614 VDD.t811 VSS 0.19201f
C16615 VDD.t678 VSS 0.56376f
C16616 VDD.n902 VSS 0.02469f
C16617 VDD.t1481 VSS 0.02577f
C16618 VDD.n903 VSS 0.05298f
C16619 VDD.t1123 VSS 0.19065f
C16620 VDD.t361 VSS 0.04737f
C16621 VDD.n904 VSS 0.01919f
C16622 VDD.n905 VSS 0.03448f
C16623 VDD.t1029 VSS 0.30531f
C16624 VDD.n907 VSS 0.07507f
C16625 VDD.n908 VSS 0.02928f
C16626 VDD.t1578 VSS 0.067f
C16627 VDD.n909 VSS 0.0565f
C16628 VDD.t366 VSS 2.195f
C16629 VDD.n910 VSS 0.01919f
C16630 VDD.n911 VSS 0.05239f
C16631 VDD.n912 VSS 0.01704f
C16632 VDD.t365 VSS 0.06373f
C16633 VDD.t937 VSS 0.3278f
C16634 VDD.t1927 VSS 0.13424f
C16635 VDD.n913 VSS 0.50432f
C16636 VDD.n914 VSS 0.50432f
C16637 VDD.n915 VSS 0.05409f
C16638 VDD.n916 VSS 0.02189f
C16639 VDD.n917 VSS 0.05584f
C16640 VDD.n918 VSS 0.01809f
C16641 VDD.n919 VSS 0.05087f
C16642 VDD.n920 VSS 0.01139f
C16643 VDD.n921 VSS 0.04662f
C16644 VDD.n922 VSS 0.013f
C16645 VDD.n923 VSS 0.02064f
C16646 VDD.n925 VSS 0.03892f
C16647 VDD.n926 VSS 0.01178f
C16648 VDD.n927 VSS 0.03324f
C16649 VDD.n928 VSS 0.01131f
C16650 VDD.n929 VSS 0.03713f
C16651 VDD.n930 VSS 0.01618f
C16652 VDD.n931 VSS 0.03881f
C16653 VDD.n933 VSS 0.50432f
C16654 VDD.t2237 VSS 0.3679f
C16655 VDD.t2135 VSS 0.02564f
C16656 VDD.t475 VSS 0.6055f
C16657 VDD.t378 VSS 0.52396f
C16658 VDD.t170 VSS 0.05627f
C16659 VDD.t91 VSS 0.05797f
C16660 VDD.n934 VSS 0.10463f
C16661 VDD.n935 VSS 0.07153f
C16662 VDD.t92 VSS 0.02314f
C16663 VDD.t371 VSS 0.137f
C16664 VDD.t1420 VSS 0.02577f
C16665 VDD.t90 VSS 0.1888f
C16666 VDD.t88 VSS 0.19051f
C16667 VDD.t89 VSS 0.02314f
C16668 VDD.t755 VSS 0.92099f
C16669 VDD.t115 VSS 0.02313f
C16670 VDD.t113 VSS 0.02484f
C16671 VDD.t2108 VSS 0.26589f
C16672 VDD.t114 VSS 0.02314f
C16673 VDD.t112 VSS 0.02313f
C16674 VDD.t1932 VSS 0.02055f
C16675 VDD.t110 VSS 0.09111f
C16676 VDD.t101 VSS 0.02313f
C16677 VDD.t111 VSS 0.08941f
C16678 VDD.t99 VSS 0.02314f
C16679 VDD.t100 VSS 0.02484f
C16680 VDD.t1460 VSS 0.02314f
C16681 VDD.t59 VSS 0.02314f
C16682 VDD.t441 VSS 0.16084f
C16683 VDD.t58 VSS 0.12253f
C16684 VDD.t524 VSS 0.02314f
C16685 VDD.t36 VSS 0.02314f
C16686 VDD.t517 VSS 0.02313f
C16687 VDD.t35 VSS 0.05627f
C16688 VDD.t945 VSS 0.02314f
C16689 VDD.t607 VSS 0.02314f
C16690 VDD.t1997 VSS 0.02313f
C16691 VDD.t606 VSS 0.02313f
C16692 VDD.t6 VSS 0.02314f
C16693 VDD.t599 VSS 0.05627f
C16694 VDD.t520 VSS 0.08941f
C16695 VDD.t554 VSS 0.02314f
C16696 VDD.t1402 VSS 0.0894f
C16697 VDD.t553 VSS 0.02313f
C16698 VDD.t1404 VSS 0.02314f
C16699 VDD.t550 VSS 0.02314f
C16700 VDD.t1401 VSS 0.09111f
C16701 VDD.t551 VSS 0.02484f
C16702 VDD.t521 VSS 0.09111f
C16703 VDD.t555 VSS 0.02484f
C16704 VDD.t590 VSS 0.02313f
C16705 VDD.t557 VSS 0.02313f
C16706 VDD.t586 VSS 0.02314f
C16707 VDD.t558 VSS 0.02314f
C16708 VDD.t583 VSS 0.09111f
C16709 VDD.t559 VSS 0.02484f
C16710 VDD.t584 VSS 0.0894f
C16711 VDD.t598 VSS 0.02313f
C16712 VDD.t7 VSS 0.09111f
C16713 VDD.t600 VSS 0.05797f
C16714 VDD.t1896 VSS 0.0894f
C16715 VDD.t602 VSS 0.02313f
C16716 VDD.t1396 VSS 0.08941f
C16717 VDD.t603 VSS 0.02314f
C16718 VDD.t1397 VSS 0.09111f
C16719 VDD.t604 VSS 0.02484f
C16720 VDD.t946 VSS 0.09111f
C16721 VDD.t608 VSS 0.05797f
C16722 VDD.t2030 VSS 0.0894f
C16723 VDD.t610 VSS 0.05627f
C16724 VDD.t840 VSS 0.05627f
C16725 VDD.t611 VSS 0.09304f
C16726 VDD.t516 VSS 0.05797f
C16727 VDD.t34 VSS 0.12788f
C16728 VDD.t150 VSS 0.02484f
C16729 VDD.t37 VSS 0.02484f
C16730 VDD.t151 VSS 0.02313f
C16731 VDD.t39 VSS 0.02313f
C16732 VDD.t152 VSS 0.02314f
C16733 VDD.t40 VSS 0.02314f
C16734 VDD.t153 VSS 0.16255f
C16735 VDD.t41 VSS 0.12424f
C16736 VDD.t548 VSS 0.02484f
C16737 VDD.t60 VSS 0.05764f
C16738 VDD.t549 VSS 0.02313f
C16739 VDD.t62 VSS 0.05593f
C16740 VDD.t63 VSS 0.0894f
C16741 VDD.t2334 VSS 0.02498f
C16742 VDD.t785 VSS 0.33678f
C16743 VDD.t787 VSS 1.00993f
C16744 VDD.t449 VSS 0.02314f
C16745 VDD.t2337 VSS 0.09212f
C16746 VDD.t1298 VSS 0.04737f
C16747 VDD.t448 VSS 0.05522f
C16748 VDD.t451 VSS 0.05351f
C16749 VDD.t453 VSS 0.06231f
C16750 VDD.t1575 VSS 0.06672f
C16751 VDD.t452 VSS 0.09681f
C16752 VDD.t454 VSS 0.05593f
C16753 VDD.t456 VSS 0.02313f
C16754 VDD.t455 VSS 0.02223f
C16755 VDD.n936 VSS 0.06271f
C16756 VDD.t1113 VSS 0.02791f
C16757 VDD.t1118 VSS 0.66371f
C16758 VDD.t1149 VSS 0.33242f
C16759 VDD.t2246 VSS 0.02569f
C16760 VDD.t124 VSS 0.12254f
C16761 VDD.t135 VSS 0.12253f
C16762 VDD.t1114 VSS 0.02581f
C16763 VDD.t136 VSS 0.02313f
C16764 VDD.t779 VSS 0.23478f
C16765 VDD.t137 VSS 0.02223f
C16766 VDD.n937 VSS 0.06271f
C16767 VDD.t125 VSS 0.22364f
C16768 VDD.n938 VSS 0.0764f
C16769 VDD.n939 VSS 0.04092f
C16770 VDD.t2055 VSS 0.02794f
C16771 VDD.t64 VSS 0.08849f
C16772 VDD.t752 VSS 0.47938f
C16773 VDD.t768 VSS 0.02887f
C16774 VDD.t1002 VSS 0.04778f
C16775 VDD.t1965 VSS 0.28666f
C16776 VDD.n940 VSS 0.06949f
C16777 VDD.n941 VSS 0.02187f
C16778 VDD.t936 VSS 0.20028f
C16779 VDD.n942 VSS 0.05752f
C16780 VDD.n943 VSS 0.02266f
C16781 VDD.t2211 VSS 0.23099f
C16782 VDD.n944 VSS 0.0505f
C16783 VDD.t362 VSS 0.52301f
C16784 VDD.n946 VSS 0.04867f
C16785 VDD.t1435 VSS 0.10008f
C16786 VDD.t375 VSS 0.19355f
C16787 VDD.n947 VSS 0.01919f
C16788 VDD.n948 VSS 0.04321f
C16789 VDD.n949 VSS 0.01155f
C16790 VDD.t719 VSS 0.09649f
C16791 VDD.n950 VSS 0.06525f
C16792 VDD.t921 VSS 0.08714f
C16793 VDD.t369 VSS 0.02053f
C16794 VDD.t992 VSS 0.02773f
C16795 VDD.t379 VSS 0.04737f
C16796 VDD.t1696 VSS 0.93472f
C16797 VDD.t1150 VSS 0.12759f
C16798 VDD.t1767 VSS 0.06751f
C16799 VDD.t1279 VSS 0.10725f
C16800 VDD.n951 VSS 0.01529f
C16801 VDD.t1242 VSS 0.02577f
C16802 VDD.n952 VSS 0.04849f
C16803 VDD.n953 VSS 0.01456f
C16804 VDD.t476 VSS 0.6046f
C16805 VDD.n954 VSS 0.06271f
C16806 VDD.n955 VSS 0.06187f
C16807 VDD.t1953 VSS 0.08737f
C16808 VDD.n956 VSS 0.04862f
C16809 VDD.n957 VSS 0.99867f
C16810 VDD.t512 VSS 0.05797f
C16811 VDD.t139 VSS 0.02313f
C16812 VDD.t202 VSS 0.05627f
C16813 VDD.t31 VSS 0.05797f
C16814 VDD.t462 VSS 0.25507f
C16815 VDD.t157 VSS 0.05627f
C16816 VDD.t149 VSS 0.05797f
C16817 VDD.t70 VSS 0.02313f
C16818 VDD.t415 VSS 0.05627f
C16819 VDD.t146 VSS 0.05797f
C16820 VDD.n958 VSS 0.38797f
.ends
